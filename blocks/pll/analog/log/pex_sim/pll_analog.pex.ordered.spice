* NGSPICE file created from pll_analog.ext - technology: gf180mcuD

.subckt pll_analog vco_out pfd_up pfd_dn pll_en cp_trim0 cp_trim1 vctrl bias_ref vdd vss
X0 a_19972_1724.t1 a_18176_360.t9 vdd.t46 vdd.t45 pfet_03v3 ad=0.52p pd=2.52u as=1.3p ps=5.3u w=2u l=0.28u
X1 a_17258_0.t1 a_15828_0.t4 a_17436_0.t2 vss.t69 nfet_03v3 ad=0.915p pd=4.22u as=0.39p ps=2.02u w=1.5u l=0.28u
X2 a_14400_19930# a_13800_12478# vss.t36 ppolyf_u r_width=1u r_length=36.6u
X3 a_1246_4604.t11 a_1246_4604.t10 a_440_8178.t6 vdd.t4 pfet_03v3 ad=3.25p pd=11.3u as=3.25p ps=11.3u w=5u l=1u
X4 a_7792_21882.t0 a_4610_27456.t12 vdd.t40 vdd.t39 pfet_03v3 ad=2.6p pd=9.3u as=2.6p ps=9.3u w=4u l=2u
X5 vss.t88 a_15772_n1100.t13 a_15650_0.t2 vss.t87 nfet_03v3 ad=1.22p pd=5.22u as=0.52p ps=2.52u w=2u l=0.5u
X6 a_562_21822.t10 cp_trim1.t1 a_8332_21882.t2 vss.t131 nfet_03v3 ad=1.22p pd=5.22u as=1.22p ps=5.22u w=2u l=0.28u
X7 a_2800_20110# vss.t63 cap_mim_2f0_m4m5_noshield c_width=100u c_length=100u
X8 a_18062_0.t3 a_15772_n1100.t8 vss.t21 vss.t20 nfet_03v3 ad=0.52p pd=2.52u as=1.22p ps=5.22u w=2u l=0.5u
X9 a_18058_1524.t3 a_15776_2628.t10 vdd.t80 vdd.t79 pfet_03v3 ad=1.3p pd=5.52u as=3.25p ps=11.3u w=5u l=0.5u
X10 a_10570_21882.t1 pfd_up.t2 vss.t123 vss.t122 nfet_03v3 ad=0.61p pd=3.22u as=0.61p ps=3.22u w=1u l=0.28u
X11 a_17258_0.t3 a_15772_n1100.t10 vss.t80 vss.t79 nfet_03v3 ad=0.52p pd=2.52u as=1.22p ps=5.22u w=2u l=0.5u
X12 vdd.t116 pll_en.t2 a_19972_1724.t5 vdd.t115 pfet_03v3 ad=1.3p pd=5.3u as=0.52p ps=2.52u w=2u l=0.28u
X13 a_440_4664.t1 a_6000_18610.t5 vss.t27 vss.t26 nfet_03v3 ad=1.22p pd=5.22u as=1.22p ps=5.22u w=2u l=2u
X14 a_1246_4604.t17 pfd_up.t0 a_1870_27516.t2 vdd.t99 pfet_03v3 ad=2.6p pd=9.3u as=2.6p ps=9.3u w=4u l=0.5u
X15 a_10800_19930# a_11400_12478# vss.t4 ppolyf_u r_width=1u r_length=36.6u
X16 a_1246_4604.t3 a_762_4664.t6 vdd.t1 vdd.t0 pfet_03v3 ad=2.6p pd=9.3u as=2.6p ps=9.3u w=4u l=2u
X17 a_440_4664.t2 a_6000_18610.t9 vss.t47 vss.t46 nfet_03v3 ad=1.22p pd=5.22u as=1.22p ps=5.22u w=2u l=2u
X18 a_562_21822.t3 a_11586_22142.t7 vss.t33 vss.t32 nfet_03v3 ad=0.61p pd=3.22u as=0.61p ps=3.22u w=1u l=0.28u
X19 a_18866_0.t1 a_15772_n1100.t6 vss.t68 vss.t67 nfet_03v3 ad=0.52p pd=2.52u as=1.22p ps=5.22u w=2u l=0.5u
X20 a_8114_4664.t0 a_6000_18610.t10 vss.t45 vss.t44 nfet_03v3 ad=1.22p pd=5.22u as=1.22p ps=5.22u w=2u l=2u
X21 a_762_4664.t1 a_762_4664.t0 vdd.t3 vdd.t2 pfet_03v3 ad=2.6p pd=9.3u as=2.6p ps=9.3u w=4u l=2u
X22 a_8114_4664.t1 vctrl.t5 a_4200_16110.t1 vss.t93 nfet_03v3 ad=3.05p pd=11.22u as=3.05p ps=11.22u w=5u l=1u
X23 a_1870_27516.t0 a_570_27456.t8 vdd.t31 vdd.t30 pfet_03v3 ad=16.25p pd=51.3u as=16.25p ps=51.3u w=25u l=2u
X24 a_15828_0.t1 a_15764_360.t5 a_15650_0.t1 vss.t7 nfet_03v3 ad=0.39p pd=2.02u as=0.915p ps=4.22u w=1.5u l=0.28u
X25 a_570_27456.t1 a_570_27456.t0 vdd.t96 vdd.t95 pfet_03v3 ad=16.25p pd=51.3u as=16.25p ps=51.3u w=25u l=2u
X26 a_440_8178.t1 a_4610_27456.t15 vdd.t62 vdd.t61 pfet_03v3 ad=2.6p pd=9.3u as=2.6p ps=9.3u w=4u l=2u
X27 a_6600_18610# a_7200_12478# vss.t99 ppolyf_u r_width=1u r_length=30u
X28 a_18062_0.t0 a_18176_360.t6 a_16568_360.t1 vss.t8 nfet_03v3 ad=0.915p pd=4.22u as=0.39p ps=2.02u w=1.5u l=0.28u
X29 vdd.t82 a_15776_2628.t11 a_17254_1524.t2 vdd.t81 pfet_03v3 ad=3.25p pd=11.3u as=1.3p ps=5.52u w=5u l=0.5u
X30 vdd.t6 a_15776_2628.t7 a_18862_1524.t0 vdd.t5 pfet_03v3 ad=3.25p pd=11.3u as=1.3p ps=5.52u w=5u l=0.5u
X31 a_440_8178.t2 a_4610_27456.t7 vdd.t64 vdd.t63 pfet_03v3 ad=2.6p pd=9.3u as=2.6p ps=9.3u w=4u l=2u
X32 a_15764_360.t3 a_16568_360.t7 a_16450_1524.t0 vdd.t53 pfet_03v3 ad=0.78p pd=3.52u as=1.95p ps=7.3u w=3u l=0.28u
X33 a_14782_4664.t3 a_6000_18610.t4 vss.t121 vss.t120 nfet_03v3 ad=3.05p pd=11.22u as=3.05p ps=11.22u w=5u l=1u
X34 a_11206_4664.t2 a_6000_18610.t7 vss.t74 vss.t73 nfet_03v3 ad=1.22p pd=5.22u as=1.22p ps=5.22u w=2u l=2u
X35 a_1870_27516.t3 a_570_27456.t7 vdd.t120 vdd.t119 pfet_03v3 ad=16.25p pd=51.3u as=16.25p ps=51.3u w=25u l=2u
X36 vctrl.t2 a_400_12478# vss.t109 ppolyf_u r_width=2u r_length=37.5u
X37 a_13200_19930# a_12600_12478# vss.t119 ppolyf_u r_width=1u r_length=36.6u
X38 a_762_4664.t3 a_762_4664.t2 vdd.t94 vdd.t93 pfet_03v3 ad=2.6p pd=9.3u as=2.6p ps=9.3u w=4u l=2u
X39 a_562_21822.t0 a_4610_27456.t14 vdd.t25 vdd.t24 pfet_03v3 ad=2.6p pd=9.3u as=2.6p ps=9.3u w=4u l=2u
X40 a_4200_16110.t0 a_4200_12478# vss.t31 ppolyf_u r_width=1u r_length=17.5u
X41 a_18176_360.t1 a_17436_0.t7 a_18862_1524.t2 vdd.t103 pfet_03v3 ad=0.78p pd=3.52u as=1.95p ps=7.3u w=3u l=0.28u
X42 a_562_21822.t4 a_4610_27456.t6 vdd.t86 vdd.t85 pfet_03v3 ad=2.6p pd=9.3u as=2.6p ps=9.3u w=4u l=2u
X43 a_17254_1524.t1 a_15828_0.t6 a_17436_0.t0 vdd.t47 pfet_03v3 ad=1.95p pd=7.3u as=0.78p ps=3.52u w=3u l=0.28u
X44 a_15646_1524.t3 a_15764_360.t6 a_15828_0.t2 vdd.t32 pfet_03v3 ad=1.95p pd=7.3u as=0.78p ps=3.52u w=3u l=0.28u
X45 a_18862_1524.t3 a_17436_0.t6 a_18176_360.t0 vdd.t102 pfet_03v3 ad=1.95p pd=7.3u as=0.78p ps=3.52u w=3u l=0.28u
X46 a_570_27456.t3 a_570_27456.t2 vdd.t42 vdd.t41 pfet_03v3 ad=16.25p pd=51.3u as=16.25p ps=51.3u w=25u l=2u
X47 a_4610_27456.t3 a_4610_27456.t2 vdd.t60 vdd.t59 pfet_03v3 ad=2.6p pd=9.3u as=2.6p ps=9.3u w=4u l=2u
X48 bias_ref.t0 a_10200_12478# vss.t16 ppolyf_u r_width=1u r_length=36.6u
X49 vdd.t12 a_19972_1724.t10 vco_out.t0 vdd.t11 pfet_03v3 ad=1.95p pd=7.3u as=0.78p ps=3.52u w=3u l=0.28u
X50 a_15772_n1100.t4 a_15772_n1100.t3 vss.t43 vss.t42 nfet_03v3 ad=2.44p pd=9.22u as=2.44p ps=9.22u w=4u l=0.5u
X51 a_8332_21882.t1 a_4610_27456.t13 vdd.t57 vdd.t56 pfet_03v3 ad=2.6p pd=9.3u as=2.6p ps=9.3u w=4u l=2u
X52 a_1200_20110# a_400_12478# vss.t128 ppolyf_u r_width=2u r_length=37.5u
X53 bias_ref.t1 a_8400_12478# vss.t28 ppolyf_u r_width=1u r_length=30u
X54 a_15764_360.t0 a_16568_360.t5 a_16454_0.t0 vss.t59 nfet_03v3 ad=0.39p pd=2.02u as=0.915p ps=4.22u w=1.5u l=0.28u
X55 a_770_8178.t6 vctrl.t11 a_440_8178.t8 vdd.t73 pfet_03v3 ad=3.25p pd=11.3u as=3.25p ps=11.3u w=5u l=1u
X56 a_770_8178.t7 vctrl.t8 a_440_8178.t11 vdd.t76 pfet_03v3 ad=3.25p pd=11.3u as=3.25p ps=11.3u w=5u l=1u
X57 a_18866_0.t2 a_17436_0.t4 a_18176_360.t3 vss.t129 nfet_03v3 ad=0.915p pd=4.22u as=0.39p ps=2.02u w=1.5u l=0.28u
X58 a_16450_1524.t3 a_15776_2628.t14 vdd.t72 vdd.t71 pfet_03v3 ad=1.3p pd=5.52u as=3.25p ps=11.3u w=5u l=0.5u
X59 a_8872_21882.t0 a_4610_27456.t10 vdd.t29 vdd.t28 pfet_03v3 ad=2.6p pd=9.3u as=2.6p ps=9.3u w=4u l=2u
X60 a_570_27456.t5 a_562_21822.t12 vss.t78 vss.t77 nfet_03v3 ad=6.1p pd=21.22u as=6.1p ps=21.22u w=10u l=2u
X61 a_440_8178.t7 a_4610_27456.t5 vdd.t68 vdd.t67 pfet_03v3 ad=2.6p pd=9.3u as=2.6p ps=9.3u w=4u l=2u
X62 a_15772_n1100.t0 a_11586_22142.t2 vss.t18 vss.t17 nfet_03v3 ad=0.61p pd=3.22u as=0.61p ps=3.22u w=1u l=0.28u
X63 a_440_8178.t0 a_4610_27456.t17 vdd.t23 vdd.t22 pfet_03v3 ad=2.6p pd=9.3u as=2.6p ps=9.3u w=4u l=2u
X64 a_18862_1524.t1 a_15776_2628.t8 vdd.t8 vdd.t7 pfet_03v3 ad=1.3p pd=5.52u as=3.25p ps=11.3u w=5u l=0.5u
X65 a_11206_4664.t1 a_4610_27456.t11 vdd.t66 vdd.t65 pfet_03v3 ad=2.6p pd=9.3u as=2.6p ps=9.3u w=4u l=2u
X66 a_14400_19930# a_15000_12478# vss.t37 ppolyf_u r_width=1u r_length=36.6u
X67 a_16454_0.t2 a_15772_n1100.t12 vss.t86 vss.t85 nfet_03v3 ad=0.52p pd=2.52u as=1.22p ps=5.22u w=2u l=0.5u
X68 vss.t106 a_19972_1724.t6 vco_out.t3 vss.t105 nfet_03v3 ad=1.83p pd=7.22u as=0.78p ps=3.52u w=3u l=0.28u
X69 a_6000_18610.t2 a_6000_12478# vss.t145 ppolyf_u r_width=1u r_length=30u
X70 vss.t54 a_15772_n1100.t5 a_18866_0.t0 vss.t53 nfet_03v3 ad=1.22p pd=5.22u as=0.52p ps=2.52u w=2u l=0.5u
X71 a_1246_4604.t13 a_1246_4604.t12 a_440_8178.t5 vdd.t58 pfet_03v3 ad=3.25p pd=11.3u as=3.25p ps=11.3u w=5u l=1u
X72 a_10570_21882.t0 pfd_up.t1 vdd.t98 vdd.t97 pfet_03v3 ad=1.3p pd=5.3u as=1.3p ps=5.3u w=2u l=0.28u
X73 a_8332_21882.t0 a_4610_27456.t9 vdd.t55 vdd.t54 pfet_03v3 ad=2.6p pd=9.3u as=2.6p ps=9.3u w=4u l=2u
X74 a_19972_1724.t3 a_18176_360.t5 a_19968_0.t1 vss.t104 nfet_03v3 ad=0.52p pd=2.52u as=1.22p ps=5.22u w=2u l=0.28u
X75 a_15772_n1100.t1 a_15776_2628.t17 vdd.t15 vdd.t14 pfet_03v3 ad=3.25p pd=11.3u as=3.25p ps=11.3u w=5u l=0.5u
X76 a_770_8178.t3 a_770_8178.t2 vss.t15 vss.t14 nfet_03v3 ad=1.22p pd=5.22u as=1.22p ps=5.22u w=2u l=2u
X77 a_15650_0.t3 a_15772_n1100.t14 vss.t125 vss.t124 nfet_03v3 ad=0.52p pd=2.52u as=1.22p ps=5.22u w=2u l=0.5u
X78 a_562_21822.t9 cp_trim1.t0 a_9050_21882.t0 vss.t132 nfet_03v3 ad=1.22p pd=5.22u as=1.22p ps=5.22u w=2u l=0.28u
X79 a_14782_4664.t1 a_6000_18610.t3 vss.t72 vss.t71 nfet_03v3 ad=3.05p pd=11.22u as=3.05p ps=11.22u w=5u l=1u
X80 a_15776_2628.t6 pll_en.t4 a_8114_4664.t4 vss.t138 nfet_03v3 ad=3.05p pd=11.22u as=3.05p ps=11.22u w=5u l=0.28u
X81 a_562_21822.t1 a_4610_27456.t16 vdd.t36 vdd.t35 pfet_03v3 ad=2.6p pd=9.3u as=2.6p ps=9.3u w=4u l=2u
X82 a_562_21822.t8 a_562_21822.t7 vss.t76 vss.t75 nfet_03v3 ad=6.1p pd=21.22u as=6.1p ps=21.22u w=10u l=2u
X83 a_12000_19930# a_11400_12478# vss.t30 ppolyf_u r_width=1u r_length=36.6u
X84 vdd.t19 a_15776_2628.t15 a_15646_1524.t0 vdd.t18 pfet_03v3 ad=3.25p pd=11.3u as=1.3p ps=5.52u w=5u l=0.5u
X85 a_14782_4664.t0 a_11586_22142.t5 vss.t66 vss.t65 nfet_03v3 ad=0.61p pd=3.22u as=0.61p ps=3.22u w=1u l=0.28u
X86 a_440_4664.t7 a_6000_18610.t6 vss.t98 vss.t97 nfet_03v3 ad=1.22p pd=5.22u as=1.22p ps=5.22u w=2u l=2u
X87 a_1200_20110# a_2000_12478# vss.t62 ppolyf_u r_width=2u r_length=37.5u
X88 a_4800_16110.t4 a_6000_18610.t14 vss.t118 vss.t117 nfet_03v3 ad=6.1p pd=21.22u as=6.1p ps=21.22u w=10u l=2u
X89 a_1246_4604.t5 a_1246_4604.t4 a_440_4664.t3 vss.t50 nfet_03v3 ad=3.05p pd=11.22u as=3.05p ps=11.22u w=5u l=1u
X90 a_15776_2628.t5 pll_en.t5 a_8114_4664.t3 vss.t137 nfet_03v3 ad=3.05p pd=11.22u as=3.05p ps=11.22u w=5u l=0.28u
X91 a_4800_16110.t2 a_6000_18610.t13 vss.t49 vss.t48 nfet_03v3 ad=6.1p pd=21.22u as=6.1p ps=21.22u w=10u l=2u
X92 a_17436_0.t3 a_15828_0.t5 a_17258_0.t2 vss.t70 nfet_03v3 ad=0.39p pd=2.02u as=0.915p ps=4.22u w=1.5u l=0.28u
X93 vdd.t101 a_19972_1724.t8 vco_out.t5 vdd.t100 pfet_03v3 ad=1.95p pd=7.3u as=0.78p ps=3.52u w=3u l=0.28u
X94 a_7330_21822.t1 pfd_dn.t1 vss.t115 vss.t114 nfet_03v3 ad=0.61p pd=3.22u as=0.61p ps=3.22u w=1u l=0.28u
X95 a_770_8178.t4 vctrl.t10 a_440_8178.t9 vdd.t74 pfet_03v3 ad=3.25p pd=11.3u as=3.25p ps=11.3u w=5u l=1u
X96 vctrl.t1 a_10570_21882.t2 a_1870_27516.t1 vdd.t26 pfet_03v3 ad=2.6p pd=9.3u as=2.6p ps=9.3u w=4u l=0.5u
X97 vco_out.t1 a_19972_1724.t9 vdd.t50 vdd.t49 pfet_03v3 ad=0.78p pd=3.52u as=1.95p ps=7.3u w=3u l=0.28u
X98 a_562_21822.t6 a_562_21822.t5 vss.t112 vss.t111 nfet_03v3 ad=6.1p pd=21.22u as=6.1p ps=21.22u w=10u l=2u
X99 a_17436_0.t1 a_15828_0.t7 a_17254_1524.t0 vdd.t48 pfet_03v3 ad=0.78p pd=3.52u as=1.95p ps=7.3u w=3u l=0.28u
X100 a_15828_0.t3 a_15764_360.t7 a_15646_1524.t2 vdd.t33 pfet_03v3 ad=0.78p pd=3.52u as=1.95p ps=7.3u w=3u l=0.28u
X101 a_562_21822.t2 a_4610_27456.t8 vdd.t38 vdd.t37 pfet_03v3 ad=2.6p pd=9.3u as=2.6p ps=9.3u w=4u l=2u
X102 a_562_21822.t11 cp_trim0.t1 a_7792_21882.t1 vss.t133 nfet_03v3 ad=1.22p pd=5.22u as=1.22p ps=5.22u w=2u l=0.28u
X103 a_1246_4604.t1 a_770_8178.t8 vss.t13 vss.t12 nfet_03v3 ad=1.22p pd=5.22u as=1.22p ps=5.22u w=2u l=2u
X104 vco_out.t2 a_19972_1724.t11 vdd.t52 vdd.t51 pfet_03v3 ad=0.78p pd=3.52u as=1.95p ps=7.3u w=3u l=0.28u
X105 a_1246_4604.t9 a_1246_4604.t8 a_440_8178.t3 vdd.t104 pfet_03v3 ad=3.25p pd=11.3u as=3.25p ps=11.3u w=5u l=1u
X106 a_4800_16110.t0 a_6000_18610.t12 vss.t3 vss.t2 nfet_03v3 ad=6.1p pd=21.22u as=6.1p ps=21.22u w=10u l=2u
X107 a_1246_4604.t7 a_1246_4604.t6 a_440_4664.t0 vss.t5 nfet_03v3 ad=3.05p pd=11.22u as=3.05p ps=11.22u w=5u l=1u
X108 a_9050_21882.t1 cp_trim0.t0 a_8872_21882.t1 vss.t134 nfet_03v3 ad=1.22p pd=5.22u as=1.22p ps=5.22u w=2u l=0.28u
X109 a_8114_4664.t2 vctrl.t4 a_4200_16110.t2 vss.t94 nfet_03v3 ad=3.05p pd=11.22u as=3.05p ps=11.22u w=5u l=1u
X110 a_7800_18610# a_7200_12478# vss.t29 ppolyf_u r_width=1u r_length=30u
X111 a_762_4664.t4 vctrl.t7 a_440_4664.t5 vss.t91 nfet_03v3 ad=3.05p pd=11.22u as=3.05p ps=11.22u w=5u l=1u
X112 a_15650_0.t0 a_15764_360.t4 a_15828_0.t0 vss.t6 nfet_03v3 ad=0.915p pd=4.22u as=0.39p ps=2.02u w=1.5u l=0.28u
X113 a_18058_1524.t1 a_18176_360.t10 a_16568_360.t2 vdd.t27 pfet_03v3 ad=1.95p pd=7.3u as=0.78p ps=3.52u w=3u l=0.28u
X114 vss.t11 a_15772_n1100.t7 a_18062_0.t2 vss.t10 nfet_03v3 ad=1.22p pd=5.22u as=0.52p ps=2.52u w=2u l=0.5u
X115 a_16568_360.t0 a_18176_360.t7 a_18062_0.t1 vss.t9 nfet_03v3 ad=0.39p pd=2.02u as=0.915p ps=4.22u w=1.5u l=0.28u
X116 a_440_4664.t4 a_6000_18610.t8 vss.t84 vss.t83 nfet_03v3 ad=1.22p pd=5.22u as=1.22p ps=5.22u w=2u l=2u
X117 a_11586_22142.t0 pll_en.t7 vdd.t110 vdd.t109 pfet_03v3 ad=1.3p pd=5.3u as=1.3p ps=5.3u w=2u l=0.28u
X118 a_13200_19930# a_13800_12478# vss.t144 ppolyf_u r_width=1u r_length=36.6u
X119 a_4800_16110.t1 a_4200_12478# vss.t19 ppolyf_u r_width=1u r_length=17.5u
X120 a_15646_1524.t1 a_15776_2628.t16 vdd.t21 vdd.t20 pfet_03v3 ad=1.3p pd=5.52u as=3.25p ps=11.3u w=5u l=0.5u
X121 a_17254_1524.t3 a_15776_2628.t12 vdd.t84 vdd.t83 pfet_03v3 ad=1.3p pd=5.52u as=3.25p ps=11.3u w=5u l=0.5u
X122 vctrl.t3 vss.t95 cap_mim_2f0_m4m5_noshield c_width=32u c_length=32u
X123 vss.t23 a_15772_n1100.t9 a_17258_0.t0 vss.t22 nfet_03v3 ad=1.22p pd=5.22u as=0.52p ps=2.52u w=2u l=0.5u
X124 a_19968_0.t2 pll_en.t1 vss.t142 vss.t141 nfet_03v3 ad=0.52p pd=2.52u as=1.22p ps=5.22u w=2u l=0.28u
X125 a_6000_18610.t1 a_11586_22142.t3 vss.t41 vss.t40 nfet_03v3 ad=0.61p pd=3.22u as=0.61p ps=3.22u w=1u l=0.28u
X126 vdd.t44 a_18176_360.t8 a_19972_1724.t0 vdd.t43 pfet_03v3 ad=1.3p pd=5.3u as=0.52p ps=2.52u w=2u l=0.28u
X127 a_4610_27456.t1 a_14782_4664.t4 vss.t58 vss.t57 nfet_03v3 ad=0.305p pd=2.22u as=0.305p ps=2.22u w=0.5u l=2u
X128 a_4610_27456.t0 a_11206_4664.t3 a_6000_18610.t0 vss.t25 nfet_03v3 ad=2.44p pd=9.22u as=2.44p ps=9.22u w=4u l=1u
X129 a_2800_20110# a_2000_12478# vss.t110 ppolyf_u r_width=2u r_length=37.5u
X130 vss.t82 a_15772_n1100.t11 a_16454_0.t1 vss.t81 nfet_03v3 ad=1.22p pd=5.22u as=0.52p ps=2.52u w=2u l=0.5u
X131 a_4610_27456.t4 pll_en.t8 vdd.t108 vdd.t107 pfet_03v3 ad=0.65p pd=3.3u as=0.65p ps=3.3u w=1u l=0.28u
X132 a_10800_19930# a_10200_12478# vss.t143 ppolyf_u r_width=1u r_length=36.6u
X133 a_770_8178.t5 vctrl.t9 a_440_8178.t10 vdd.t75 pfet_03v3 ad=3.25p pd=11.3u as=3.25p ps=11.3u w=5u l=1u
X134 a_14782_4664.t2 a_11586_22142.t6 vdd.t88 vdd.t87 pfet_03v3 ad=0.325p pd=2.3u as=0.325p ps=2.3u w=0.5u l=10u
X135 a_11206_4664.t0 a_11586_22142.t4 vss.t90 vss.t89 nfet_03v3 ad=0.61p pd=3.22u as=0.61p ps=3.22u w=1u l=0.28u
X136 vctrl.t0 pfd_dn.t2 a_2730_21882.t2 vss.t113 nfet_03v3 ad=1.22p pd=5.22u as=1.22p ps=5.22u w=2u l=0.5u
X137 a_16454_0.t3 a_16568_360.t4 a_15764_360.t1 vss.t100 nfet_03v3 ad=0.915p pd=4.22u as=0.39p ps=2.02u w=1.5u l=0.28u
X138 vdd.t78 a_15776_2628.t9 a_18058_1524.t2 vdd.t77 pfet_03v3 ad=3.25p pd=11.3u as=1.3p ps=5.52u w=5u l=0.5u
X139 vdd.t70 a_15776_2628.t13 a_16450_1524.t2 vdd.t69 pfet_03v3 ad=3.25p pd=11.3u as=1.3p ps=5.52u w=5u l=0.5u
X140 vss.t39 a_15000_12478# vss.t38 ppolyf_u r_width=1u r_length=36.6u
X141 a_762_4664.t5 vctrl.t6 a_440_4664.t6 vss.t92 nfet_03v3 ad=3.05p pd=11.22u as=3.05p ps=11.22u w=5u l=1u
X142 a_6600_18610# a_6000_12478# vss.t24 ppolyf_u r_width=1u r_length=30u
X143 a_1246_4604.t16 a_7330_21822.t2 a_2730_21882.t3 vss.t101 nfet_03v3 ad=1.22p pd=5.22u as=1.22p ps=5.22u w=2u l=0.5u
X144 a_570_27456.t4 a_562_21822.t15 vss.t1 vss.t0 nfet_03v3 ad=6.1p pd=21.22u as=6.1p ps=21.22u w=10u l=2u
X145 a_1246_4604.t0 a_770_8178.t9 vss.t56 vss.t55 nfet_03v3 ad=1.22p pd=5.22u as=1.22p ps=5.22u w=2u l=2u
X146 a_15772_n1100.t2 a_15776_2628.t18 vdd.t17 vdd.t16 pfet_03v3 ad=3.25p pd=11.3u as=3.25p ps=11.3u w=5u l=0.5u
X147 a_18176_360.t2 a_17436_0.t5 a_18866_0.t3 vss.t130 nfet_03v3 ad=0.39p pd=2.02u as=0.915p ps=4.22u w=1.5u l=0.28u
X148 a_770_8178.t1 a_770_8178.t0 vss.t35 vss.t34 nfet_03v3 ad=1.22p pd=5.22u as=1.22p ps=5.22u w=2u l=2u
X149 vco_out.t4 a_19972_1724.t7 vss.t127 vss.t126 nfet_03v3 ad=0.78p pd=3.52u as=1.83p ps=7.22u w=3u l=0.28u
X150 a_15776_2628.t4 pll_en.t6 vdd.t112 vdd.t111 pfet_03v3 ad=0.65p pd=3.3u as=0.65p ps=3.3u w=1u l=0.28u
X151 a_7330_21822.t0 pfd_dn.t0 vdd.t92 vdd.t91 pfet_03v3 ad=1.3p pd=5.3u as=1.3p ps=5.3u w=2u l=0.28u
X152 a_12000_19930# a_12600_12478# vss.t116 ppolyf_u r_width=1u r_length=36.6u
X153 a_1246_4604.t15 a_1246_4604.t14 a_440_8178.t4 vdd.t13 pfet_03v3 ad=3.25p pd=11.3u as=3.25p ps=11.3u w=5u l=1u
X154 a_19968_0.t0 a_18176_360.t4 a_19972_1724.t2 vss.t103 nfet_03v3 ad=1.22p pd=5.22u as=0.52p ps=2.52u w=2u l=0.28u
X155 vss.t140 pll_en.t0 a_19968_0.t3 vss.t139 nfet_03v3 ad=1.22p pd=5.22u as=0.52p ps=2.52u w=2u l=0.28u
X156 a_19972_1724.t4 pll_en.t3 vdd.t114 vdd.t113 pfet_03v3 ad=0.52p pd=2.52u as=1.3p ps=5.3u w=2u l=0.28u
X157 a_11586_22142.t1 pll_en.t10 vss.t136 vss.t135 nfet_03v3 ad=0.61p pd=3.22u as=0.61p ps=3.22u w=1u l=0.28u
X158 a_16450_1524.t1 a_16568_360.t6 a_15764_360.t2 vdd.t34 pfet_03v3 ad=1.95p pd=7.3u as=0.78p ps=3.52u w=3u l=0.28u
X159 a_2730_21882.t0 a_562_21822.t14 vss.t52 vss.t51 nfet_03v3 ad=6.1p pd=21.22u as=6.1p ps=21.22u w=10u l=2u
X160 a_1246_4604.t2 a_762_4664.t7 vdd.t90 vdd.t89 pfet_03v3 ad=2.6p pd=9.3u as=2.6p ps=9.3u w=4u l=2u
X161 a_16568_360.t3 a_18176_360.t11 a_18058_1524.t0 vdd.t121 pfet_03v3 ad=0.78p pd=3.52u as=1.95p ps=7.3u w=3u l=0.28u
X162 a_4800_16110.t3 a_6000_18610.t11 vss.t108 vss.t107 nfet_03v3 ad=6.1p pd=21.22u as=6.1p ps=21.22u w=10u l=2u
X163 a_7800_18610# a_8400_12478# vss.t102 ppolyf_u r_width=1u r_length=30u
X164 a_2730_21882.t1 a_562_21822.t13 vss.t61 vss.t60 nfet_03v3 ad=6.1p pd=21.22u as=6.1p ps=21.22u w=10u l=2u
X165 a_15776_2628.t1 a_15776_2628.t0 vdd.t10 vdd.t9 pfet_03v3 ad=3.25p pd=11.3u as=3.25p ps=11.3u w=5u l=0.5u
X166 a_570_27456.t6 pll_en.t9 vdd.t106 vdd.t105 pfet_03v3 ad=0.65p pd=3.3u as=0.65p ps=3.3u w=1u l=0.28u
X167 a_15776_2628.t3 a_15776_2628.t2 vdd.t118 vdd.t117 pfet_03v3 ad=3.25p pd=11.3u as=3.25p ps=11.3u w=5u l=0.5u
R0 vco_out vco_out.n1 8.6225
R1 vco_out.n1 vco_out.n4 5.7305
R2 vco_out.n4 vco_out.n3 6.77734
R3 vco_out.n3 vco_out.t4 0.5465
R4 vco_out.n3 vco_out.t3 0.5465
R5 vco_out.n4 vco_out.n2 6.61734
R6 vco_out.n2 vco_out.t2 0.607167
R7 vco_out.n2 vco_out.t0 0.607167
R8 vco_out.n1 vco_out.n0 11.1173
R9 vco_out.n0 vco_out.t1 0.607167
R10 vco_out.n0 vco_out.t5 0.607167
R11 bias_ref bias_ref.n0 56.2752
R12 bias_ref.n0 bias_ref.t0 21.0588
R13 bias_ref.n0 bias_ref.t1 23.8937
R14 pll_en pll_en.n0 10.1405
R15 pll_en.n0 pll_en.n9 6.1085
R16 pll_en.n9 pll_en.n8 5.37555
R17 pll_en.n8 pll_en.t0 45.5434
R18 pll_en.n8 pll_en.t1 45.7328
R19 pll_en.n9 pll_en.n7 6.03729
R20 pll_en.n7 pll_en.t2 45.5434
R21 pll_en.n7 pll_en.t3 45.7328
R22 pll_en.n4 pll_en.n3 4.5005
R23 pll_en.n0 pll_en.n6 11.8085
R24 pll_en.n6 pll_en.n4 4.1675
R25 pll_en.n6 pll_en.n5 5.1665
R26 pll_en.n5 pll_en.t4 96.3364
R27 pll_en.n5 pll_en.t5 95.7289
R28 pll_en.n2 pll_en.n1 1.121
R29 pll_en.n3 pll_en.n2 8.411
R30 pll_en.n3 pll_en.t6 44.7698
R31 pll_en.n2 pll_en.t7 57.513
R32 pll_en.n1 pll_en.t8 44.7023
R33 pll_en.n1 pll_en.t9 45.3278
R34 pll_en.n4 pll_en.t10 79.1968
R35 pfd_up.n1 pfd_up.n0 5.5535
R36 pfd_up pfd_up.n1 6.953
R37 pfd_up.n1 pfd_up.t2 87.3193
R38 pfd_up.n0 pfd_up.t0 55.1802
R39 pfd_up.n0 pfd_up.t1 64.4475
R40 vctrl vctrl.n10 18.4033
R41 vctrl.n10 vctrl.n6 3.9875
R42 vctrl.n6 vctrl.n0 11.903
R43 vctrl.n8 vctrl.n7 20.075
R44 vctrl.n9 vctrl.n8 0.77
R45 vctrl.n10 vctrl.n9 4.622
R46 vctrl.n9 vctrl.t4 40.0182
R47 vctrl.n8 vctrl.t5 40.0182
R48 vctrl.n7 vctrl.t6 40.0182
R49 vctrl.n7 vctrl.t7 42.3267
R50 vctrl.n2 vctrl.n1 1.283
R51 vctrl.n3 vctrl.n2 2.363
R52 vctrl.n5 vctrl.n3 1.4135
R53 vctrl.n4 vctrl.n5 11.0637
R54 vctrl.n6 vctrl.n4 9.27725
R55 vctrl.n5 vctrl.t3 9.23931
R56 vctrl.n4 vctrl.t1 12.186
R57 vctrl.n3 vctrl.t8 40.1274
R58 vctrl.n2 vctrl.t9 40.1274
R59 vctrl.n1 vctrl.t10 40.1274
R60 vctrl.n1 vctrl.t11 42.4899
R61 vctrl.n0 vctrl.t2 41.6334
R62 vctrl.n0 vctrl.t0 41.9313
R63 cp_trim1 cp_trim1.n0 21.9155
R64 cp_trim1.n0 cp_trim1.t0 58.7818
R65 cp_trim1.n0 cp_trim1.t1 59.9968
R66 cp_trim0 cp_trim0.n0 22.523
R67 cp_trim0.n0 cp_trim0.t0 58.4218
R68 cp_trim0.n0 cp_trim0.t1 59.6368
R69 pfd_dn pfd_dn.n0 7.133
R70 pfd_dn.n0 pfd_dn.n1 38.2212
R71 pfd_dn.n1 pfd_dn.t1 45.071
R72 pfd_dn.n1 pfd_dn.t2 47.265
R73 pfd_dn.n0 pfd_dn.t0 69.555
R74 vdd vdd.n83 21.8503
R75 vdd.n30 vdd.n29 3.6455
R76 vdd.n31 vdd.n30 0.43475
R77 vdd.n32 vdd.n31 1.013
R78 vdd.n33 vdd.n32 1.013
R79 vdd.n34 vdd.n33 1.07375
R80 vdd.n35 vdd.n34 0.43475
R81 vdd.n36 vdd.n35 1.013
R82 vdd.n37 vdd.n36 0.626
R83 vdd.n38 vdd.n37 0.626
R84 vdd.n39 vdd.n38 0.626
R85 vdd.n40 vdd.n39 0.68675
R86 vdd.n41 vdd.n40 0.43475
R87 vdd.n42 vdd.n41 0.626
R88 vdd.n57 vdd.n42 1.18625
R89 vdd.n43 vdd.n57 1.688
R90 vdd.n44 vdd.n43 1.78475
R91 vdd.n45 vdd.n44 0.6755
R92 vdd.n46 vdd.n45 0.6755
R93 vdd.n47 vdd.n46 0.73625
R94 vdd.n48 vdd.n47 0.43475
R95 vdd.n49 vdd.n48 0.6755
R96 vdd.n56 vdd.n49 0.68675
R97 vdd.n83 vdd.n56 7.7675
R98 vdd.n57 vdd.n82 24.2533
R99 vdd.n82 vdd.n65 0.3095
R100 vdd.n65 vdd.n66 0.3545
R101 vdd.n66 vdd.n67 0.2495
R102 vdd.n67 vdd.n58 0.254
R103 vdd.n58 vdd.n68 0.101
R104 vdd.n68 vdd.n69 0.2495
R105 vdd.n69 vdd.n70 0.3545
R106 vdd.n70 vdd.n71 0.2495
R107 vdd.n71 vdd.n60 0.248
R108 vdd.n60 vdd.n72 0.107
R109 vdd.n72 vdd.n73 0.2495
R110 vdd.n73 vdd.n74 0.3545
R111 vdd.n74 vdd.n75 0.3395
R112 vdd.n75 vdd.n62 0.152
R113 vdd.n62 vdd.n76 0.137
R114 vdd.n76 vdd.n77 0.3395
R115 vdd.n77 vdd.n78 0.2885
R116 vdd.n78 vdd.n79 0.3395
R117 vdd.n79 vdd.n64 0.098
R118 vdd.n64 vdd.n80 0.191
R119 vdd.n80 vdd.n81 0.3395
R120 vdd.n81 vdd.t101 4.86639
R121 vdd.n81 vdd.t50 4.57839
R122 vdd.n80 vdd.t12 4.57839
R123 vdd.n79 vdd.t52 4.57839
R124 vdd.n78 vdd.t44 5.64331
R125 vdd.n77 vdd.t46 5.64331
R126 vdd.n76 vdd.t116 5.64331
R127 vdd.n75 vdd.t114 5.64331
R128 vdd.n74 vdd.t6 2.01891
R129 vdd.n73 vdd.t8 2.01891
R130 vdd.n72 vdd.t78 2.01891
R131 vdd.n71 vdd.t80 2.01891
R132 vdd.n70 vdd.t82 2.01891
R133 vdd.n69 vdd.t84 2.01891
R134 vdd.n68 vdd.t70 2.01891
R135 vdd.n67 vdd.t72 2.01891
R136 vdd.n66 vdd.t19 2.01891
R137 vdd.n65 vdd.t21 2.01891
R138 vdd.n58 vdd.t69 12.6005
R139 vdd.n60 vdd.n59 12.6005
R140 vdd.n62 vdd.n61 12.6005
R141 vdd.n64 vdd.n63 12.6005
R142 vdd.n82 vdd.t33 203.654
R143 vdd.t33 vdd.t20 7.37315
R144 vdd.t20 vdd.t32 46.2471
R145 vdd.t32 vdd.t18 22.1185
R146 vdd.t18 vdd.t53 193.701
R147 vdd.t71 vdd.t53 7.37315
R148 vdd.t34 vdd.t71 46.2471
R149 vdd.t69 vdd.t34 22.1185
R150 vdd.t69 vdd.t48 193.701
R151 vdd.t48 vdd.t83 7.37315
R152 vdd.t83 vdd.t47 46.2471
R153 vdd.t47 vdd.t81 22.1185
R154 vdd.t121 vdd.t81 193.701
R155 vdd.t79 vdd.t121 7.37315
R156 vdd.t27 vdd.t79 46.2471
R157 vdd.n59 vdd.t27 19.4375
R158 vdd.n59 vdd.t77 2.68147
R159 vdd.t77 vdd.t103 193.701
R160 vdd.t103 vdd.t7 7.37315
R161 vdd.t7 vdd.t102 46.2471
R162 vdd.t102 vdd.t5 22.1185
R163 vdd.t113 vdd.t5 233.915
R164 vdd.n61 vdd.t113 30.1614
R165 vdd.n61 vdd.t115 23.4589
R166 vdd.t115 vdd.t45 226.542
R167 vdd.t45 vdd.t43 53.6198
R168 vdd.t51 vdd.t43 226.542
R169 vdd.n63 vdd.t51 6.03267
R170 vdd.n63 vdd.t11 47.5876
R171 vdd.t11 vdd.t49 226.542
R172 vdd.t49 vdd.t100 53.6198
R173 vdd.n29 vdd.t73 438.584
R174 vdd.t73 vdd.t104 505.781
R175 vdd.t104 vdd.t13 505.781
R176 vdd.t74 vdd.t13 505.781
R177 vdd.n50 vdd.t74 411.851
R178 vdd.n50 vdd.t75 411.851
R179 vdd.t75 vdd.t58 505.781
R180 vdd.t58 vdd.t4 505.781
R181 vdd.t76 vdd.t4 505.781
R182 vdd.n51 vdd.t76 411.851
R183 vdd.n51 vdd.t2 484.104
R184 vdd.t2 vdd.t89 650.289
R185 vdd.t0 vdd.t89 650.289
R186 vdd.n52 vdd.t0 484.104
R187 vdd.n52 vdd.t93 484.104
R188 vdd.t93 vdd.t97 526.013
R189 vdd.t97 vdd.t91 401.735
R190 vdd.t105 vdd.t91 401.735
R191 vdd.t107 vdd.t105 401.735
R192 vdd.n53 vdd.t107 359.827
R193 vdd.n53 vdd.t109 359.827
R194 vdd.t109 vdd.t87 1104.05
R195 vdd.n54 vdd.t87 1062.14
R196 vdd.n54 vdd.t26 375.724
R197 vdd.t26 vdd.t99 433.526
R198 vdd.t99 vdd.t9 433.526
R199 vdd.t16 vdd.t9 433.526
R200 vdd.t14 vdd.t16 433.526
R201 vdd.n55 vdd.t14 375.724
R202 vdd.n55 vdd.t117 375.724
R203 vdd.t117 vdd.t111 417.63
R204 vdd.n56 vdd.t111 382.916
R205 vdd.n47 vdd.n55 23.09
R206 vdd.n43 vdd.n54 23.09
R207 vdd.n40 vdd.n53 23.09
R208 vdd.n34 vdd.n52 23.09
R209 vdd.n30 vdd.n51 23.09
R210 vdd.n29 vdd.n50 23.09
R211 vdd.n49 vdd.t112 18.6345
R212 vdd.n48 vdd.t118 11.2274
R213 vdd.n46 vdd.t15 11.2274
R214 vdd.n45 vdd.t17 11.2274
R215 vdd.n44 vdd.t10 11.2274
R216 vdd.n42 vdd.t88 21.6308
R217 vdd.n41 vdd.t110 13.5844
R218 vdd.n39 vdd.t108 18.6345
R219 vdd.n38 vdd.t106 18.6345
R220 vdd.n37 vdd.t92 13.5844
R221 vdd.n36 vdd.t98 13.5844
R222 vdd.n35 vdd.t94 11.646
R223 vdd.n33 vdd.t1 11.646
R224 vdd.n32 vdd.t90 11.646
R225 vdd.n31 vdd.t3 11.646
R226 vdd.n1 vdd.n0 1.013
R227 vdd.n2 vdd.n1 1.013
R228 vdd.n3 vdd.n2 1.07375
R229 vdd.n4 vdd.n3 0.43475
R230 vdd.n5 vdd.n4 1.013
R231 vdd.n6 vdd.n5 1.013
R232 vdd.n7 vdd.n6 1.07375
R233 vdd.n8 vdd.n7 0.43475
R234 vdd.n9 vdd.n8 1.013
R235 vdd.n10 vdd.n9 1.013
R236 vdd.n11 vdd.n10 1.07375
R237 vdd.n12 vdd.n11 0.43475
R238 vdd.n13 vdd.n12 1.013
R239 vdd.n14 vdd.n13 1.013
R240 vdd.n15 vdd.n14 1.07375
R241 vdd.n16 vdd.n15 0.43475
R242 vdd.n17 vdd.n16 1.013
R243 vdd.n18 vdd.n17 1.013
R244 vdd.n19 vdd.n18 1.07375
R245 vdd.n20 vdd.n19 0.43475
R246 vdd.n21 vdd.n20 1.013
R247 vdd.n22 vdd.n21 1.013
R248 vdd.n28 vdd.n22 1.07375
R249 vdd.n83 vdd.n28 37.2583
R250 vdd.n0 vdd.t95 152.468
R251 vdd.t95 vdd.t30 167.162
R252 vdd.t119 vdd.t30 167.162
R253 vdd.n23 vdd.t119 124.444
R254 vdd.n23 vdd.t41 124.444
R255 vdd.t41 vdd.t22 167.162
R256 vdd.t35 vdd.t22 167.162
R257 vdd.n24 vdd.t35 124.444
R258 vdd.n24 vdd.t61 124.444
R259 vdd.t61 vdd.t24 167.162
R260 vdd.t56 vdd.t24 167.162
R261 vdd.n25 vdd.t56 124.444
R262 vdd.n25 vdd.t39 124.444
R263 vdd.t39 vdd.t59 167.162
R264 vdd.t65 vdd.t59 167.162
R265 vdd.n26 vdd.t65 124.444
R266 vdd.n26 vdd.t28 124.444
R267 vdd.t28 vdd.t54 167.162
R268 vdd.t37 vdd.t54 167.162
R269 vdd.n27 vdd.t37 124.444
R270 vdd.n27 vdd.t63 124.444
R271 vdd.t63 vdd.t85 167.162
R272 vdd.t67 vdd.t85 167.162
R273 vdd.n28 vdd.t67 152.032
R274 vdd.n19 vdd.n27 27.59
R275 vdd.n15 vdd.n26 27.59
R276 vdd.n11 vdd.n25 27.59
R277 vdd.n7 vdd.n24 27.59
R278 vdd.n3 vdd.n23 27.59
R279 vdd.n22 vdd.t68 16.146
R280 vdd.n21 vdd.t86 16.146
R281 vdd.n20 vdd.t64 16.146
R282 vdd.n18 vdd.t38 16.146
R283 vdd.n17 vdd.t55 16.146
R284 vdd.n16 vdd.t29 16.146
R285 vdd.n14 vdd.t66 16.146
R286 vdd.n13 vdd.t60 16.146
R287 vdd.n12 vdd.t40 16.146
R288 vdd.n10 vdd.t57 16.146
R289 vdd.n9 vdd.t25 16.146
R290 vdd.n8 vdd.t62 16.146
R291 vdd.n6 vdd.t36 16.146
R292 vdd.n5 vdd.t23 16.146
R293 vdd.n4 vdd.t42 12.6482
R294 vdd.n2 vdd.t120 12.6482
R295 vdd.n1 vdd.t31 12.6482
R296 vdd.n0 vdd.t96 12.6482
R297 vss.n107 vss.n106 4.5005
R298 vss vss.n107 17.8632
R299 vss.n107 vss.n0 16.25
R300 vss.n2 vss.n1 0.43025
R301 vss.n3 vss.n2 0.995
R302 vss.n4 vss.n3 0.995
R303 vss.n5 vss.n4 1.06025
R304 vss.n6 vss.n5 0.43025
R305 vss.n7 vss.n6 0.995
R306 vss.n105 vss.n7 0.14225
R307 vss.n8 vss.n105 0.85325
R308 vss.n9 vss.n8 1.06025
R309 vss.n10 vss.n9 0.43025
R310 vss.n11 vss.n10 0.995
R311 vss.n12 vss.n11 0.995
R312 vss.n13 vss.n12 1.06025
R313 vss.n14 vss.n13 0.43025
R314 vss.n15 vss.n14 1.7645
R315 vss.n25 vss.n15 0.69575
R316 vss.n16 vss.n25 0.07475
R317 vss.n17 vss.n16 0.83525
R318 vss.n18 vss.n17 0.43025
R319 vss.n19 vss.n18 0.995
R320 vss.n20 vss.n19 0.608
R321 vss.n21 vss.n20 0.608
R322 vss.n22 vss.n21 0.608
R323 vss.n23 vss.n22 0.72275
R324 vss.n24 vss.n23 0.43025
R325 vss.n106 vss.n24 3.15275
R326 vss.n105 vss.t95 13.992
R327 vss.n27 vss.n26 10.4005
R328 vss.n29 vss.n28 10.4005
R329 vss.n31 vss.n30 10.4005
R330 vss.n33 vss.n32 10.4005
R331 vss.n91 vss.n90 10.4005
R332 vss.n25 vss.n27 26.3862
R333 vss.n27 vss.n104 0.344
R334 vss.n104 vss.n103 0.3485
R335 vss.n103 vss.n102 0.2555
R336 vss.n102 vss.n29 0.254
R337 vss.n29 vss.n101 0.095
R338 vss.n101 vss.n100 0.2555
R339 vss.n100 vss.n99 0.3485
R340 vss.n99 vss.n98 0.2555
R341 vss.n98 vss.n31 0.248
R342 vss.n31 vss.n97 0.101
R343 vss.n97 vss.n96 0.2555
R344 vss.n96 vss.n95 0.3485
R345 vss.n95 vss.n94 0.3455
R346 vss.n94 vss.n33 0.152
R347 vss.n33 vss.n93 0.131
R348 vss.n93 vss.n92 0.9725
R349 vss.n92 vss.n91 0.098
R350 vss.n104 vss.t125 3.85787
R351 vss.n103 vss.t88 3.85787
R352 vss.n102 vss.t86 3.85787
R353 vss.n101 vss.t82 3.85787
R354 vss.n100 vss.t80 3.85787
R355 vss.n99 vss.t23 3.85787
R356 vss.n98 vss.t21 3.85787
R357 vss.n97 vss.t11 3.85787
R358 vss.n96 vss.t68 3.85787
R359 vss.n95 vss.t54 3.85787
R360 vss.n94 vss.t142 5.08945
R361 vss.n93 vss.t140 5.08945
R362 vss.n92 vss.t127 3.94787
R363 vss.n91 vss.t106 4.13237
R364 vss.n26 vss.n37 349.685
R365 vss.n26 vss.t7 582.12
R366 vss.t7 vss.t124 22.6271
R367 vss.t124 vss.t6 141.93
R368 vss.t6 vss.t87 67.8803
R369 vss.t87 vss.t59 594.462
R370 vss.t85 vss.t59 22.6271
R371 vss.t100 vss.t85 141.93
R372 vss.t81 vss.t100 67.8803
R373 vss.n28 vss.t81 4.11442
R374 vss.n28 vss.t70 590.348
R375 vss.t70 vss.t79 22.6271
R376 vss.t79 vss.t69 141.93
R377 vss.t69 vss.t22 67.8803
R378 vss.t22 vss.t9 594.462
R379 vss.t20 vss.t9 22.6271
R380 vss.t8 vss.t20 141.93
R381 vss.n30 vss.t8 63.7663
R382 vss.n30 vss.t10 4.11442
R383 vss.t10 vss.t130 594.462
R384 vss.t130 vss.t67 22.6271
R385 vss.t67 vss.t129 141.93
R386 vss.t129 vss.t53 67.8803
R387 vss.t141 vss.t53 717.88
R388 vss.n32 vss.t141 96.6777
R389 vss.n32 vss.t139 67.8803
R390 vss.t139 vss.t104 695.254
R391 vss.t104 vss.t103 164.558
R392 vss.t126 vss.t103 695.254
R393 vss.n90 vss.t126 22.6271
R394 vss.n90 vss.t105 141.93
R395 vss.n37 vss.t71 410.82
R396 vss.n34 vss.t71 489.154
R397 vss.n34 vss.t57 576.192
R398 vss.t57 vss.t65 619.712
R399 vss.t65 vss.t89 470.005
R400 vss.t40 vss.t89 470.005
R401 vss.t42 vss.t40 489.154
R402 vss.n35 vss.t42 445.635
R403 vss.n35 vss.t17 426.486
R404 vss.t17 vss.t93 532.673
R405 vss.t93 vss.t94 595.341
R406 vss.t137 vss.t94 532.673
R407 vss.t138 vss.t137 470.005
R408 vss.n36 vss.t138 426.486
R409 vss.n36 vss.n89 760.712
R410 vss.n89 vss.t105 7952.74
R411 vss.n50 vss.n42 21.9812
R412 vss.n54 vss.n43 21.9812
R413 vss.n55 vss.n44 21.9812
R414 vss.n61 vss.n45 21.9812
R415 vss.n67 vss.t109 3.46717
R416 vss.n68 vss.t128 3.46717
R417 vss.n69 vss.t62 3.46717
R418 vss.n70 vss.t110 3.46717
R419 vss.n71 vss.t31 10.4005
R420 vss.n72 vss.t19 10.4005
R421 vss.n73 vss.t145 10.4005
R422 vss.n74 vss.t24 10.4005
R423 vss.n75 vss.t99 10.4005
R424 vss.n76 vss.t29 10.4005
R425 vss.n77 vss.t102 10.4005
R426 vss.n78 vss.t28 10.4005
R427 vss.n79 vss.t16 10.4005
R428 vss.n80 vss.t143 10.4005
R429 vss.n81 vss.t4 10.4005
R430 vss.n82 vss.t30 10.4005
R431 vss.n83 vss.t116 10.4005
R432 vss.n84 vss.t119 10.4005
R433 vss.n85 vss.t144 10.4005
R434 vss.n86 vss.t36 10.4005
R435 vss.n87 vss.t37 8.68176
R436 vss.n47 vss.t109 112.921
R437 vss.t109 vss.t111 29.3254
R438 vss.t111 vss.t128 115.49
R439 vss.t128 vss.t0 44.531
R440 vss.t0 vss.t62 100.284
R441 vss.t62 vss.t51 59.7365
R442 vss.t51 vss.t110 85.079
R443 vss.t110 vss.n42 34.756
R444 vss.n42 vss.t60 119.835
R445 vss.t31 vss.t60 80.7346
R446 vss.t31 vss.t77 79.2864
R447 vss.t19 vss.t77 29.3254
R448 vss.t19 vss.t75 130.696
R449 vss.t145 vss.t75 86.5272
R450 vss.t145 vss.t113 46.3411
R451 vss.t113 vss.t24 62.2707
R452 vss.t24 vss.n43 30.4116
R453 vss.n43 vss.t99 78.2003
R454 vss.t99 vss.t101 14.482
R455 vss.t101 vss.t29 94.1299
R456 vss.t29 vss.t133 7.60326
R457 vss.t133 vss.t131 97.7503
R458 vss.t102 vss.t131 3.25883
R459 vss.t102 vss.t134 94.492
R460 vss.t28 vss.t134 14.1199
R461 vss.t28 vss.t132 83.6309
R462 vss.n44 vss.t132 88.6994
R463 vss.n44 vss.t16 44.893
R464 vss.t16 vss.t122 43.8069
R465 vss.t122 vss.t143 64.805
R466 vss.t143 vss.t114 32.9458
R467 vss.t114 vss.t4 75.6661
R468 vss.t4 vss.t32 22.0847
R469 vss.t32 vss.t30 86.5272
R470 vss.t30 vss.t135 11.2236
R471 vss.t135 vss.t116 97.3883
R472 vss.t116 vss.t117 31.4977
R473 vss.t117 vss.t119 77.1142
R474 vss.t119 vss.n45 42.7208
R475 vss.n45 vss.t144 65.8911
R476 vss.t144 vss.t48 53.9439
R477 vss.t48 vss.t36 54.668
R478 vss.t36 vss.t2 105.353
R479 vss.t37 vss.t2 3.25883
R480 vss.n87 vss.t38 9.27483
R481 vss.t38 vss.t107 48.1513
R482 vss.t107 vss.n46 119.835
R483 vss.n46 vss.n89 2677.22
R484 vss.n67 vss.n68 0.947868
R485 vss.n68 vss.n69 0.947868
R486 vss.n69 vss.n70 0.947868
R487 vss.n70 vss.n71 1.53997
R488 vss.n71 vss.n72 0.711026
R489 vss.n72 vss.n73 1.42155
R490 vss.n73 vss.n74 0.711026
R491 vss.n74 vss.n75 0.711026
R492 vss.n75 vss.n76 0.711026
R493 vss.n76 vss.n77 0.711026
R494 vss.n77 vss.n78 0.711026
R495 vss.n78 vss.n79 1.42155
R496 vss.n79 vss.n80 0.711026
R497 vss.n80 vss.n81 0.711026
R498 vss.n81 vss.n82 0.711026
R499 vss.n82 vss.n83 0.711026
R500 vss.n83 vss.n84 0.711026
R501 vss.n84 vss.n85 0.711026
R502 vss.n85 vss.n86 0.711026
R503 vss.n86 vss.n87 1.59954
R504 vss.n88 vss.n67 36.2627
R505 vss.n0 vss.n88 12.308
R506 vss.n88 vss.t39 19.9788
R507 vss.n66 vss.n46 21.9812
R508 vss.n48 vss.n47 0.995
R509 vss.n49 vss.n48 0.995
R510 vss.n50 vss.n49 1.06025
R511 vss.n51 vss.n50 0.43025
R512 vss.n52 vss.n51 0.995
R513 vss.n53 vss.n52 0.995
R514 vss.n54 vss.n53 1.71725
R515 vss.n55 vss.n54 3.5825
R516 vss.n56 vss.n55 0.43025
R517 vss.n57 vss.n56 0.608
R518 vss.n58 vss.n57 0.608
R519 vss.n59 vss.n58 0.608
R520 vss.n60 vss.n59 0.608
R521 vss.n61 vss.n60 1.06025
R522 vss.n62 vss.n61 0.43025
R523 vss.n63 vss.n62 0.995
R524 vss.n64 vss.n63 0.995
R525 vss.n66 vss.n64 1.06025
R526 vss.n65 vss.n66 5.324
R527 vss.n0 vss.n65 10.1863
R528 vss.n65 vss.t63 13.9313
R529 vss.n64 vss.t108 11.1876
R530 vss.n63 vss.t3 11.1876
R531 vss.n62 vss.t49 11.1876
R532 vss.n60 vss.t118 11.1876
R533 vss.n59 vss.t136 20.4058
R534 vss.n58 vss.t33 20.4058
R535 vss.n57 vss.t115 20.4058
R536 vss.n56 vss.t123 20.4058
R537 vss.n53 vss.t76 11.1876
R538 vss.n52 vss.t78 11.1876
R539 vss.n51 vss.t61 11.1876
R540 vss.n49 vss.t52 11.1876
R541 vss.n48 vss.t1 11.1876
R542 vss.n47 vss.t112 11.1876
R543 vss.n1 vss.t91 209.335
R544 vss.t91 vss.t50 225.047
R545 vss.t50 vss.t5 225.047
R546 vss.t92 vss.t5 225.047
R547 vss.n38 vss.t92 184.906
R548 vss.n38 vss.t34 217.808
R549 vss.t34 vss.t55 290.849
R550 vss.t12 vss.t55 290.849
R551 vss.n39 vss.t12 217.808
R552 vss.n39 vss.t14 217.808
R553 vss.t14 vss.t44 290.849
R554 vss.t46 vss.t44 290.849
R555 vss.n40 vss.t46 217.808
R556 vss.n40 vss.t83 217.808
R557 vss.t83 vss.t73 290.849
R558 vss.t97 vss.t73 290.849
R559 vss.n41 vss.t97 217.808
R560 vss.n41 vss.t26 217.808
R561 vss.t26 vss.t25 257.947
R562 vss.t25 vss.t120 225.047
R563 vss.n37 vss.t120 69.7515
R564 vss.n13 vss.n41 20.8562
R565 vss.n9 vss.n40 20.8562
R566 vss.n5 vss.n39 20.8562
R567 vss.n1 vss.n38 20.8562
R568 vss.n106 vss.n36 21.1308
R569 vss.n23 vss.n35 20.8562
R570 vss.n17 vss.n34 20.8562
R571 vss.n24 vss.t18 19.2808
R572 vss.n22 vss.t43 11.6644
R573 vss.n21 vss.t41 19.2808
R574 vss.n20 vss.t90 19.2808
R575 vss.n19 vss.t66 19.2808
R576 vss.n18 vss.t58 21.857
R577 vss.n16 vss.t72 11.2319
R578 vss.n15 vss.t121 11.2319
R579 vss.n14 vss.t27 13.7073
R580 vss.n12 vss.t98 13.7073
R581 vss.n11 vss.t74 13.7073
R582 vss.n10 vss.t84 13.7073
R583 vss.n8 vss.t47 13.7073
R584 vss.n7 vss.t45 13.7073
R585 vss.n6 vss.t15 13.7073
R586 vss.n4 vss.t13 13.7073
R587 vss.n3 vss.t56 13.7073
R588 vss.n2 vss.t35 13.7073
R589 a_19968_0.t2 a_19968_0.n0 0.8195
R590 a_19968_0.n0 a_19968_0.t3 0.8195
R591 a_19968_0.n0 a_19968_0.n1 7.64805
R592 a_19968_0.n1 a_19968_0.t1 8.17905
R593 a_19968_0.n1 a_19968_0.t0 8.60205
R594 a_18866_0.n0 a_18866_0.t1 0.8195
R595 a_18866_0.t0 a_18866_0.n0 0.8195
R596 a_18866_0.n0 a_18866_0.n1 7.36905
R597 a_18866_0.n1 a_18866_0.t3 9.85078
R598 a_18866_0.n1 a_18866_0.t2 9.75178
R599 a_18062_0.t0 a_18062_0.n1 9.75178
R600 a_18062_0.n1 a_18062_0.n0 7.36905
R601 a_18062_0.n0 a_18062_0.t3 0.8195
R602 a_18062_0.n0 a_18062_0.t2 0.8195
R603 a_18062_0.n1 a_18062_0.t1 9.85078
R604 a_17258_0.n0 a_17258_0.t3 0.8195
R605 a_17258_0.t0 a_17258_0.n0 0.8195
R606 a_17258_0.n0 a_17258_0.n1 7.36905
R607 a_17258_0.n1 a_17258_0.t2 9.85078
R608 a_17258_0.n1 a_17258_0.t1 9.75178
R609 a_16454_0.t0 a_16454_0.n1 9.85078
R610 a_16454_0.n1 a_16454_0.n0 7.36905
R611 a_16454_0.n0 a_16454_0.t2 0.8195
R612 a_16454_0.n0 a_16454_0.t1 0.8195
R613 a_16454_0.n1 a_16454_0.t3 9.75178
R614 a_15650_0.t0 a_15650_0.n1 9.75178
R615 a_15650_0.n1 a_15650_0.n0 7.36905
R616 a_15650_0.n0 a_15650_0.t3 0.8195
R617 a_15650_0.n0 a_15650_0.t2 0.8195
R618 a_15650_0.n1 a_15650_0.t1 9.85078
R619 a_19972_1724.n0 a_19972_1724.t4 0.9105
R620 a_19972_1724.t5 a_19972_1724.n0 0.9105
R621 a_19972_1724.n0 a_19972_1724.n4 12.9109
R622 a_19972_1724.n4 a_19972_1724.n3 4.5005
R623 a_19972_1724.n8 a_19972_1724.n7 4.5005
R624 a_19972_1724.n4 a_19972_1724.n8 1.8365
R625 a_19972_1724.n8 a_19972_1724.n9 10.8733
R626 a_19972_1724.n9 a_19972_1724.t8 58.5791
R627 a_19972_1724.n9 a_19972_1724.t9 58.7685
R628 a_19972_1724.n7 a_19972_1724.n6 5.67555
R629 a_19972_1724.n6 a_19972_1724.t6 58.5791
R630 a_19972_1724.n6 a_19972_1724.t7 58.7685
R631 a_19972_1724.n7 a_19972_1724.n5 5.13729
R632 a_19972_1724.n5 a_19972_1724.t10 58.5791
R633 a_19972_1724.n5 a_19972_1724.t11 58.7685
R634 a_19972_1724.n3 a_19972_1724.n2 8.09955
R635 a_19972_1724.n2 a_19972_1724.t3 0.8195
R636 a_19972_1724.n2 a_19972_1724.t2 0.8195
R637 a_19972_1724.n3 a_19972_1724.n1 7.19289
R638 a_19972_1724.n1 a_19972_1724.t1 0.9105
R639 a_19972_1724.n1 a_19972_1724.t0 0.9105
R640 a_17436_0.n0 a_17436_0.t1 0.607167
R641 a_17436_0.t0 a_17436_0.n0 0.607167
R642 a_17436_0.n0 a_17436_0.n1 6.31734
R643 a_17436_0.n1 a_17436_0.n5 9.24066
R644 a_17436_0.n5 a_17436_0.t3 1.0925
R645 a_17436_0.n5 a_17436_0.t2 1.0925
R646 a_17436_0.n1 a_17436_0.n4 11.9945
R647 a_17436_0.n4 a_17436_0.n3 6.12555
R648 a_17436_0.n3 a_17436_0.t4 39.0255
R649 a_17436_0.n3 a_17436_0.t5 39.215
R650 a_17436_0.n4 a_17436_0.n2 5.13729
R651 a_17436_0.n2 a_17436_0.t6 58.5791
R652 a_17436_0.n2 a_17436_0.t7 58.7685
R653 a_18176_360.n0 a_18176_360.t1 0.607167
R654 a_18176_360.t0 a_18176_360.n0 0.607167
R655 a_18176_360.n0 a_18176_360.n1 6.61734
R656 a_18176_360.n1 a_18176_360.n8 4.5005
R657 a_18176_360.n1 a_18176_360.n9 8.94066
R658 a_18176_360.n9 a_18176_360.t2 1.0925
R659 a_18176_360.n9 a_18176_360.t3 1.0925
R660 a_18176_360.n8 a_18176_360.n7 7.7225
R661 a_18176_360.n7 a_18176_360.n6 5.67555
R662 a_18176_360.n6 a_18176_360.t4 45.5434
R663 a_18176_360.n6 a_18176_360.t5 45.7328
R664 a_18176_360.n7 a_18176_360.n5 5.73729
R665 a_18176_360.n5 a_18176_360.t8 45.5434
R666 a_18176_360.n5 a_18176_360.t9 45.7328
R667 a_18176_360.n8 a_18176_360.n4 5.0645
R668 a_18176_360.n4 a_18176_360.n3 5.82555
R669 a_18176_360.n3 a_18176_360.t6 39.0255
R670 a_18176_360.n3 a_18176_360.t7 39.215
R671 a_18176_360.n4 a_18176_360.n2 5.43729
R672 a_18176_360.n2 a_18176_360.t11 58.7685
R673 a_18176_360.n2 a_18176_360.t10 58.5791
R674 a_15828_0.n0 a_15828_0.t3 0.607167
R675 a_15828_0.t2 a_15828_0.n0 0.607167
R676 a_15828_0.n0 a_15828_0.n1 6.61734
R677 a_15828_0.n1 a_15828_0.n5 8.94066
R678 a_15828_0.n5 a_15828_0.t1 1.0925
R679 a_15828_0.n5 a_15828_0.t0 1.0925
R680 a_15828_0.n1 a_15828_0.n4 11.9945
R681 a_15828_0.n4 a_15828_0.n3 5.82555
R682 a_15828_0.n3 a_15828_0.t4 39.0255
R683 a_15828_0.n3 a_15828_0.t5 39.215
R684 a_15828_0.n4 a_15828_0.n2 5.43729
R685 a_15828_0.n2 a_15828_0.t6 58.5791
R686 a_15828_0.n2 a_15828_0.t7 58.7685
R687 a_16568_360.n0 a_16568_360.t3 0.607167
R688 a_16568_360.t2 a_16568_360.n0 0.607167
R689 a_16568_360.n0 a_16568_360.n1 6.91734
R690 a_16568_360.n1 a_16568_360.n5 8.64066
R691 a_16568_360.n5 a_16568_360.t0 1.0925
R692 a_16568_360.n5 a_16568_360.t1 1.0925
R693 a_16568_360.n1 a_16568_360.n4 10.7705
R694 a_16568_360.n4 a_16568_360.n3 5.52555
R695 a_16568_360.n3 a_16568_360.t4 39.0255
R696 a_16568_360.n3 a_16568_360.t5 39.215
R697 a_16568_360.n4 a_16568_360.n2 5.73729
R698 a_16568_360.n2 a_16568_360.t7 58.7685
R699 a_16568_360.n2 a_16568_360.t6 58.5791
R700 a_15764_360.n0 a_15764_360.t3 0.607167
R701 a_15764_360.t2 a_15764_360.n0 0.607167
R702 a_15764_360.n0 a_15764_360.n1 6.91734
R703 a_15764_360.n1 a_15764_360.n5 8.64066
R704 a_15764_360.n5 a_15764_360.t0 1.0925
R705 a_15764_360.n5 a_15764_360.t1 1.0925
R706 a_15764_360.n1 a_15764_360.n4 9.5645
R707 a_15764_360.n4 a_15764_360.n3 5.52555
R708 a_15764_360.n3 a_15764_360.t4 39.0255
R709 a_15764_360.n3 a_15764_360.t5 39.215
R710 a_15764_360.n4 a_15764_360.n2 5.73729
R711 a_15764_360.n2 a_15764_360.t7 58.7685
R712 a_15764_360.n2 a_15764_360.t6 58.5791
R713 a_18862_1524.t2 a_18862_1524.n1 7.22309
R714 a_18862_1524.n1 a_18862_1524.t3 7.12409
R715 a_18862_1524.n1 a_18862_1524.n0 6.20245
R716 a_18862_1524.n0 a_18862_1524.t1 0.3645
R717 a_18862_1524.n0 a_18862_1524.t0 0.3645
R718 a_18058_1524.t1 a_18058_1524.n1 7.12409
R719 a_18058_1524.n1 a_18058_1524.t0 7.22309
R720 a_18058_1524.n1 a_18058_1524.n0 6.20245
R721 a_18058_1524.n0 a_18058_1524.t3 0.3645
R722 a_18058_1524.n0 a_18058_1524.t2 0.3645
R723 a_17254_1524.t1 a_17254_1524.n1 7.12409
R724 a_17254_1524.n1 a_17254_1524.t0 7.22309
R725 a_17254_1524.n1 a_17254_1524.n0 6.20245
R726 a_17254_1524.n0 a_17254_1524.t3 0.3645
R727 a_17254_1524.n0 a_17254_1524.t2 0.3645
R728 a_16450_1524.t1 a_16450_1524.n1 7.12409
R729 a_16450_1524.n1 a_16450_1524.t0 7.22309
R730 a_16450_1524.n1 a_16450_1524.n0 6.20245
R731 a_16450_1524.n0 a_16450_1524.t3 0.3645
R732 a_16450_1524.n0 a_16450_1524.t2 0.3645
R733 a_15646_1524.t2 a_15646_1524.n1 7.22309
R734 a_15646_1524.n1 a_15646_1524.t3 7.12409
R735 a_15646_1524.n1 a_15646_1524.n0 6.20245
R736 a_15646_1524.n0 a_15646_1524.t1 0.3645
R737 a_15646_1524.n0 a_15646_1524.t0 0.3645
R738 a_8114_4664.t3 a_8114_4664.n2 12.1319
R739 a_8114_4664.n1 a_8114_4664.n0 0.77
R740 a_8114_4664.n2 a_8114_4664.n1 0.365
R741 a_8114_4664.n2 a_8114_4664.t4 12.7394
R742 a_8114_4664.n1 a_8114_4664.t2 12.1319
R743 a_8114_4664.n0 a_8114_4664.t1 12.1319
R744 a_8114_4664.n0 a_8114_4664.t0 28.7193
R745 a_440_4664.t0 a_440_4664.n5 11.4119
R746 a_440_4664.n5 a_440_4664.n0 0.77
R747 a_440_4664.n5 a_440_4664.n1 0.77
R748 a_440_4664.n1 a_440_4664.n2 7.3625
R749 a_440_4664.n2 a_440_4664.n3 1.49
R750 a_440_4664.n3 a_440_4664.n4 1.9895
R751 a_440_4664.n4 a_440_4664.t1 15.3768
R752 a_440_4664.n4 a_440_4664.t7 13.8873
R753 a_440_4664.n3 a_440_4664.t4 13.8873
R754 a_440_4664.n2 a_440_4664.t2 13.8873
R755 a_440_4664.n1 a_440_4664.t6 11.4119
R756 a_440_4664.n0 a_440_4664.t3 11.4119
R757 a_440_4664.n0 a_440_4664.t5 12.1814
R758 a_15772_n1100.t1 a_15772_n1100.n0 13.8307
R759 a_15772_n1100.n0 a_15772_n1100.n12 14.0675
R760 a_15772_n1100.n2 a_15772_n1100.n11 20.624
R761 a_15772_n1100.n12 a_15772_n1100.n2 0.77225
R762 a_15772_n1100.n11 a_15772_n1100.n5 1.1405
R763 a_15772_n1100.n5 a_15772_n1100.n7 1.1765
R764 a_15772_n1100.n7 a_15772_n1100.n9 1.1765
R765 a_15772_n1100.n9 a_15772_n1100.n10 10.8946
R766 a_15772_n1100.n10 a_15772_n1100.t5 29.6085
R767 a_15772_n1100.n10 a_15772_n1100.t6 29.8501
R768 a_15772_n1100.n9 a_15772_n1100.n8 9.71861
R769 a_15772_n1100.n8 a_15772_n1100.t7 29.6085
R770 a_15772_n1100.n8 a_15772_n1100.t8 29.8501
R771 a_15772_n1100.n7 a_15772_n1100.n6 9.71861
R772 a_15772_n1100.n6 a_15772_n1100.t9 29.6085
R773 a_15772_n1100.n6 a_15772_n1100.t10 29.8501
R774 a_15772_n1100.n5 a_15772_n1100.n4 9.71861
R775 a_15772_n1100.n4 a_15772_n1100.t11 29.6085
R776 a_15772_n1100.n4 a_15772_n1100.t12 29.8501
R777 a_15772_n1100.n11 a_15772_n1100.n3 9.74561
R778 a_15772_n1100.n3 a_15772_n1100.t13 29.6085
R779 a_15772_n1100.n3 a_15772_n1100.t14 29.8501
R780 a_15772_n1100.n12 a_15772_n1100.t0 21.0515
R781 a_15772_n1100.n2 a_15772_n1100.n1 11.2168
R782 a_15772_n1100.n1 a_15772_n1100.t4 1.88813
R783 a_15772_n1100.n1 a_15772_n1100.t3 44.5424
R784 a_15772_n1100.n0 a_15772_n1100.t2 14.3392
R785 a_14782_4664.t1 a_14782_4664.n2 12.4919
R786 a_14782_4664.n2 a_14782_4664.n1 0.78125
R787 a_14782_4664.n1 a_14782_4664.n0 0.878
R788 a_14782_4664.n1 a_14782_4664.t2 37.851
R789 a_14782_4664.n0 a_14782_4664.t0 20.9795
R790 a_14782_4664.n0 a_14782_4664.t4 17.4463
R791 a_14782_4664.n2 a_14782_4664.t3 13.2614
R792 a_762_4664.t5 a_762_4664.n5 11.5919
R793 a_762_4664.n5 a_762_4664.n4 19.9018
R794 a_762_4664.n4 a_762_4664.n1 0.0275
R795 a_762_4664.n1 a_762_4664.n2 1.013
R796 a_762_4664.n2 a_762_4664.n3 12.0492
R797 a_762_4664.n3 a_762_4664.t3 1.83599
R798 a_762_4664.n3 a_762_4664.t2 12.2744
R799 a_762_4664.n2 a_762_4664.t6 22.759
R800 a_762_4664.n1 a_762_4664.t7 22.759
R801 a_762_4664.n4 a_762_4664.n0 11.8648
R802 a_762_4664.n0 a_762_4664.t1 1.83599
R803 a_762_4664.n0 a_762_4664.t0 12.2744
R804 a_762_4664.n5 a_762_4664.t4 13.9004
R805 a_770_8178.t4 a_770_8178.n7 11.5874
R806 a_770_8178.n7 a_770_8178.n0 1.283
R807 a_770_8178.n0 a_770_8178.n1 2.363
R808 a_770_8178.n1 a_770_8178.n6 15.0755
R809 a_770_8178.n4 a_770_8178.n3 0.995
R810 a_770_8178.n6 a_770_8178.n4 1.32125
R811 a_770_8178.n6 a_770_8178.n5 11.1312
R812 a_770_8178.n5 a_770_8178.t3 3.47655
R813 a_770_8178.n5 a_770_8178.t2 8.58548
R814 a_770_8178.n4 a_770_8178.t8 19.4863
R815 a_770_8178.n3 a_770_8178.t9 19.4863
R816 a_770_8178.n3 a_770_8178.n2 12.2945
R817 a_770_8178.n2 a_770_8178.t1 3.47655
R818 a_770_8178.n2 a_770_8178.t0 8.58548
R819 a_770_8178.n1 a_770_8178.t7 11.5874
R820 a_770_8178.n0 a_770_8178.t5 11.5874
R821 a_770_8178.n7 a_770_8178.t6 13.9499
R822 a_15776_2628.t6 a_15776_2628.n0 13.4594
R823 a_15776_2628.n1 a_15776_2628.n16 19.5462
R824 a_15776_2628.n0 a_15776_2628.n1 1.21775
R825 a_15776_2628.n16 a_15776_2628.n10 0.9125
R826 a_15776_2628.n10 a_15776_2628.n12 1.1765
R827 a_15776_2628.n12 a_15776_2628.n14 1.1765
R828 a_15776_2628.n14 a_15776_2628.n15 10.8963
R829 a_15776_2628.n15 a_15776_2628.t7 51.6545
R830 a_15776_2628.n15 a_15776_2628.t8 51.8961
R831 a_15776_2628.n14 a_15776_2628.n13 9.72034
R832 a_15776_2628.n13 a_15776_2628.t9 51.6545
R833 a_15776_2628.n13 a_15776_2628.t10 51.8961
R834 a_15776_2628.n12 a_15776_2628.n11 9.72034
R835 a_15776_2628.n11 a_15776_2628.t11 51.6545
R836 a_15776_2628.n11 a_15776_2628.t12 51.8961
R837 a_15776_2628.n10 a_15776_2628.n9 9.72034
R838 a_15776_2628.n9 a_15776_2628.t13 51.6545
R839 a_15776_2628.n9 a_15776_2628.t14 51.8961
R840 a_15776_2628.n16 a_15776_2628.n8 9.95434
R841 a_15776_2628.n8 a_15776_2628.t15 51.6545
R842 a_15776_2628.n8 a_15776_2628.t16 51.8961
R843 a_15776_2628.n1 a_15776_2628.n7 13.7075
R844 a_15776_2628.n4 a_15776_2628.n3 0.6755
R845 a_15776_2628.n6 a_15776_2628.n4 1.00175
R846 a_15776_2628.n7 a_15776_2628.n6 0.00725
R847 a_15776_2628.n7 a_15776_2628.t4 21.5933
R848 a_15776_2628.n6 a_15776_2628.n5 11.9233
R849 a_15776_2628.n5 a_15776_2628.t3 1.6447
R850 a_15776_2628.n5 a_15776_2628.t2 51.9932
R851 a_15776_2628.n4 a_15776_2628.t17 63.6952
R852 a_15776_2628.n3 a_15776_2628.t18 63.6952
R853 a_15776_2628.n3 a_15776_2628.n2 12.767
R854 a_15776_2628.n2 a_15776_2628.t1 1.6447
R855 a_15776_2628.n2 a_15776_2628.t0 51.9932
R856 a_15776_2628.n0 a_15776_2628.t5 12.8519
R857 a_4200_16110.t1 a_4200_16110.n0 13.2614
R858 a_4200_16110.n0 a_4200_16110.t0 76.7935
R859 a_4200_16110.n0 a_4200_16110.t2 12.4919
R860 a_4800_16110.t0 a_4800_16110.n2 14.0676
R861 a_4800_16110.n2 a_4800_16110.n0 0.995
R862 a_4800_16110.n2 a_4800_16110.n1 0.995
R863 a_4800_16110.n1 a_4800_16110.t1 71.5128
R864 a_4800_16110.n1 a_4800_16110.t3 14.0676
R865 a_4800_16110.n0 a_4800_16110.t2 14.0676
R866 a_4800_16110.n0 a_4800_16110.t4 15.5571
R867 a_10570_21882.t0 a_10570_21882.n0 21.0926
R868 a_10570_21882.n0 a_10570_21882.t1 71.5708
R869 a_10570_21882.n0 a_10570_21882.t2 54.6402
R870 a_11586_22142.t0 a_11586_22142.n0 18.5456
R871 a_11586_22142.n0 a_11586_22142.n5 10.4585
R872 a_11586_22142.n3 a_11586_22142.n2 0.608
R873 a_11586_22142.n4 a_11586_22142.n3 1.76
R874 a_11586_22142.n5 a_11586_22142.n4 10.508
R875 a_11586_22142.n4 a_11586_22142.t2 44.8461
R876 a_11586_22142.n3 a_11586_22142.t3 44.8461
R877 a_11586_22142.n2 a_11586_22142.t4 44.8461
R878 a_11586_22142.n2 a_11586_22142.t5 45.4536
R879 a_11586_22142.n5 a_11586_22142.n1 32.315
R880 a_11586_22142.n1 a_11586_22142.t1 22.9257
R881 a_11586_22142.n1 a_11586_22142.t7 47.1298
R882 a_11586_22142.n0 a_11586_22142.t6 14.7589
R883 a_9050_21882.t0 a_9050_21882.t1 34.3486
R884 a_1246_4604.t7 a_1246_4604.n0 1.68292
R885 a_1246_4604.n0 a_1246_4604.t6 30.1453
R886 a_1246_4604.n0 a_1246_4604.n15 10.2695
R887 a_1246_4604.n15 a_1246_4604.n2 3.254
R888 a_1246_4604.n2 a_1246_4604.n3 0.995
R889 a_1246_4604.n3 a_1246_4604.n14 26.8632
R890 a_1246_4604.n8 a_1246_4604.n6 2.858
R891 a_1246_4604.n10 a_1246_4604.n8 0.788
R892 a_1246_4604.n11 a_1246_4604.n10 3.308
R893 a_1246_4604.n12 a_1246_4604.n11 1.013
R894 a_1246_4604.n13 a_1246_4604.n12 9.788
R895 a_1246_4604.n14 a_1246_4604.n13 9.32225
R896 a_1246_4604.n13 a_1246_4604.t17 12.366
R897 a_1246_4604.n12 a_1246_4604.t3 12.366
R898 a_1246_4604.n11 a_1246_4604.t2 12.366
R899 a_1246_4604.n10 a_1246_4604.n9 10.3032
R900 a_1246_4604.n9 a_1246_4604.t11 1.6447
R901 a_1246_4604.n9 a_1246_4604.t10 30.2254
R902 a_1246_4604.n8 a_1246_4604.n7 10.3032
R903 a_1246_4604.n7 a_1246_4604.t13 1.6447
R904 a_1246_4604.n7 a_1246_4604.t12 30.2254
R905 a_1246_4604.n6 a_1246_4604.n5 10.3032
R906 a_1246_4604.n5 a_1246_4604.t15 1.6447
R907 a_1246_4604.n5 a_1246_4604.t14 30.2254
R908 a_1246_4604.n6 a_1246_4604.n4 11.0908
R909 a_1246_4604.n4 a_1246_4604.t9 1.6447
R910 a_1246_4604.n4 a_1246_4604.t8 30.2254
R911 a_1246_4604.n14 a_1246_4604.t16 52.8618
R912 a_1246_4604.n3 a_1246_4604.t1 14.4273
R913 a_1246_4604.n2 a_1246_4604.t0 14.4273
R914 a_1246_4604.n15 a_1246_4604.n1 11.039
R915 a_1246_4604.n1 a_1246_4604.t5 1.68292
R916 a_1246_4604.n1 a_1246_4604.t4 30.1453
R917 a_7330_21822.t0 a_7330_21822.n0 65.6246
R918 a_7330_21822.n0 a_7330_21822.t1 21.4858
R919 a_7330_21822.n0 a_7330_21822.t2 46.1242
R920 a_2730_21882.t0 a_2730_21882.n0 13.2171
R921 a_2730_21882.n0 a_2730_21882.n1 2.354
R922 a_2730_21882.n1 a_2730_21882.t3 16.5243
R923 a_2730_21882.n1 a_2730_21882.t2 15.3723
R924 a_2730_21882.n0 a_2730_21882.t1 11.7276
R925 a_6000_18610.t0 a_6000_18610.n12 12.7444
R926 a_6000_18610.n1 a_6000_18610.n0 1.49
R927 a_6000_18610.n2 a_6000_18610.n1 0.995
R928 a_6000_18610.n3 a_6000_18610.n2 0.995
R929 a_6000_18610.n4 a_6000_18610.n3 1.49
R930 a_6000_18610.n12 a_6000_18610.n4 0.19625
R931 a_6000_18610.n12 a_6000_18610.n5 1.34375
R932 a_6000_18610.n5 a_6000_18610.n6 0.77
R933 a_6000_18610.n6 a_6000_18610.n7 3.14375
R934 a_6000_18610.n7 a_6000_18610.n11 25.0588
R935 a_6000_18610.n11 a_6000_18610.t2 45.2912
R936 a_6000_18610.n9 a_6000_18610.n8 0.995
R937 a_6000_18610.n10 a_6000_18610.n9 0.995
R938 a_6000_18610.n11 a_6000_18610.n10 17.7507
R939 a_6000_18610.n10 a_6000_18610.t11 35.5713
R940 a_6000_18610.n9 a_6000_18610.t12 35.5713
R941 a_6000_18610.n8 a_6000_18610.t13 35.5713
R942 a_6000_18610.n8 a_6000_18610.t14 37.0608
R943 a_6000_18610.n7 a_6000_18610.t1 20.3608
R944 a_6000_18610.n6 a_6000_18610.t3 40.5582
R945 a_6000_18610.n5 a_6000_18610.t4 40.5582
R946 a_6000_18610.n4 a_6000_18610.t5 19.6663
R947 a_6000_18610.n3 a_6000_18610.t6 19.6663
R948 a_6000_18610.n2 a_6000_18610.t7 19.6663
R949 a_6000_18610.n1 a_6000_18610.t8 19.6663
R950 a_6000_18610.n0 a_6000_18610.t9 19.6663
R951 a_6000_18610.n0 a_6000_18610.t10 20.6608
R952 a_8872_21882.t1 a_8872_21882.t0 80.3608
R953 a_11206_4664.t0 a_11206_4664.n1 19.6407
R954 a_11206_4664.n1 a_11206_4664.n0 4.07525
R955 a_11206_4664.n1 a_11206_4664.t1 78.0862
R956 a_11206_4664.n0 a_11206_4664.t3 36.4132
R957 a_11206_4664.n0 a_11206_4664.t2 17.4896
R958 a_7792_21882.t1 a_7792_21882.t0 84.0283
R959 a_8332_21882.t2 a_8332_21882.n0 62.0103
R960 a_8332_21882.n0 a_8332_21882.t0 17.226
R961 a_8332_21882.n0 a_8332_21882.t1 23.2785
R962 a_562_21822.t8 a_562_21822.n0 1.64987
R963 a_562_21822.n0 a_562_21822.t7 23.1665
R964 a_562_21822.n0 a_562_21822.n13 9.71825
R965 a_562_21822.n3 a_562_21822.n2 0.995
R966 a_562_21822.n4 a_562_21822.n3 1.49
R967 a_562_21822.n5 a_562_21822.n4 0.995
R968 a_562_21822.n13 a_562_21822.n5 0.82625
R969 a_562_21822.n13 a_562_21822.n6 2.417
R970 a_562_21822.n6 a_562_21822.n7 0.608
R971 a_562_21822.n7 a_562_21822.n8 1.2155
R972 a_562_21822.n8 a_562_21822.n9 2.318
R973 a_562_21822.n9 a_562_21822.n12 41.6705
R974 a_562_21822.n11 a_562_21822.n10 8.078
R975 a_562_21822.n12 a_562_21822.n11 2.5205
R976 a_562_21822.n12 a_562_21822.t4 17.046
R977 a_562_21822.n11 a_562_21822.t2 17.046
R978 a_562_21822.n10 a_562_21822.t0 17.046
R979 a_562_21822.n10 a_562_21822.t1 19.566
R980 a_562_21822.n9 a_562_21822.t3 20.5858
R981 a_562_21822.n8 a_562_21822.t9 15.0123
R982 a_562_21822.n7 a_562_21822.t10 15.0123
R983 a_562_21822.n6 a_562_21822.t11 15.0123
R984 a_562_21822.n5 a_562_21822.t12 32.6913
R985 a_562_21822.n4 a_562_21822.t13 32.6913
R986 a_562_21822.n3 a_562_21822.t14 32.6913
R987 a_562_21822.n2 a_562_21822.t15 32.6913
R988 a_562_21822.n2 a_562_21822.n1 10.8815
R989 a_562_21822.n1 a_562_21822.t6 1.64987
R990 a_562_21822.n1 a_562_21822.t5 23.1665
R991 a_440_8178.t6 a_440_8178.n9 11.4074
R992 a_440_8178.n1 a_440_8178.n0 0.788
R993 a_440_8178.n2 a_440_8178.n1 0.788
R994 a_440_8178.n3 a_440_8178.n2 1.283
R995 a_440_8178.n4 a_440_8178.n3 0.788
R996 a_440_8178.n9 a_440_8178.n4 0.788
R997 a_440_8178.n9 a_440_8178.n5 0.788
R998 a_440_8178.n5 a_440_8178.n8 62.7282
R999 a_440_8178.n7 a_440_8178.n6 10.598
R1000 a_440_8178.n8 a_440_8178.n7 2.0255
R1001 a_440_8178.n8 a_440_8178.t7 16.686
R1002 a_440_8178.n7 a_440_8178.t2 16.686
R1003 a_440_8178.n6 a_440_8178.t1 16.686
R1004 a_440_8178.n6 a_440_8178.t0 19.206
R1005 a_440_8178.n5 a_440_8178.t11 11.4074
R1006 a_440_8178.n4 a_440_8178.t5 11.4074
R1007 a_440_8178.n3 a_440_8178.t10 11.4074
R1008 a_440_8178.n2 a_440_8178.t9 11.4074
R1009 a_440_8178.n1 a_440_8178.t4 11.4074
R1010 a_440_8178.n0 a_440_8178.t3 11.4074
R1011 a_440_8178.n0 a_440_8178.t8 12.1949
R1012 a_4610_27456.t0 a_4610_27456.n0 14.8729
R1013 a_4610_27456.n0 a_4610_27456.n15 15.8788
R1014 a_4610_27456.n15 a_4610_27456.t4 35.1743
R1015 a_4610_27456.n2 a_4610_27456.n1 1.508
R1016 a_4610_27456.n3 a_4610_27456.n2 1.013
R1017 a_4610_27456.n4 a_4610_27456.n3 1.013
R1018 a_4610_27456.n5 a_4610_27456.n4 1.508
R1019 a_4610_27456.n7 a_4610_27456.n5 0.84425
R1020 a_4610_27456.n8 a_4610_27456.n7 1.18175
R1021 a_4610_27456.n9 a_4610_27456.n8 1.508
R1022 a_4610_27456.n10 a_4610_27456.n9 1.013
R1023 a_4610_27456.n11 a_4610_27456.n10 1.013
R1024 a_4610_27456.n12 a_4610_27456.n11 1.508
R1025 a_4610_27456.n13 a_4610_27456.n12 1.013
R1026 a_4610_27456.n14 a_4610_27456.n13 1.013
R1027 a_4610_27456.n15 a_4610_27456.n14 33.3838
R1028 a_4610_27456.n14 a_4610_27456.t5 27.079
R1029 a_4610_27456.n13 a_4610_27456.t6 27.079
R1030 a_4610_27456.n12 a_4610_27456.t7 27.079
R1031 a_4610_27456.n11 a_4610_27456.t8 27.079
R1032 a_4610_27456.n10 a_4610_27456.t9 27.079
R1033 a_4610_27456.n9 a_4610_27456.t10 27.079
R1034 a_4610_27456.n8 a_4610_27456.t11 27.079
R1035 a_4610_27456.n7 a_4610_27456.n6 15.0305
R1036 a_4610_27456.n6 a_4610_27456.t3 1.83599
R1037 a_4610_27456.n6 a_4610_27456.t2 12.2744
R1038 a_4610_27456.n5 a_4610_27456.t12 27.079
R1039 a_4610_27456.n4 a_4610_27456.t13 27.079
R1040 a_4610_27456.n3 a_4610_27456.t14 27.079
R1041 a_4610_27456.n2 a_4610_27456.t15 27.079
R1042 a_4610_27456.n1 a_4610_27456.t16 27.079
R1043 a_4610_27456.n1 a_4610_27456.t17 28.0915
R1044 a_4610_27456.n0 a_4610_27456.t1 22.037
R1045 a_1870_27516.t0 a_1870_27516.n0 14.0207
R1046 a_1870_27516.n0 a_1870_27516.n1 64.0783
R1047 a_1870_27516.n1 a_1870_27516.t2 13.806
R1048 a_1870_27516.n1 a_1870_27516.t1 14.481
R1049 a_1870_27516.n0 a_1870_27516.t3 13.0082
R1050 a_570_27456.t3 a_570_27456.n0 3.11042
R1051 a_570_27456.n0 a_570_27456.t2 50.5496
R1052 a_570_27456.n0 a_570_27456.n6 9.71825
R1053 a_570_27456.n3 a_570_27456.n2 1.013
R1054 a_570_27456.n6 a_570_27456.n3 1.33925
R1055 a_570_27456.n6 a_570_27456.n5 34.2793
R1056 a_570_27456.n5 a_570_27456.t6 51.048
R1057 a_570_27456.n5 a_570_27456.n4 23.7852
R1058 a_570_27456.n4 a_570_27456.t5 11.5476
R1059 a_570_27456.n4 a_570_27456.t4 15.0261
R1060 a_570_27456.n3 a_570_27456.t7 60.139
R1061 a_570_27456.n2 a_570_27456.t8 60.139
R1062 a_570_27456.n2 a_570_27456.n1 10.8995
R1063 a_570_27456.n1 a_570_27456.t1 3.11042
R1064 a_570_27456.n1 a_570_27456.t0 50.5496
C0 a_2800_20110# a_400_12478# 0.04747f
C1 bias_ref cp_trim0 0.00247f
C2 a_7200_12478# a_6000_12478# 0.00585f
C3 a_10200_12478# a_2800_20110# 0.02959f
C4 a_11400_12478# a_10200_12478# 0.00585f
C5 vctrl a_2800_20110# 12.3242f
C6 vdd cp_trim1 0.05642f
C7 vco_out pll_en 0.61997f
C8 pfd_dn pfd_up 3.21485f
C9 bias_ref pll_en 0.1054f
C10 a_2000_12478# a_400_12478# 0.00585f
C11 vctrl cp_trim1 0.0778f
C12 cp_trim0 pfd_dn 0.065f
C13 a_2000_12478# vctrl 0.00842f
C14 bias_ref a_2800_20110# 4.89881f
C15 a_13800_12478# a_15000_12478# 0.00585f
C16 pfd_dn pll_en 0.27106f
C17 a_13800_12478# a_12600_12478# 0.00585f
C18 a_14400_19930# vctrl 0.00289f
C19 cp_trim0 pfd_up 0.07656f
C20 a_10800_19930# a_2800_20110# 0.09186f
C21 bias_ref cp_trim1 0.00516f
C22 vctrl a_1200_20110# 0.01597f
C23 vdd vctrl 6.04476f
C24 pfd_up pll_en 0.27016f
C25 pfd_dn a_2800_20110# 3.74566f
C26 vctrl a_12000_19930# 0.00289f
C27 vctrl a_6000_12478# 0.00279f
C28 vctrl a_400_12478# 0.00842f
C29 a_14400_19930# bias_ref 0
C30 vdd vco_out 0.63527f
C31 pfd_up a_2800_20110# 2.62965f
C32 a_4200_12478# a_2800_20110# 0.02959f
C33 bias_ref vdd 1.09436f
C34 cp_trim0 pll_en 0.0832f
C35 pfd_dn cp_trim1 0.07807f
C36 bias_ref a_7800_18610# 0.00948f
C37 a_8400_12478# a_2800_20110# 0.02959f
C38 bias_ref a_12000_19930# 0
C39 a_13200_19930# a_2800_20110# 0.09187f
C40 vco_out vctrl 0.11638f
C41 a_8400_12478# a_7200_12478# 0.00585f
C42 pfd_up cp_trim1 0.07714f
C43 cp_trim0 a_2800_20110# 3.24502f
C44 bias_ref vctrl 0.13449f
C45 a_2000_12478# a_4200_12478# 0.00234f
C46 a_10800_19930# a_12000_19930# 0.00585f
C47 a_6600_18610# a_2800_20110# 0.10189f
C48 vdd pfd_dn 0.58949f
C49 a_2800_20110# pll_en 2.38963f
C50 vctrl a_10800_19930# 0.00289f
C51 cp_trim0 cp_trim1 0.30197f
C52 bias_ref vco_out 0.04861f
C53 vdd pfd_up 1.07208f
C54 a_14400_19930# a_13200_19930# 0.00585f
C55 vctrl pfd_dn 3.70147f
C56 cp_trim1 pll_en 0.0832f
C57 a_11400_12478# a_2800_20110# 0.02959f
C58 a_6000_12478# a_4200_12478# 0.00234f
C59 a_7200_12478# a_2800_20110# 0.02959f
C60 bias_ref a_10800_19930# 0.01034f
C61 a_13200_19930# a_12000_19930# 0.00585f
C62 vctrl pfd_up 0.14359f
C63 vctrl a_4200_12478# 0.00482f
C64 a_15000_12478# pll_en 0
C65 vdd cp_trim0 0.05536f
C66 cp_trim1 a_2800_20110# 3.23126f
C67 a_10200_12478# a_8400_12478# 0.00234f
C68 a_2000_12478# a_2800_20110# 0.04747f
C69 bias_ref pfd_dn 0.10304f
C70 a_12600_12478# pll_en 0.00109f
C71 a_13200_19930# vctrl 0.00289f
C72 vdd pll_en 3.2639f
C73 a_7800_18610# a_6600_18610# 0.00585f
C74 a_15000_12478# a_2800_20110# 0.02959f
C75 cp_trim0 vctrl 0.06417f
C76 a_14400_19930# a_2800_20110# 0.09186f
C77 a_13800_12478# pll_en 0
C78 bias_ref pfd_up 0.11322f
C79 a_12600_12478# a_2800_20110# 0.02959f
C80 a_2800_20110# a_1200_20110# 0.16254f
C81 vdd a_2800_20110# 30.4242f
C82 a_11400_12478# a_12600_12478# 0.00585f
C83 vctrl pll_en 5.25148f
C84 bias_ref a_13200_19930# 0
C85 a_7800_18610# a_2800_20110# 0.10189f
C86 a_2800_20110# a_12000_19930# 0.09187f
C87 a_6000_12478# a_2800_20110# 0.02959f
C88 a_13800_12478# a_2800_20110# 0.02959f
C89 vco_out vss 1.20719f
C90 bias_ref vss 13.8127f
C91 pll_en vss 9.23861f
C92 pfd_up vss 4.1408f
C93 vctrl vss 27.99254f
C94 cp_trim1 vss 5.82211f
C95 cp_trim0 vss 5.66925f
C96 pfd_dn vss 4.46581f
C97 vdd vss 0.49604p
C98 a_15000_12478# vss 0.67694f
C99 a_14400_19930# vss 0.68276f
C100 a_13800_12478# vss 0.66937f
C101 a_13200_19930# vss 0.67329f
C102 a_12600_12478# vss 0.66937f
C103 a_12000_19930# vss 0.67329f
C104 a_11400_12478# vss 0.66937f
C105 a_10800_19930# vss 0.67329f
C106 a_10200_12478# vss 0.67529f
C107 a_8400_12478# vss 0.67529f
C108 a_7800_18610# vss 0.66004f
C109 a_7200_12478# vss 0.66937f
C110 a_6600_18610# vss 0.66004f
C111 a_6000_12478# vss 0.68001f
C112 a_4200_12478# vss 0.68519f
C113 a_2000_12478# vss 1.08757f
C114 a_1200_20110# vss 1.08608f
C115 a_400_12478# vss 1.10395f
C116 a_570_27456.t3 vss 4.92743f
C117 a_570_27456.n0 vss 2.0917f
C118 a_570_27456.t1 vss 4.92743f
C119 a_570_27456.n1 vss 2.11514f
C120 a_570_27456.n2 vss 1.89159f
C121 a_570_27456.n3 vss 1.71514f
C122 a_570_27456.t4 vss 2.37513f
C123 a_570_27456.t5 vss 2.25231f
C124 a_570_27456.n4 vss 3.31634f
C125 a_570_27456.n5 vss 8.67163f
C126 a_570_27456.t6 vss 2.32392f
C127 a_570_27456.n6 vss 3.47292f
C128 a_1870_27516.t0 vss 6.521f
C129 a_1870_27516.t3 vss 6.48831f
C130 a_1870_27516.n0 vss 8.95777f
C131 a_1870_27516.t1 vss 1.22746f
C132 a_1870_27516.t2 vss 1.20626f
C133 a_1870_27516.n1 vss 8.67384f
C134 a_4610_27456.t0 vss 1.27285f
C135 a_4610_27456.t1 vss 0.49802f
C136 a_4610_27456.n0 vss 3.14759f
C137 a_4610_27456.n1 vss 3.53874f
C138 a_4610_27456.n2 vss 1.90572f
C139 a_4610_27456.n3 vss 1.83181f
C140 a_4610_27456.n4 vss 1.90572f
C141 a_4610_27456.n5 vss 1.88053f
C142 a_4610_27456.t3 vss 1.01007f
C143 a_4610_27456.n6 vss 1.80654f
C144 a_4610_27456.n7 vss 1.21616f
C145 a_4610_27456.n8 vss 1.93092f
C146 a_4610_27456.n9 vss 1.90572f
C147 a_4610_27456.n10 vss 1.83181f
C148 a_4610_27456.n11 vss 1.90572f
C149 a_4610_27456.n12 vss 1.90572f
C150 a_4610_27456.n13 vss 1.83181f
C151 a_4610_27456.n14 vss 5.58331f
C152 a_4610_27456.t4 vss 1.69642f
C153 a_4610_27456.n15 vss 9.11883f
C154 a_440_8178.t6 vss 1.42736f
C155 a_440_8178.t8 vss 1.10551f
C156 a_440_8178.t3 vss 1.42737f
C157 a_440_8178.n0 vss 0.82259f
C158 a_440_8178.t4 vss 1.42737f
C159 a_440_8178.n1 vss 0.48101f
C160 a_440_8178.t9 vss 1.07724f
C161 a_440_8178.n2 vss 0.56322f
C162 a_440_8178.t10 vss 1.07724f
C163 a_440_8178.n3 vss 0.56322f
C164 a_440_8178.t5 vss 1.42737f
C165 a_440_8178.n4 vss 0.48101f
C166 a_440_8178.t11 vss 1.07724f
C167 a_440_8178.n5 vss 9.63754f
C168 a_440_8178.t0 vss 2.85946f
C169 a_440_8178.t1 vss 2.62343f
C170 a_440_8178.n6 vss 4.67205f
C171 a_440_8178.t2 vss 2.62343f
C172 a_440_8178.n7 vss 3.22911f
C173 a_440_8178.t7 vss 2.62343f
C174 a_440_8178.n8 vss 10.0877f
C175 a_440_8178.n9 vss 0.48101f
C176 a_562_21822.t8 vss 1.77368f
C177 a_562_21822.n0 vss 1.08592f
C178 a_562_21822.t6 vss 1.77368f
C179 a_562_21822.n1 vss 1.10807f
C180 a_562_21822.n2 vss 1.00246f
C181 a_562_21822.n3 vss 0.85021f
C182 a_562_21822.n4 vss 0.85021f
C183 a_562_21822.n5 vss 0.78349f
C184 a_562_21822.t11 vss 0.60492f
C185 a_562_21822.n6 vss 0.65071f
C186 a_562_21822.t10 vss 0.60787f
C187 a_562_21822.n7 vss 0.52992f
C188 a_562_21822.t9 vss 0.58647f
C189 a_562_21822.n8 vss 0.70183f
C190 a_562_21822.t3 vss 0.43487f
C191 a_562_21822.n9 vss 4.10041f
C192 a_562_21822.t1 vss 2.16429f
C193 a_562_21822.t0 vss 2.03725f
C194 a_562_21822.n10 vss 2.64856f
C195 a_562_21822.t2 vss 2.03725f
C196 a_562_21822.n11 vss 1.78929f
C197 a_562_21822.t4 vss 2.03725f
C198 a_562_21822.n12 vss 4.13789f
C199 a_562_21822.n13 vss 0.40715f
C200 a_8332_21882.t2 vss 7.43339f
C201 a_8332_21882.t1 vss 3.69422f
C202 a_8332_21882.t0 vss 3.00508f
C203 a_8332_21882.n0 vss 13.7766f
C204 a_7792_21882.t1 vss 10.54563f
C205 a_7792_21882.t0 vss 12.36217f
C206 a_11206_4664.t0 vss 0.41071f
C207 a_11206_4664.t2 vss 1.07247f
C208 a_11206_4664.n0 vss 2.40389f
C209 a_11206_4664.t1 vss 9.99366f
C210 a_11206_4664.n1 vss 11.16f
C211 a_8872_21882.t1 vss 9.47115f
C212 a_8872_21882.t0 vss 11.13708f
C213 a_6000_18610.t0 vss 1.00008f
C214 a_6000_18610.n0 vss 1.23429f
C215 a_6000_18610.n1 vss 0.70365f
C216 a_6000_18610.n2 vss 0.65195f
C217 a_6000_18610.n3 vss 0.70365f
C218 a_6000_18610.n4 vss 0.62022f
C219 a_6000_18610.n5 vss 0.66799f
C220 a_6000_18610.n6 vss 0.856f
C221 a_6000_18610.t1 vss 0.36466f
C222 a_6000_18610.n7 vss 2.67976f
C223 a_6000_18610.n8 vss 2.52528f
C224 a_6000_18610.n9 vss 1.2831f
C225 a_6000_18610.n10 vss 2.58403f
C226 a_6000_18610.t2 vss 1.66614f
C227 a_6000_18610.n11 vss 6.68627f
C228 a_6000_18610.n12 vss 0.42347f
C229 a_2730_21882.t0 vss 2.44555f
C230 a_2730_21882.t1 vss 2.40248f
C231 a_2730_21882.n0 vss 0.98288f
C232 a_2730_21882.t2 vss 0.86827f
C233 a_2730_21882.n1 vss 1.40188f
C234 a_2730_21882.t3 vss 0.84444f
C235 a_7330_21822.t0 vss 7.86747f
C236 a_7330_21822.t1 vss 0.72995f
C237 a_7330_21822.n0 vss 13.5695f
C238 a_1246_4604.t7 vss 0.94921f
C239 a_1246_4604.n0 vss 0.98478f
C240 a_1246_4604.t5 vss 0.94921f
C241 a_1246_4604.n1 vss 1.01003f
C242 a_1246_4604.t0 vss 0.97672f
C243 a_1246_4604.n2 vss 1.14372f
C244 a_1246_4604.t1 vss 0.97672f
C245 a_1246_4604.n3 vss 4.66451f
C246 a_1246_4604.t16 vss 5.29216f
C247 a_1246_4604.t9 vss 0.95651f
C248 a_1246_4604.n4 vss 1.05104f
C249 a_1246_4604.t15 vss 0.95651f
C250 a_1246_4604.n5 vss 1.02472f
C251 a_1246_4604.n6 vss 1.16701f
C252 a_1246_4604.t13 vss 0.95651f
C253 a_1246_4604.n7 vss 1.02472f
C254 a_1246_4604.n8 vss 0.82262f
C255 a_1246_4604.t11 vss 0.95651f
C256 a_1246_4604.n9 vss 1.02472f
C257 a_1246_4604.n10 vss 0.8961f
C258 a_1246_4604.t2 vss 1.51642f
C259 a_1246_4604.n11 vss 1.0593f
C260 a_1246_4604.t3 vss 1.51642f
C261 a_1246_4604.n12 vss 2.11743f
C262 a_1246_4604.t17 vss 1.14652f
C263 a_1246_4604.n13 vss 3.12663f
C264 a_1246_4604.n14 vss 10.8514f
C265 a_1246_4604.n15 vss 1.21584f
C266 a_9050_21882.t0 vss 2.13462f
C267 a_9050_21882.t1 vss 2.13205f
C268 a_11586_22142.t0 vss 1.09316f
C269 a_11586_22142.n0 vss 3.83152f
C270 a_11586_22142.t1 vss 2.14227f
C271 a_11586_22142.n1 vss 7.58949f
C272 a_11586_22142.n2 vss 2.39222f
C273 a_11586_22142.n3 vss 1.44534f
C274 a_11586_22142.n4 vss 2.21794f
C275 a_11586_22142.n5 vss 6.72392f
C276 a_10570_21882.t0 vss 1.45207f
C277 a_10570_21882.n0 vss 13.2522f
C278 a_10570_21882.t1 vss 9.02289f
C279 a_4800_16110.t0 vss 3.55571f
C280 a_4800_16110.t4 vss 3.67712f
C281 a_4800_16110.t2 vss 3.55571f
C282 a_4800_16110.n0 vss 2.07549f
C283 a_4800_16110.t3 vss 3.55571f
C284 a_4800_16110.n1 vss 9.92918f
C285 a_4800_16110.t1 vss 6.1505f
C286 a_4800_16110.n2 vss 1.0786f
C287 a_4200_16110.t1 vss 1.34749f
C288 a_4200_16110.t2 vss 1.31232f
C289 a_4200_16110.n0 vss 11.688f
C290 a_4200_16110.t0 vss 7.46422f
C291 a_15776_2628.t6 vss 1.09276f
C292 a_15776_2628.t5 vss 1.06896f
C293 a_15776_2628.n0 vss 1.05394f
C294 a_15776_2628.n1 vss 2.47844f
C295 a_15776_2628.t1 vss 0.58387f
C296 a_15776_2628.n2 vss 0.97924f
C297 a_15776_2628.n3 vss 1.51463f
C298 a_15776_2628.n4 vss 1.05277f
C299 a_15776_2628.t3 vss 0.58387f
C300 a_15776_2628.n5 vss 0.9451f
C301 a_15776_2628.n6 vss 0.52634f
C302 a_15776_2628.t4 vss 0.56895f
C303 a_15776_2628.n7 vss 1.50992f
C304 a_15776_2628.n8 vss 0.42491f
C305 a_15776_2628.n9 vss 0.42308f
C306 a_15776_2628.n10 vss 0.20765f
C307 a_15776_2628.n11 vss 0.42308f
C308 a_15776_2628.n12 vss 0.22709f
C309 a_15776_2628.n13 vss 0.42308f
C310 a_15776_2628.n14 vss 0.35834f
C311 a_15776_2628.n15 vss 0.43896f
C312 a_15776_2628.n16 vss 1.27582f
C313 a_770_8178.t4 vss 0.7597f
C314 a_770_8178.t6 vss 0.83823f
C315 a_770_8178.t5 vss 0.7597f
C316 a_770_8178.n0 vss 0.56698f
C317 a_770_8178.t7 vss 0.7597f
C318 a_770_8178.n1 vss 1.19352f
C319 a_770_8178.t1 vss 0.41254f
C320 a_770_8178.n2 vss 0.68962f
C321 a_770_8178.n3 vss 1.02269f
C322 a_770_8178.n4 vss 0.69468f
C323 a_770_8178.t3 vss 0.41254f
C324 a_770_8178.n5 vss 0.65353f
C325 a_770_8178.n6 vss 0.99485f
C326 a_770_8178.n7 vss 0.92919f
C327 a_762_4664.t5 vss 0.73668f
C328 a_762_4664.t4 vss 0.812f
C329 a_762_4664.t1 vss 0.74663f
C330 a_762_4664.n0 vss 0.89125f
C331 a_762_4664.n1 vss 0.60244f
C332 a_762_4664.n2 vss 1.06398f
C333 a_762_4664.t3 vss 0.74663f
C334 a_762_4664.n3 vss 0.89816f
C335 a_762_4664.n4 vss 1.335f
C336 a_762_4664.n5 vss 2.30695f
C337 a_14782_4664.t1 vss 1.05198f
C338 a_14782_4664.t3 vss 1.07272f
C339 a_14782_4664.n0 vss 1.09001f
C340 a_14782_4664.t0 vss 0.40295f
C341 a_14782_4664.n1 vss 1.47943f
C342 a_14782_4664.t2 vss 2.73243f
C343 a_14782_4664.n2 vss 0.76872f
C344 a_15772_n1100.t1 vss 1.00541f
C345 a_15772_n1100.t2 vss 1.02117f
C346 a_15772_n1100.n0 vss 1.37178f
C347 a_15772_n1100.t4 vss 0.32873f
C348 a_15772_n1100.n1 vss 0.56567f
C349 a_15772_n1100.n2 vss 1.56212f
C350 a_15772_n1100.t0 vss 0.37668f
C351 a_15772_n1100.n3 vss 0.22993f
C352 a_15772_n1100.n4 vss 0.22981f
C353 a_15772_n1100.n5 vss 0.16577f
C354 a_15772_n1100.n6 vss 0.22981f
C355 a_15772_n1100.n7 vss 0.16773f
C356 a_15772_n1100.n8 vss 0.22981f
C357 a_15772_n1100.n9 vss 0.2647f
C358 a_15772_n1100.n10 vss 0.24154f
C359 a_15772_n1100.n11 vss 1.11927f
C360 a_15772_n1100.n12 vss 1.06256f
C361 a_440_4664.t0 vss 1.01926f
C362 a_440_4664.t5 vss 0.68774f
C363 a_440_4664.t3 vss 1.01926f
C364 a_440_4664.n0 vss 0.48797f
C365 a_440_4664.t6 vss 0.66959f
C366 a_440_4664.n1 vss 0.95612f
C367 a_440_4664.t2 vss 0.71431f
C368 a_440_4664.n2 vss 1.11513f
C369 a_440_4664.t4 vss 0.71431f
C370 a_440_4664.n3 vss 0.56847f
C371 a_440_4664.t7 vss 0.71431f
C372 a_440_4664.n4 vss 0.90737f
C373 a_440_4664.t1 vss 0.75066f
C374 a_440_4664.n5 vss 0.28538f
C375 a_8114_4664.t3 vss 1.07939f
C376 a_8114_4664.t0 vss 2.17145f
C377 a_8114_4664.t1 vss 1.01718f
C378 a_8114_4664.n0 vss 3.74881f
C379 a_8114_4664.t2 vss 1.01718f
C380 a_8114_4664.n1 vss 0.46626f
C381 a_8114_4664.t4 vss 1.10146f
C382 a_8114_4664.n2 vss 0.82593f
C383 a_15646_1524.t2 vss 0.30435f
C384 a_15646_1524.t1 vss 0.2343f
C385 a_15646_1524.t0 vss 0.23397f
C386 a_15646_1524.n0 vss 0.29304f
C387 a_15646_1524.n1 vss 0.40745f
C388 a_15646_1524.t3 vss 0.30238f
C389 a_16450_1524.t1 vss 0.33579f
C390 a_16450_1524.t3 vss 0.24207f
C391 a_16450_1524.t2 vss 0.24174f
C392 a_16450_1524.n0 vss 0.32741f
C393 a_16450_1524.n1 vss 0.45524f
C394 a_16450_1524.t0 vss 0.33799f
C395 a_17254_1524.t1 vss 0.32777f
C396 a_17254_1524.t3 vss 0.23946f
C397 a_17254_1524.t2 vss 0.23912f
C398 a_17254_1524.n0 vss 0.31583f
C399 a_17254_1524.n1 vss 0.43914f
C400 a_17254_1524.t0 vss 0.3299f
C401 a_18058_1524.t1 vss 0.3228f
C402 a_18058_1524.t3 vss 0.23878f
C403 a_18058_1524.t2 vss 0.23845f
C404 a_18058_1524.n0 vss 0.31286f
C405 a_18058_1524.n1 vss 0.43502f
C406 a_18058_1524.t0 vss 0.32491f
C407 a_18862_1524.t2 vss 0.33076f
C408 a_18862_1524.t1 vss 0.2394f
C409 a_18862_1524.t0 vss 0.23907f
C410 a_18862_1524.n0 vss 0.31559f
C411 a_18862_1524.n1 vss 0.43881f
C412 a_18862_1524.t3 vss 0.32862f
C413 a_15764_360.t2 vss 0.10727f
C414 a_15764_360.n0 vss 0.21433f
C415 a_15764_360.n1 vss 0.36862f
C416 a_15764_360.n2 vss 0.22951f
C417 a_15764_360.n3 vss 0.19363f
C418 a_15764_360.n4 vss 0.27059f
C419 a_15764_360.t0 vss 0.06072f
C420 a_15764_360.t1 vss 0.06058f
C421 a_15764_360.n5 vss 0.08618f
C422 a_15764_360.t3 vss 0.10739f
C423 a_16568_360.t2 vss 0.11059f
C424 a_16568_360.n0 vss 0.23117f
C425 a_16568_360.n1 vss 0.48102f
C426 a_16568_360.n2 vss 0.24754f
C427 a_16568_360.n3 vss 0.20884f
C428 a_16568_360.n4 vss 0.3752f
C429 a_16568_360.t0 vss 0.06231f
C430 a_16568_360.t1 vss 0.06216f
C431 a_16568_360.n5 vss 0.09295f
C432 a_16568_360.t3 vss 0.11071f
C433 a_15828_0.t2 vss 0.10875f
C434 a_15828_0.n0 vss 0.23118f
C435 a_15828_0.n1 vss 0.58522f
C436 a_15828_0.n2 vss 0.24948f
C437 a_15828_0.n3 vss 0.222f
C438 a_15828_0.n4 vss 0.47475f
C439 a_15828_0.t1 vss 0.06095f
C440 a_15828_0.t0 vss 0.06081f
C441 a_15828_0.n5 vss 0.10198f
C442 a_15828_0.t3 vss 0.10886f
C443 a_18176_360.t0 vss 0.11351f
C444 a_18176_360.n0 vss 0.22163f
C445 a_18176_360.n1 vss 0.33986f
C446 a_18176_360.n2 vss 0.23917f
C447 a_18176_360.n3 vss 0.21283f
C448 a_18176_360.n4 vss 0.2396f
C449 a_18176_360.n5 vss 0.22497f
C450 a_18176_360.n6 vss 0.21955f
C451 a_18176_360.n7 vss 0.35086f
C452 a_18176_360.n8 vss 0.45543f
C453 a_18176_360.t2 vss 0.0642f
C454 a_18176_360.t3 vss 0.06405f
C455 a_18176_360.n9 vss 0.09776f
C456 a_18176_360.t1 vss 0.11364f
C457 a_17436_0.t0 vss 0.11575f
C458 a_17436_0.n0 vss 0.22916f
C459 a_17436_0.n1 vss 0.59469f
C460 a_17436_0.n2 vss 0.2497f
C461 a_17436_0.n3 vss 0.23406f
C462 a_17436_0.n4 vss 0.47942f
C463 a_17436_0.t3 vss 0.06519f
C464 a_17436_0.t2 vss 0.06504f
C465 a_17436_0.n5 vss 0.11098f
C466 a_17436_0.t1 vss 0.11588f
C467 a_19972_1724.t5 vss 0.09765f
C468 a_19972_1724.n0 vss 0.22771f
C469 a_19972_1724.t1 vss 0.08045f
C470 a_19972_1724.t0 vss 0.08031f
C471 a_19972_1724.n1 vss 0.14407f
C472 a_19972_1724.t3 vss 0.08025f
C473 a_19972_1724.t2 vss 0.08012f
C474 a_19972_1724.n2 vss 0.15358f
C475 a_19972_1724.n3 vss 0.37858f
C476 a_19972_1724.n4 vss 0.42058f
C477 a_19972_1724.n5 vss 0.25017f
C478 a_19972_1724.n6 vss 0.25457f
C479 a_19972_1724.n7 vss 0.19071f
C480 a_19972_1724.n8 vss 0.36236f
C481 a_19972_1724.n9 vss 0.30031f
C482 a_19972_1724.t4 vss 0.09783f
C483 a_15650_0.t0 vss 0.08736f
C484 a_15650_0.t1 vss 0.08813f
C485 a_15650_0.t3 vss 0.0766f
C486 a_15650_0.t2 vss 0.07633f
C487 a_15650_0.n0 vss 0.05232f
C488 a_15650_0.n1 vss 0.19835f
C489 a_16454_0.t0 vss 0.11331f
C490 a_16454_0.t3 vss 0.11227f
C491 a_16454_0.t2 vss 0.0824f
C492 a_16454_0.t1 vss 0.08214f
C493 a_16454_0.n0 vss 0.07379f
C494 a_16454_0.n1 vss 0.27974f
C495 a_17258_0.t0 vss 0.0815f
C496 a_17258_0.n0 vss 0.07144f
C497 a_17258_0.t1 vss 0.11097f
C498 a_17258_0.t2 vss 0.11198f
C499 a_17258_0.n1 vss 0.27084f
C500 a_17258_0.t3 vss 0.08177f
C501 a_18062_0.t0 vss 0.10831f
C502 a_18062_0.t1 vss 0.10931f
C503 a_18062_0.t3 vss 0.08147f
C504 a_18062_0.t2 vss 0.08121f
C505 a_18062_0.n0 vss 0.07035f
C506 a_18062_0.n1 vss 0.2667f
C507 a_18866_0.t0 vss 0.08009f
C508 a_18866_0.n0 vss 0.06623f
C509 a_18866_0.t2 vss 0.1062f
C510 a_18866_0.t3 vss 0.10715f
C511 a_18866_0.n1 vss 0.25107f
C512 a_18866_0.t1 vss 0.08036f
C513 a_19968_0.t2 vss 0.07001f
C514 a_19968_0.n0 vss 0.04071f
C515 a_19968_0.t0 vss 0.1008f
C516 a_19968_0.t1 vss 0.09852f
C517 a_19968_0.n1 vss 0.16601f
C518 a_19968_0.t3 vss 0.06983f
C519 vss.t35 vss 0.29709f
C520 vss.t56 vss 0.43699f
C521 vss.t13 vss 0.43699f
C522 vss.t15 vss 0.29709f
C523 vss.t45 vss 0.43545f
C524 vss.t47 vss 0.42203f
C525 vss.t84 vss 0.42203f
C526 vss.t74 vss 0.42203f
C527 vss.t98 vss 0.42203f
C528 vss.t27 vss 0.42203f
C529 vss.t121 vss 0.32977f
C530 vss.t72 vss 0.32977f
C531 vss.t58 vss 0.31233f
C532 vss.t66 vss 0.14048f
C533 vss.t90 vss 0.13273f
C534 vss.t41 vss 0.13273f
C535 vss.t43 vss 0.10363f
C536 vss.t18 vss 0.13273f
C537 vss.t112 vss 0.95536f
C538 vss.t1 vss 1.06614f
C539 vss.t52 vss 1.06614f
C540 vss.t61 vss 1.06614f
C541 vss.t78 vss 1.06614f
C542 vss.t76 vss 0.95536f
C543 vss.t123 vss 2.09881f
C544 vss.t115 vss 0.16927f
C545 vss.t33 vss 0.19732f
C546 vss.t136 vss 1.4677f
C547 vss.t118 vss 1.20776f
C548 vss.t49 vss 1.18284f
C549 vss.t3 vss 1.18284f
C550 vss.t108 vss 1.18284f
C551 vss.t63 vss 76.2313f
C552 vss.t106 vss 0.0601f
C553 vss.t127 vss 0.06023f
C554 vss.t140 vss 0.05952f
C555 vss.t142 vss 0.05971f
C556 vss.t54 vss 0.06219f
C557 vss.t68 vss 0.06245f
C558 vss.t11 vss 0.06219f
C559 vss.t21 vss 0.06245f
C560 vss.t23 vss 0.06219f
C561 vss.t80 vss 0.06245f
C562 vss.t82 vss 0.06219f
C563 vss.t86 vss 0.06245f
C564 vss.t88 vss 0.06219f
C565 vss.t125 vss 0.06245f
C566 vss.t95 vss 65.9619f
C567 vdd.t96 vss 3.04366f
C568 vdd.n0 vss 2.52167f
C569 vdd.t31 vss 3.17677f
C570 vdd.n1 vss 0.09633f
C571 vdd.t120 vss 3.17677f
C572 vdd.n2 vss 0.09791f
C573 vdd.n3 vss 0.27953f
C574 vdd.t42 vss 3.04366f
C575 vdd.n4 vss 0.08138f
C576 vdd.t23 vss 1.31389f
C577 vdd.n5 vss 0.21404f
C578 vdd.t36 vss 1.28336f
C579 vdd.n6 vss 0.21561f
C580 vdd.n7 vss 0.27953f
C581 vdd.t62 vss 1.28336f
C582 vdd.n8 vss 0.19908f
C583 vdd.t25 vss 1.28336f
C584 vdd.n9 vss 0.21404f
C585 vdd.t57 vss 1.28336f
C586 vdd.n10 vss 0.21561f
C587 vdd.n11 vss 0.27953f
C588 vdd.t40 vss 1.28336f
C589 vdd.n12 vss 0.19908f
C590 vdd.t60 vss 0.8926f
C591 vdd.n13 vss 0.21404f
C592 vdd.t66 vss 1.28336f
C593 vdd.n14 vss 0.21561f
C594 vdd.n15 vss 0.27953f
C595 vdd.t29 vss 1.28336f
C596 vdd.n16 vss 0.19908f
C597 vdd.t55 vss 1.28336f
C598 vdd.n17 vss 0.21404f
C599 vdd.t38 vss 1.28336f
C600 vdd.n18 vss 0.21561f
C601 vdd.n19 vss 0.27953f
C602 vdd.t64 vss 1.28336f
C603 vdd.n20 vss 0.19908f
C604 vdd.t86 vss 1.28336f
C605 vdd.n21 vss 0.21404f
C606 vdd.t68 vss 1.28336f
C607 vdd.n22 vss 0.21561f
C608 vdd.n23 vss 2.73817f
C609 vdd.n24 vss 2.73817f
C610 vdd.n25 vss 2.73817f
C611 vdd.n26 vss 2.73817f
C612 vdd.n27 vss 2.73817f
C613 vdd.t22 vss 3.52554f
C614 vdd.t24 vss 3.52554f
C615 vdd.t28 vss 3.07506f
C616 vdd.t30 vss 3.52554f
C617 vdd.t35 vss 3.07506f
C618 vdd.t37 vss 3.07506f
C619 vdd.t39 vss 3.07506f
C620 vdd.t41 vss 3.07506f
C621 vdd.t54 vss 3.52554f
C622 vdd.t56 vss 3.07506f
C623 vdd.t59 vss 3.52554f
C624 vdd.t61 vss 3.07506f
C625 vdd.t63 vss 3.07506f
C626 vdd.t65 vss 3.07506f
C627 vdd.t67 vss 3.56129f
C628 vdd.t85 vss 3.52554f
C629 vdd.t95 vss 3.56826f
C630 vdd.t119 vss 3.07506f
C631 vdd.n28 vss 3.25073f
C632 vdd.n29 vss 1.05125f
C633 vdd.n30 vss 0.18234f
C634 vdd.t3 vss 0.61367f
C635 vdd.n31 vss 0.0728f
C636 vdd.t90 vss 0.74713f
C637 vdd.n32 vss 0.08776f
C638 vdd.t1 vss 0.74713f
C639 vdd.n33 vss 0.08933f
C640 vdd.n34 vss 0.11581f
C641 vdd.t94 vss 0.61367f
C642 vdd.n35 vss 0.0728f
C643 vdd.t98 vss 0.3276f
C644 vdd.n36 vss 0.0925f
C645 vdd.t92 vss 0.54356f
C646 vdd.n37 vss 0.08249f
C647 vdd.t106 vss 0.17974f
C648 vdd.n38 vss 0.09522f
C649 vdd.t108 vss 0.17199f
C650 vdd.n39 vss 0.09679f
C651 vdd.n40 vss 0.1058f
C652 vdd.t110 vss 0.19907f
C653 vdd.n41 vss 0.07754f
C654 vdd.t88 vss 2.05387f
C655 vdd.n42 vss 0.11507f
C656 vdd.n43 vss 0.16663f
C657 vdd.t10 vss 0.31825f
C658 vdd.n44 vss 0.09266f
C659 vdd.t17 vss 0.37076f
C660 vdd.n45 vss 0.06396f
C661 vdd.t15 vss 0.37076f
C662 vdd.n46 vss 0.06553f
C663 vdd.n47 vss 0.10708f
C664 vdd.t118 vss 0.31825f
C665 vdd.n48 vss 0.05773f
C666 vdd.t112 vss 0.17276f
C667 vdd.n49 vss 0.09807f
C668 vdd.n50 vss 0.61845f
C669 vdd.n51 vss 0.6688f
C670 vdd.n52 vss 0.71915f
C671 vdd.n53 vss 0.54595f
C672 vdd.n54 vss 1.04641f
C673 vdd.n55 vss 0.56811f
C674 vdd.t0 vss 0.79047f
C675 vdd.t2 vss 0.79047f
C676 vdd.t4 vss 0.70487f
C677 vdd.t9 vss 0.60418f
C678 vdd.t13 vss 0.70487f
C679 vdd.t14 vss 0.5639f
C680 vdd.t16 vss 0.60418f
C681 vdd.t26 vss 0.5639f
C682 vdd.t58 vss 0.70487f
C683 vdd.t73 vss 0.68071f
C684 vdd.t74 vss 0.63942f
C685 vdd.t75 vss 0.63942f
C686 vdd.t76 vss 0.63942f
C687 vdd.t87 vss 1.50944f
C688 vdd.t89 vss 0.90627f
C689 vdd.t91 vss 0.55987f
C690 vdd.t93 vss 0.70387f
C691 vdd.t97 vss 0.64647f
C692 vdd.t99 vss 0.60418f
C693 vdd.t104 vss 0.70487f
C694 vdd.t105 vss 0.55987f
C695 vdd.t107 vss 0.53067f
C696 vdd.t109 vss 1.02006f
C697 vdd.t111 vss 0.57898f
C698 vdd.t117 vss 0.55282f
C699 vdd.n56 vss 0.80962f
C700 vdd.n57 vss 0.30189f
C701 vdd.t69 vss 0.71364f
C702 vdd.n58 vss 0.0404f
C703 vdd.n59 vss 0.0862f
C704 vdd.n60 vss 0.0404f
C705 vdd.n61 vss 0.18824f
C706 vdd.n62 vss 0.03655f
C707 vdd.n63 vss 0.18824f
C708 vdd.n64 vss 0.03655f
C709 vdd.t5 vss 0.82936f
C710 vdd.t7 vss 0.17369f
C711 vdd.t11 vss 0.88797f
C712 vdd.t18 vss 0.69909f
C713 vdd.t20 vss 0.17369f
C714 vdd.t27 vss 0.21277f
C715 vdd.t32 vss 0.22145f
C716 vdd.t33 vss 0.72773f
C717 vdd.t34 vss 0.22145f
C718 vdd.t43 vss 0.90751f
C719 vdd.t45 vss 0.90751f
C720 vdd.t47 vss 0.22145f
C721 vdd.t48 vss 0.65133f
C722 vdd.t49 vss 0.90751f
C723 vdd.t51 vss 0.75337f
C724 vdd.t53 vss 0.65133f
C725 vdd.t71 vss 0.17369f
C726 vdd.t77 vss 0.63613f
C727 vdd.t79 vss 0.17369f
C728 vdd.t81 vss 0.69909f
C729 vdd.t83 vss 0.17369f
C730 vdd.t100 vss 1.76292f
C731 vdd.t102 vss 0.22145f
C732 vdd.t103 vss 0.65133f
C733 vdd.t113 vss 0.85541f
C734 vdd.t115 vss 0.80981f
C735 vdd.t121 vss 0.65133f
C736 vdd.t21 vss 0.26283f
C737 vdd.n65 vss 0.10289f
C738 vdd.t19 vss 0.2625f
C739 vdd.n66 vss 0.0994f
C740 vdd.t72 vss 0.26283f
C741 vdd.n67 vss 0.09355f
C742 vdd.t70 vss 0.2625f
C743 vdd.n68 vss 0.08464f
C744 vdd.t84 vss 0.26283f
C745 vdd.n69 vss 0.0994f
C746 vdd.t82 vss 0.2625f
C747 vdd.n70 vss 0.0994f
C748 vdd.t80 vss 0.26283f
C749 vdd.n71 vss 0.0932f
C750 vdd.t78 vss 0.2625f
C751 vdd.n72 vss 0.08499f
C752 vdd.t8 vss 0.26283f
C753 vdd.n73 vss 0.0994f
C754 vdd.t6 vss 0.2625f
C755 vdd.n74 vss 0.10464f
C756 vdd.t114 vss 0.11912f
C757 vdd.n75 vss 0.1289f
C758 vdd.t116 vss 0.11893f
C759 vdd.n76 vss 0.12803f
C760 vdd.t46 vss 0.10174f
C761 vdd.n77 vss 0.13685f
C762 vdd.t44 vss 0.1016f
C763 vdd.n78 vss 0.13685f
C764 vdd.t52 vss 0.14977f
C765 vdd.n79 vss 0.12561f
C766 vdd.t12 vss 0.14964f
C767 vdd.n80 vss 0.13102f
C768 vdd.t50 vss 0.14977f
C769 vdd.n81 vss 0.28452f
C770 vdd.t101 vss 0.15894f
C771 vdd.n82 vss 1.45381f
C772 vdd.n83 vss 1.41802f
C773 pfd_dn.n0 vss 11.9824f
C774 pfd_dn.n1 vss 11.3249f
C775 cp_trim0.n0 vss 9.24656f
C776 cp_trim1.n0 vss 8.97157f
C777 vctrl.t0 vss 1.02421f
C778 vctrl.t2 vss 0.62027f
C779 vctrl.n0 vss 2.04283f
C780 vctrl.n1 vss 0.36151f
C781 vctrl.n2 vss 0.20246f
C782 vctrl.n3 vss 0.20619f
C783 vctrl.t1 vss 0.39558f
C784 vctrl.n4 vss 0.57601f
C785 vctrl.n5 vss 0.38964f
C786 vctrl.n6 vss 0.52536f
C787 vctrl.n7 vss 0.89142f
C788 vctrl.n8 vss 0.69162f
C789 vctrl.n9 vss 0.12766f
C790 vctrl.n10 vss 0.5164f
C791 pfd_up.n0 vss 5.19067f
C792 pfd_up.n1 vss 11.4847f
C793 pll_en.n0 vss 1.88227f
C794 pll_en.n1 vss 2.40763f
C795 pll_en.n2 vss 2.6176f
C796 pll_en.n3 vss 2.47808f
C797 pll_en.n4 vss 9.3545f
C798 pll_en.n5 vss 2.02569f
C799 pll_en.n6 vss 2.46459f
C800 pll_en.n7 vss 0.32691f
C801 pll_en.n8 vss 0.30151f
C802 pll_en.n9 vss 0.39843f
C803 bias_ref.t1 vss 0.37251f
C804 bias_ref.t0 vss 0.214f
C805 bias_ref.n0 vss 7.65986f
C806 vco_out.t1 vss 0.11358f
C807 vco_out.t5 vss 0.11345f
C808 vco_out.n0 vss 0.2848f
C809 vco_out.n1 vss 0.70577f
C810 vco_out.t2 vss 0.11358f
C811 vco_out.t0 vss 0.11345f
C812 vco_out.n2 vss 0.22089f
C813 vco_out.t4 vss 0.11341f
C814 vco_out.t3 vss 0.11328f
C815 vco_out.n3 vss 0.21595f
C816 vco_out.n4 vss 0.31208f
.ends
