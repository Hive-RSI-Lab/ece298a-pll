* NGSPICE file created from pll_analog.ext - technology: gf180mcuD

.subckt pll_analog vco_out pfd_up pfd_dn pll_en cp_trim0 cp_trim1 vctrl bias_ref vdd vss
X0 t2.t1 vbp.t9 vdd.t34 vdd.t33 pfet_03v3 ad=2.6p pd=9.3u as=2.6p ps=9.3u w=4u l=2u
X1 vbl.t3 vbl.t2 vss.t8 vss.t7 nfet_03v3 ad=1.22p pd=5.22u as=1.22p ps=5.22u w=2u l=2u
X2 vst.t3 vref.t3 vss.t110 vss.t109 nfet_03v3 ad=3.05p pd=11.22u as=3.05p ps=11.22u w=5u l=1u
X3 a_20880_0.t1 vbn_vco.t6 vss.t73 vss.t72 nfet_03v3 ad=0.52p pd=2.52u as=1.22p ps=5.22u w=2u l=0.5u
X4 vcp_n.t2 vbp.t16 vdd.t44 vdd.t43 pfet_03v3 ad=2.6p pd=9.3u as=2.6p ps=9.3u w=4u l=2u
X5 a_12000_19550# a_11400_12098# vss.t14 ppolyf_u r_width=1u r_length=36.6u
X6 vnt.t2 vref.t6 vss.t12 vss.t11 nfet_03v3 ad=1.22p pd=5.22u as=1.22p ps=5.22u w=2u l=2u
X7 vdd.t116 pll_en.t2 nb.t5 vdd.t115 pfet_03v3 ad=1.3p pd=5.3u as=0.52p ps=2.52u w=2u l=0.28u
X8 a_20192_1144.t1 r5.t10 r1.t1 vdd.t77 pfet_03v3 ad=1.95p pd=7.3u as=0.78p ps=3.52u w=3u l=0.28u
X9 a_1200_19730# a_2000_12098# vss.t0 ppolyf_u r_width=2u r_length=37.5u
X10 vst.t0 en_b.t5 vss.t18 vss.t17 nfet_03v3 ad=0.61p pd=3.22u as=0.61p ps=3.22u w=1u l=0.28u
X11 vdump.t13 vdump.t12 vnt.t7 vss.t139 nfet_03v3 ad=3.05p pd=11.22u as=3.05p ps=11.22u w=5u l=1u
X12 vbl.t5 vctrl.t10 vbt.t2 vdd.t20 pfet_03v3 ad=3.25p pd=11.3u as=3.25p ps=11.3u w=5u l=1u
X13 vss.t142 vbn_vco.t7 a_20196_0.t3 vss.t141 nfet_03v3 ad=1.22p pd=5.22u as=0.52p ps=2.52u w=2u l=0.5u
X14 a_21564_n100.t2 pll_en.t1 vss.t136 vss.t135 nfet_03v3 ad=0.52p pd=2.52u as=1.22p ps=5.22u w=2u l=0.28u
X15 r1.t0 r5.t11 a_20192_1144.t0 vdd.t95 pfet_03v3 ad=0.78p pd=3.52u as=1.95p ps=7.3u w=3u l=0.28u
X16 vctrl.t2 up_b.t2 up_s.t1 vdd.t89 pfet_03v3 ad=2.6p pd=9.3u as=2.6p ps=9.3u w=4u l=0.5u
X17 vdump.t5 vdump.t4 vbt.t5 vdd.t5 pfet_03v3 ad=3.25p pd=11.3u as=3.25p ps=11.3u w=5u l=1u
X18 vctrl.t1 pfd_dn.t2 dn_s.t2 vss.t114 nfet_03v3 ad=1.22p pd=5.22u as=1.22p ps=5.22u w=2u l=0.5u
X19 vcp_n.t4 vbp.t8 vdd.t52 vdd.t51 pfet_03v3 ad=2.6p pd=9.3u as=2.6p ps=9.3u w=4u l=2u
X20 vdd.t24 vbp_vco.t7 a_20876_1144.t0 vdd.t23 pfet_03v3 ad=3.25p pd=11.3u as=1.3p ps=5.52u w=5u l=0.5u
X21 vdump.t1 vbl.t8 vss.t102 vss.t101 nfet_03v3 ad=1.22p pd=5.22u as=1.22p ps=5.22u w=2u l=2u
X22 vss.t95 vbn_vco.t13 a_18144_0.t1 vss.t94 nfet_03v3 ad=1.22p pd=5.22u as=0.52p ps=2.52u w=2u l=0.5u
X23 vbn_vco.t0 en_b.t2 vss.t40 vss.t39 nfet_03v3 ad=0.61p pd=3.22u as=0.61p ps=3.22u w=1u l=0.28u
X24 vcp_p.t4 vcp_n.t15 vss.t42 vss.t41 nfet_03v3 ad=6.1p pd=21.22u as=6.1p ps=21.22u w=10u l=2u
X25 vdump.t16 dn_b.t2 dn_s.t1 vss.t66 nfet_03v3 ad=1.22p pd=5.22u as=1.22p ps=5.22u w=2u l=0.5u
X26 vctrl.t3 vss.t37 cap_mim_2f0_m4m5_noshield c_width=32u c_length=32u
X27 vdump.t15 vdump.t14 vnt.t6 vss.t89 nfet_03v3 ad=3.05p pd=11.22u as=3.05p ps=11.22u w=5u l=1u
X28 a_20192_1144.t3 vbp_vco.t10 vdd.t104 vdd.t103 pfet_03v3 ad=1.3p pd=5.52u as=3.25p ps=11.3u w=5u l=0.5u
X29 a_7800_18230# a_7200_12098# vss.t25 ppolyf_u r_width=1u r_length=30u
X30 a_18828_0.t3 vbn_vco.t12 vss.t93 vss.t92 nfet_03v3 ad=0.52p pd=2.52u as=1.22p ps=5.22u w=2u l=0.5u
X31 en_b.t1 pll_en.t7 vdd.t114 vdd.t113 pfet_03v3 ad=1.3p pd=5.3u as=1.3p ps=5.3u w=2u l=0.28u
X32 vbh.t4 vctrl.t7 vnt.t3 vss.t33 nfet_03v3 ad=3.05p pd=11.22u as=3.05p ps=11.22u w=5u l=1u
X33 vi.t2 vctrl.t4 vs.t2 vss.t36 nfet_03v3 ad=3.05p pd=11.22u as=3.05p ps=11.22u w=5u l=1u
X34 vdd.t54 nb.t8 vco_out.t1 vdd.t53 pfet_03v3 ad=1.95p pd=7.3u as=0.78p ps=3.52u w=3u l=0.28u
X35 vdd.t2 vbp_vco.t15 a_18140_1144.t0 vdd.t1 pfet_03v3 ad=3.25p pd=11.3u as=1.3p ps=5.52u w=5u l=0.5u
X36 en_b.t0 pll_en.t10 vss.t132 vss.t131 nfet_03v3 ad=0.61p pd=3.22u as=0.61p ps=3.22u w=1u l=0.28u
X37 a_20876_1144.t3 r4.t6 r5.t3 vdd.t92 pfet_03v3 ad=1.95p pd=7.3u as=0.78p ps=3.52u w=3u l=0.28u
X38 vnt.t0 vref.t8 vss.t4 vss.t3 nfet_03v3 ad=1.22p pd=5.22u as=1.22p ps=5.22u w=2u l=2u
X39 r3.t2 r2.t5 a_18144_0.t3 vss.t145 nfet_03v3 ad=0.39p pd=2.02u as=0.915p ps=4.22u w=1.5u l=0.28u
X40 a_13200_19550# a_13800_12098# vss.t28 ppolyf_u r_width=1u r_length=36.6u
X41 a_21564_n100.t1 r5.t4 nb.t3 vss.t128 nfet_03v3 ad=1.22p pd=5.22u as=0.52p ps=2.52u w=2u l=0.28u
X42 vcl.t3 a_4200_12098# vss.t67 ppolyf_u r_width=1u r_length=17.5u
X43 vbp.t2 pll_en.t8 vdd.t112 vdd.t111 pfet_03v3 ad=0.65p pd=3.3u as=0.65p ps=3.3u w=1u l=0.28u
X44 vbl.t4 vctrl.t9 vbt.t3 vdd.t21 pfet_03v3 ad=3.25p pd=11.3u as=3.25p ps=11.3u w=5u l=1u
X45 dn_s.t3 vcp_n.t14 vss.t119 vss.t118 nfet_03v3 ad=6.1p pd=21.22u as=6.1p ps=21.22u w=10u l=2u
X46 r5.t2 r4.t7 a_20876_1144.t2 vdd.t0 pfet_03v3 ad=0.78p pd=3.52u as=1.95p ps=7.3u w=3u l=0.28u
X47 vbp.t0 vst.t4 vss.t125 vss.t124 nfet_03v3 ad=0.305p pd=2.22u as=0.305p ps=2.22u w=0.5u l=4u
X48 vcl.t0 vref.t11 vss.t16 vss.t15 nfet_03v3 ad=6.1p pd=21.22u as=6.1p ps=21.22u w=10u l=2u
X49 vst.t2 en_b.t6 vdd.t37 vdd.t36 pfet_03v3 ad=0.325p pd=2.3u as=0.325p ps=2.3u w=0.5u l=10u
X50 dn_s.t0 vcp_n.t13 vss.t77 vss.t76 nfet_03v3 ad=6.1p pd=21.22u as=6.1p ps=21.22u w=10u l=2u
X51 vfilt a_2000_12098# vss.t87 ppolyf_u r_width=2u r_length=37.5u
X52 vbp.t1 va.t3 vref.t1 vss.t32 nfet_03v3 ad=2.44p pd=9.22u as=2.44p ps=9.22u w=4u l=1u
X53 nb.t4 pll_en.t3 vdd.t120 vdd.t119 pfet_03v3 ad=0.52p pd=2.52u as=1.3p ps=5.3u w=2u l=0.28u
X54 vref.t0 en_b.t3 vss.t121 vss.t120 nfet_03v3 ad=0.61p pd=3.22u as=0.61p ps=3.22u w=1u l=0.28u
X55 a_10800_19550# a_10200_12098# vss.t140 ppolyf_u r_width=1u r_length=36.6u
X56 a_18140_1144.t3 r2.t6 r3.t3 vdd.t121 pfet_03v3 ad=1.95p pd=7.3u as=0.78p ps=3.52u w=3u l=0.28u
X57 vss.t100 vbn_vco.t9 a_19512_0.t1 vss.t99 nfet_03v3 ad=1.22p pd=5.22u as=0.52p ps=2.52u w=2u l=0.5u
X58 vcp_n.t7 cp_trim1.t1 t2.t2 vss.t107 nfet_03v3 ad=1.22p pd=5.22u as=1.22p ps=5.22u w=2u l=0.28u
X59 vdd.t48 r5.t8 nb.t1 vdd.t47 pfet_03v3 ad=1.3p pd=5.3u as=0.52p ps=2.52u w=2u l=0.28u
X60 vbn_vco.t4 vbp_vco.t18 vdd.t70 vdd.t69 pfet_03v3 ad=3.25p pd=11.3u as=3.25p ps=11.3u w=5u l=0.5u
X61 vss.t31 a_15000_12098# vss.t30 ppolyf_u r_width=1u r_length=36.6u
X62 r2.t1 r1.t5 a_18828_0.t1 vss.t54 nfet_03v3 ad=0.39p pd=2.02u as=0.915p ps=4.22u w=1.5u l=0.28u
X63 vbh.t5 vctrl.t6 vnt.t4 vss.t34 nfet_03v3 ad=3.05p pd=11.22u as=3.05p ps=11.22u w=5u l=1u
X64 a_6600_18230# a_6000_12098# vss.t26 ppolyf_u r_width=1u r_length=30u
X65 a_19512_0.t2 r3.t4 r4.t2 vss.t129 nfet_03v3 ad=0.915p pd=4.22u as=0.39p ps=2.02u w=1.5u l=0.28u
X66 a_20876_1144.t1 vbp_vco.t8 vdd.t26 vdd.t25 pfet_03v3 ad=1.3p pd=5.52u as=3.25p ps=11.3u w=5u l=0.5u
X67 vbp_vco.t6 pll_en.t6 vdd.t118 vdd.t117 pfet_03v3 ad=0.65p pd=3.3u as=0.65p ps=3.3u w=1u l=0.28u
X68 up_b.t0 pfd_up.t2 vss.t84 vss.t83 nfet_03v3 ad=0.61p pd=3.22u as=0.61p ps=3.22u w=1u l=0.28u
X69 dn_b.t1 pfd_dn.t0 vdd.t94 vdd.t93 pfet_03v3 ad=1.3p pd=5.3u as=1.3p ps=5.3u w=2u l=0.28u
X70 vdump.t7 vdump.t6 vbt.t6 vdd.t100 pfet_03v3 ad=3.25p pd=11.3u as=3.25p ps=11.3u w=5u l=1u
X71 vdump.t0 vbl.t9 vss.t104 vss.t103 nfet_03v3 ad=1.22p pd=5.22u as=1.22p ps=5.22u w=2u l=2u
X72 r4.t3 r3.t5 a_19512_0.t3 vss.t130 nfet_03v3 ad=0.39p pd=2.02u as=0.915p ps=4.22u w=1.5u l=0.28u
X73 vcp_n.t0 en_b.t7 vss.t123 vss.t122 nfet_03v3 ad=0.61p pd=3.22u as=0.61p ps=3.22u w=1u l=0.28u
X74 vbp_vco.t4 pll_en.t5 vi.t3 vss.t133 nfet_03v3 ad=3.05p pd=11.22u as=3.05p ps=11.22u w=5u l=0.28u
X75 vbl.t1 vbl.t0 vss.t44 vss.t43 nfet_03v3 ad=1.22p pd=5.22u as=1.22p ps=5.22u w=2u l=2u
X76 vdd.t106 vbp_vco.t13 a_18824_1144.t2 vdd.t105 pfet_03v3 ad=3.25p pd=11.3u as=1.3p ps=5.52u w=5u l=0.5u
X77 a_12000_19550# a_12600_12098# vss.t29 ppolyf_u r_width=1u r_length=36.6u
X78 vdump.t2 vbh.t7 vdd.t7 vdd.t6 pfet_03v3 ad=2.6p pd=9.3u as=2.6p ps=9.3u w=4u l=2u
X79 vss.t138 pll_en.t0 a_21564_n100.t3 vss.t137 nfet_03v3 ad=1.22p pd=5.22u as=0.52p ps=2.52u w=2u l=0.28u
X80 r2.t3 r1.t7 a_18824_1144.t0 vdd.t35 pfet_03v3 ad=0.78p pd=3.52u as=1.95p ps=7.3u w=3u l=0.28u
X81 vbp_vco.t1 vbp_vco.t0 vdd.t66 vdd.t65 pfet_03v3 ad=3.25p pd=11.3u as=3.25p ps=11.3u w=5u l=0.5u
X82 vcp_p.t6 pll_en.t9 vdd.t110 vdd.t109 pfet_03v3 ad=0.65p pd=3.3u as=0.65p ps=3.3u w=1u l=0.28u
X83 vfilt vss.t1 cap_mim_2f0_m4m5_noshield c_width=100u c_length=100u
X84 vbp_vco.t3 vbp_vco.t2 vdd.t64 vdd.t63 pfet_03v3 ad=3.25p pd=11.3u as=3.25p ps=11.3u w=5u l=0.5u
X85 vco_out.t4 nb.t9 vdd.t91 vdd.t90 pfet_03v3 ad=0.78p pd=3.52u as=1.95p ps=7.3u w=3u l=0.28u
X86 a_7800_18230# a_8400_12098# vss.t96 ppolyf_u r_width=1u r_length=30u
X87 vdump.t11 vdump.t10 vbt.t8 vdd.t12 pfet_03v3 ad=3.25p pd=11.3u as=3.25p ps=11.3u w=5u l=1u
X88 a_18824_1144.t1 r1.t6 r2.t0 vdd.t38 pfet_03v3 ad=1.95p pd=7.3u as=0.78p ps=3.52u w=3u l=0.28u
X89 vdd.t85 vbp_vco.t11 a_19508_1144.t0 vdd.t84 pfet_03v3 ad=3.25p pd=11.3u as=1.3p ps=5.52u w=5u l=0.5u
X90 a_14400_19550# a_13800_12098# vss.t113 ppolyf_u r_width=1u r_length=36.6u
X91 t1a.t0 vbp.t12 vdd.t30 vdd.t29 pfet_03v3 ad=2.6p pd=9.3u as=2.6p ps=9.3u w=4u l=2u
X92 vss.t57 vbn_vco.t5 a_20880_0.t0 vss.t56 nfet_03v3 ad=1.22p pd=5.22u as=0.52p ps=2.52u w=2u l=0.5u
X93 vco_out.t5 nb.t7 vss.t144 vss.t143 nfet_03v3 ad=0.78p pd=3.52u as=1.83p ps=7.22u w=3u l=0.28u
X94 vdump.t17 pfd_up.t0 up_s.t2 vdd.t73 pfet_03v3 ad=2.6p pd=9.3u as=2.6p ps=9.3u w=4u l=0.5u
X95 vdump.t3 vbh.t6 vdd.t18 vdd.t17 pfet_03v3 ad=2.6p pd=9.3u as=2.6p ps=9.3u w=4u l=2u
X96 r3.t0 r2.t7 a_18140_1144.t2 vdd.t74 pfet_03v3 ad=0.78p pd=3.52u as=1.95p ps=7.3u w=3u l=0.28u
X97 a_18824_1144.t3 vbp_vco.t14 vdd.t108 vdd.t107 pfet_03v3 ad=1.3p pd=5.52u as=3.25p ps=11.3u w=5u l=0.5u
X98 vbh.t1 vbh.t0 vdd.t9 vdd.t8 pfet_03v3 ad=2.6p pd=9.3u as=2.6p ps=9.3u w=4u l=2u
X99 vss.t75 nb.t6 vco_out.t0 vss.t74 nfet_03v3 ad=1.83p pd=7.22u as=0.78p ps=3.52u w=3u l=0.28u
X100 vcp_p.t5 vcp_n.t12 vss.t91 vss.t90 nfet_03v3 ad=6.1p pd=21.22u as=6.1p ps=21.22u w=10u l=2u
X101 a_10800_19550# a_11400_12098# vss.t45 ppolyf_u r_width=1u r_length=36.6u
X102 nb.t0 r5.t9 vdd.t28 vdd.t27 pfet_03v3 ad=0.52p pd=2.52u as=1.3p ps=5.3u w=2u l=0.28u
X103 vnt.t1 vref.t5 vss.t6 vss.t5 nfet_03v3 ad=1.22p pd=5.22u as=1.22p ps=5.22u w=2u l=2u
X104 a_19508_1144.t3 r3.t6 r4.t0 vdd.t98 pfet_03v3 ad=1.95p pd=7.3u as=0.78p ps=3.52u w=3u l=0.28u
X105 vnt.t5 vref.t9 vss.t62 vss.t61 nfet_03v3 ad=1.22p pd=5.22u as=1.22p ps=5.22u w=2u l=2u
X106 vdd.t102 vbp_vco.t9 a_20192_1144.t2 vdd.t101 pfet_03v3 ad=3.25p pd=11.3u as=1.3p ps=5.52u w=5u l=0.5u
X107 vi.t0 vref.t10 vss.t10 vss.t9 nfet_03v3 ad=1.22p pd=5.22u as=1.22p ps=5.22u w=2u l=2u
X108 a_20196_0.t1 vbn_vco.t8 vss.t98 vss.t97 nfet_03v3 ad=0.52p pd=2.52u as=1.22p ps=5.22u w=2u l=0.5u
X109 vss.t24 vbn_vco.t11 a_18828_0.t0 vss.t23 nfet_03v3 ad=1.22p pd=5.22u as=0.52p ps=2.52u w=2u l=0.5u
X110 a_20196_0.t2 r5.t6 r1.t3 vss.t106 nfet_03v3 ad=0.915p pd=4.22u as=0.39p ps=2.02u w=1.5u l=0.28u
X111 r4.t1 r3.t7 a_19508_1144.t2 vdd.t99 pfet_03v3 ad=0.78p pd=3.52u as=1.95p ps=7.3u w=3u l=0.28u
X112 va.t0 en_b.t4 vss.t49 vss.t48 nfet_03v3 ad=0.61p pd=3.22u as=0.61p ps=3.22u w=1u l=0.28u
X113 up_s.t0 vcp_p.t8 vdd.t11 vdd.t10 pfet_03v3 ad=16.25p pd=51.3u as=16.25p ps=51.3u w=25u l=2u
X114 vcp_p.t1 vcp_p.t0 vdd.t97 vdd.t96 pfet_03v3 ad=16.25p pd=51.3u as=16.25p ps=51.3u w=25u l=2u
X115 vbt.t9 vbp.t15 vdd.t32 vdd.t31 pfet_03v3 ad=2.6p pd=9.3u as=2.6p ps=9.3u w=4u l=2u
X116 a_19512_0.t0 vbn_vco.t10 vss.t22 vss.t21 nfet_03v3 ad=0.52p pd=2.52u as=1.22p ps=5.22u w=2u l=0.5u
X117 a_6600_18230# a_7200_12098# vss.t50 ppolyf_u r_width=1u r_length=30u
X118 r1.t2 r5.t7 a_20196_0.t0 vss.t82 nfet_03v3 ad=0.39p pd=2.02u as=0.915p ps=4.22u w=1.5u l=0.28u
X119 a_18140_1144.t1 vbp_vco.t16 vdd.t4 vdd.t3 pfet_03v3 ad=1.3p pd=5.52u as=3.25p ps=11.3u w=5u l=0.5u
X120 vcp_n.t6 cp_trim1.t0 t1c.t1 vss.t108 nfet_03v3 ad=1.22p pd=5.22u as=1.22p ps=5.22u w=2u l=0.28u
X121 vbh.t3 vbh.t2 vdd.t79 vdd.t78 pfet_03v3 ad=2.6p pd=9.3u as=2.6p ps=9.3u w=4u l=2u
X122 a_18144_0.t2 r2.t4 r3.t1 vss.t111 nfet_03v3 ad=0.915p pd=4.22u as=0.39p ps=2.02u w=1.5u l=0.28u
X123 vi.t1 vctrl.t5 vs.t1 vss.t35 nfet_03v3 ad=3.05p pd=11.22u as=3.05p ps=11.22u w=5u l=1u
X124 vbt.t10 vbp.t7 vdd.t46 vdd.t45 pfet_03v3 ad=2.6p pd=9.3u as=2.6p ps=9.3u w=4u l=2u
X125 vcp_n.t11 vcp_n.t10 vss.t81 vss.t80 nfet_03v3 ad=6.1p pd=21.22u as=6.1p ps=21.22u w=10u l=2u
X126 vst.t1 vref.t4 vss.t20 vss.t19 nfet_03v3 ad=3.05p pd=11.22u as=3.05p ps=11.22u w=5u l=1u
X127 va.t1 vref.t7 vss.t60 vss.t59 nfet_03v3 ad=1.22p pd=5.22u as=1.22p ps=5.22u w=2u l=2u
X128 vctrl.t0 a_400_12098# vss.t65 ppolyf_u r_width=2u r_length=37.5u
X129 a_18144_0.t0 vbn_vco.t14 vss.t71 vss.t70 nfet_03v3 ad=0.52p pd=2.52u as=1.22p ps=5.22u w=2u l=0.5u
X130 up_s.t3 vcp_p.t7 vdd.t76 vdd.t75 pfet_03v3 ad=16.25p pd=51.3u as=16.25p ps=51.3u w=25u l=2u
X131 a_20880_0.t2 r4.t4 r5.t1 vss.t85 nfet_03v3 ad=0.915p pd=4.22u as=0.39p ps=2.02u w=1.5u l=0.28u
X132 vcp_n.t3 vbp.t14 vdd.t50 vdd.t49 pfet_03v3 ad=2.6p pd=9.3u as=2.6p ps=9.3u w=4u l=2u
X133 a_13200_19550# a_12600_12098# vss.t58 ppolyf_u r_width=1u r_length=36.6u
X134 vcl.t4 vref.t14 vss.t69 vss.t68 nfet_03v3 ad=6.1p pd=21.22u as=6.1p ps=21.22u w=10u l=2u
X135 vs.t0 a_4200_12098# vss.t27 ppolyf_u r_width=1u r_length=17.5u
X136 vbn_vco.t2 vbn_vco.t1 vss.t127 vss.t126 nfet_03v3 ad=2.44p pd=9.22u as=2.44p ps=9.22u w=4u l=0.5u
X137 nb.t2 r5.t5 a_21564_n100.t0 vss.t105 nfet_03v3 ad=0.52p pd=2.52u as=1.22p ps=5.22u w=2u l=0.28u
X138 a_19508_1144.t1 vbp_vco.t12 vdd.t87 vdd.t86 pfet_03v3 ad=1.3p pd=5.52u as=3.25p ps=11.3u w=5u l=0.5u
X139 vcp_n.t1 vbp.t6 vdd.t40 vdd.t39 pfet_03v3 ad=2.6p pd=9.3u as=2.6p ps=9.3u w=4u l=2u
X140 vcl.t1 vref.t13 vss.t47 vss.t46 nfet_03v3 ad=6.1p pd=21.22u as=6.1p ps=21.22u w=10u l=2u
X141 r5.t0 r4.t5 a_20880_0.t3 vss.t86 nfet_03v3 ad=0.39p pd=2.02u as=0.915p ps=4.22u w=1.5u l=0.28u
X142 vbl.t6 vctrl.t11 vbt.t1 vdd.t19 pfet_03v3 ad=3.25p pd=11.3u as=3.25p ps=11.3u w=5u l=1u
X143 vbl.t7 vctrl.t8 vbt.t4 vdd.t22 pfet_03v3 ad=3.25p pd=11.3u as=3.25p ps=11.3u w=5u l=1u
X144 a_18828_0.t2 r1.t4 r2.t2 vss.t55 nfet_03v3 ad=0.915p pd=4.22u as=0.39p ps=2.02u w=1.5u l=0.28u
X145 vcp_p.t3 vcp_p.t2 vdd.t62 vdd.t61 pfet_03v3 ad=16.25p pd=51.3u as=16.25p ps=51.3u w=25u l=2u
X146 dn_b.t0 pfd_dn.t1 vss.t116 vss.t115 nfet_03v3 ad=0.61p pd=3.22u as=0.61p ps=3.22u w=1u l=0.28u
X147 bias_ref.t0 a_10200_12098# vss.t13 ppolyf_u r_width=1u r_length=36.6u
X148 t2.t0 vbp.t13 vdd.t16 vdd.t15 pfet_03v3 ad=2.6p pd=9.3u as=2.6p ps=9.3u w=4u l=2u
X149 vbp.t4 vbp.t3 vdd.t83 vdd.t82 pfet_03v3 ad=2.6p pd=9.3u as=2.6p ps=9.3u w=4u l=2u
X150 a_1200_19730# a_400_12098# vss.t112 ppolyf_u r_width=2u r_length=37.5u
X151 bias_ref.t1 a_8400_12098# vss.t88 ppolyf_u r_width=1u r_length=30u
X152 vco_out.t3 nb.t11 vdd.t58 vdd.t57 pfet_03v3 ad=0.78p pd=3.52u as=1.95p ps=7.3u w=3u l=0.28u
X153 vcp_n.t9 vcp_n.t8 vss.t53 vss.t52 nfet_03v3 ad=6.1p pd=21.22u as=6.1p ps=21.22u w=10u l=2u
X154 t1b.t0 vbp.t10 vdd.t42 vdd.t41 pfet_03v3 ad=2.6p pd=9.3u as=2.6p ps=9.3u w=4u l=2u
X155 vbt.t0 vbp.t5 vdd.t14 vdd.t13 pfet_03v3 ad=2.6p pd=9.3u as=2.6p ps=9.3u w=4u l=2u
X156 vdump.t9 vdump.t8 vbt.t7 vdd.t88 pfet_03v3 ad=3.25p pd=11.3u as=3.25p ps=11.3u w=5u l=1u
X157 up_b.t1 pfd_up.t1 vdd.t72 vdd.t71 pfet_03v3 ad=1.3p pd=5.3u as=1.3p ps=5.3u w=2u l=0.28u
X158 vcp_n.t5 cp_trim0.t1 t1a.t1 vss.t78 nfet_03v3 ad=1.22p pd=5.22u as=1.22p ps=5.22u w=2u l=0.28u
X159 vbn_vco.t3 vbp_vco.t17 vdd.t68 vdd.t67 pfet_03v3 ad=3.25p pd=11.3u as=3.25p ps=11.3u w=5u l=0.5u
X160 vdd.t56 nb.t10 vco_out.t2 vdd.t55 pfet_03v3 ad=1.95p pd=7.3u as=0.78p ps=3.52u w=3u l=0.28u
X161 vbt.t11 vbp.t17 vdd.t60 vdd.t59 pfet_03v3 ad=2.6p pd=9.3u as=2.6p ps=9.3u w=4u l=2u
X162 va.t2 vbp.t11 vdd.t81 vdd.t80 pfet_03v3 ad=2.6p pd=9.3u as=2.6p ps=9.3u w=4u l=2u
X163 vcl.t2 vref.t12 vss.t64 vss.t63 nfet_03v3 ad=6.1p pd=21.22u as=6.1p ps=21.22u w=10u l=2u
X164 a_14400_19550# a_15000_12098# vss.t51 ppolyf_u r_width=1u r_length=36.6u
X165 t1c.t0 cp_trim0.t0 t1b.t1 vss.t79 nfet_03v3 ad=1.22p pd=5.22u as=1.22p ps=5.22u w=2u l=0.28u
X166 vref.t2 a_6000_12098# vss.t117 ppolyf_u r_width=1u r_length=30u
X167 vbp_vco.t5 pll_en.t4 vi.t4 vss.t134 nfet_03v3 ad=3.05p pd=11.22u as=3.05p ps=11.22u w=5u l=0.28u
R0 vco_out vco_out.n1 7.0415
R1 vco_out.n1 vco_out.n4 5.3705
R2 vco_out.n4 vco_out.n3 6.71734
R3 vco_out.n3 vco_out.t5 0.5465
R4 vco_out.n3 vco_out.t0 0.5465
R5 vco_out.n4 vco_out.n2 6.55734
R6 vco_out.n2 vco_out.t3 0.607167
R7 vco_out.n2 vco_out.t2 0.607167
R8 vco_out.n1 vco_out.n0 11.0573
R9 vco_out.n0 vco_out.t4 0.607167
R10 vco_out.n0 vco_out.t1 0.607167
R11 bias_ref bias_ref.n0 55.8478
R12 bias_ref.n0 bias_ref.t0 21.0588
R13 bias_ref.n0 bias_ref.t1 23.8937
R14 pll_en.n3 pll_en.n2 4.5005
R15 pll_en pll_en.n3 9.1175
R16 pll_en.n3 pll_en.n9 13.0715
R17 pll_en.n7 pll_en.n6 4.5005
R18 pll_en.n9 pll_en.n7 3.8075
R19 pll_en.n9 pll_en.n8 5.6165
R20 pll_en.n8 pll_en.t4 97.1914
R21 pll_en.n8 pll_en.t5 96.0889
R22 pll_en.n5 pll_en.n4 1.121
R23 pll_en.n6 pll_en.n5 8.411
R24 pll_en.n6 pll_en.t6 44.7698
R25 pll_en.n5 pll_en.t7 57.513
R26 pll_en.n4 pll_en.t8 44.7023
R27 pll_en.n4 pll_en.t9 45.3278
R28 pll_en.n7 pll_en.t10 79.1968
R29 pll_en.n2 pll_en.n1 4.81503
R30 pll_en.n1 pll_en.t0 45.7328
R31 pll_en.n1 pll_en.t1 45.5434
R32 pll_en.n2 pll_en.n0 5.35676
R33 pll_en.n0 pll_en.t2 45.7328
R34 pll_en.n0 pll_en.t3 45.5434
R35 pfd_up.n1 pfd_up.n0 5.5535
R36 pfd_up pfd_up.n1 6.953
R37 pfd_up.n1 pfd_up.t2 87.3193
R38 pfd_up.n0 pfd_up.t0 55.1802
R39 pfd_up.n0 pfd_up.t1 64.4475
R40 vctrl.n10 vctrl.n9 4.5005
R41 vctrl vctrl.n10 17.9758
R42 vctrl.n10 vctrl.n6 3.9875
R43 vctrl.n6 vctrl.n0 11.903
R44 vctrl.n8 vctrl.n7 20.525
R45 vctrl.n9 vctrl.n8 0.4415
R46 vctrl.n9 vctrl.t4 40.3467
R47 vctrl.n8 vctrl.t5 40.0182
R48 vctrl.n7 vctrl.t6 40.0182
R49 vctrl.n7 vctrl.t7 42.3267
R50 vctrl.n2 vctrl.n1 1.283
R51 vctrl.n3 vctrl.n2 2.363
R52 vctrl.n5 vctrl.n3 1.4135
R53 vctrl.n4 vctrl.n5 11.0637
R54 vctrl.n6 vctrl.n4 9.27725
R55 vctrl.n5 vctrl.t3 9.23931
R56 vctrl.n4 vctrl.t2 12.186
R57 vctrl.n3 vctrl.t8 40.1274
R58 vctrl.n2 vctrl.t9 40.1274
R59 vctrl.n1 vctrl.t10 40.1274
R60 vctrl.n1 vctrl.t11 42.4899
R61 vctrl.n0 vctrl.t0 41.6334
R62 vctrl.n0 vctrl.t1 41.9313
R63 cp_trim1 cp_trim1.n0 21.9155
R64 cp_trim1.n0 cp_trim1.t0 58.7818
R65 cp_trim1.n0 cp_trim1.t1 59.9968
R66 cp_trim0 cp_trim0.n0 22.523
R67 cp_trim0.n0 cp_trim0.t0 58.4218
R68 cp_trim0.n0 cp_trim0.t1 59.6368
R69 pfd_dn pfd_dn.n0 7.133
R70 pfd_dn.n0 pfd_dn.n1 38.2212
R71 pfd_dn.n1 pfd_dn.t1 45.071
R72 pfd_dn.n1 pfd_dn.t2 47.265
R73 pfd_dn.n0 pfd_dn.t0 69.555
R74 vdd vdd.n82 21.4228
R75 vdd.n30 vdd.n29 3.6455
R76 vdd.n31 vdd.n30 0.43475
R77 vdd.n32 vdd.n31 1.013
R78 vdd.n33 vdd.n32 1.013
R79 vdd.n34 vdd.n33 1.07375
R80 vdd.n35 vdd.n34 0.43475
R81 vdd.n36 vdd.n35 1.013
R82 vdd.n37 vdd.n36 0.626
R83 vdd.n38 vdd.n37 0.626
R84 vdd.n39 vdd.n38 0.626
R85 vdd.n40 vdd.n39 0.68675
R86 vdd.n41 vdd.n40 0.43475
R87 vdd.n42 vdd.n41 0.626
R88 vdd.n43 vdd.n42 2.87375
R89 vdd.n57 vdd.n43 1.013
R90 vdd.n44 vdd.n57 0.77225
R91 vdd.n45 vdd.n44 0.6755
R92 vdd.n46 vdd.n45 0.6755
R93 vdd.n47 vdd.n46 0.73625
R94 vdd.n48 vdd.n47 0.43475
R95 vdd.n49 vdd.n48 0.6755
R96 vdd.n56 vdd.n49 0.68675
R97 vdd.n82 vdd.n56 7.7675
R98 vdd.n57 vdd.n58 24.2892
R99 vdd.n58 vdd.n65 0.344
R100 vdd.n65 vdd.n66 0.3545
R101 vdd.n66 vdd.n67 0.1595
R102 vdd.n67 vdd.n60 0.344
R103 vdd.n60 vdd.n68 0.011
R104 vdd.n68 vdd.n69 0.1595
R105 vdd.n69 vdd.n70 0.3545
R106 vdd.n70 vdd.n71 0.1595
R107 vdd.n71 vdd.n72 0.3545
R108 vdd.n72 vdd.n73 0.1595
R109 vdd.n73 vdd.n62 0.005
R110 vdd.n62 vdd.n74 0.35
R111 vdd.n74 vdd.n75 0.1595
R112 vdd.n75 vdd.n76 0.2885
R113 vdd.n76 vdd.n77 0.1595
R114 vdd.n77 vdd.n64 0.245
R115 vdd.n64 vdd.n78 0.044
R116 vdd.n78 vdd.n79 0.1595
R117 vdd.n79 vdd.n80 0.2885
R118 vdd.n80 vdd.n81 0.1595
R119 vdd.n81 vdd.t54 4.86639
R120 vdd.n81 vdd.t91 4.57839
R121 vdd.n80 vdd.t56 4.57839
R122 vdd.n79 vdd.t58 4.57839
R123 vdd.n78 vdd.t116 5.88015
R124 vdd.n77 vdd.t120 5.88015
R125 vdd.n76 vdd.t48 5.88015
R126 vdd.n75 vdd.t28 5.88015
R127 vdd.n74 vdd.t24 2.01891
R128 vdd.n73 vdd.t26 2.01891
R129 vdd.n72 vdd.t102 2.01891
R130 vdd.n71 vdd.t104 2.01891
R131 vdd.n70 vdd.t85 2.01891
R132 vdd.n69 vdd.t87 2.01891
R133 vdd.n68 vdd.t106 2.01891
R134 vdd.n67 vdd.t108 2.01891
R135 vdd.n66 vdd.t2 2.01891
R136 vdd.n65 vdd.t4 2.01891
R137 vdd.n60 vdd.n59 12.6005
R138 vdd.n62 vdd.n61 12.6005
R139 vdd.n64 vdd.n63 12.6005
R140 vdd.n58 vdd.t74 203.619
R141 vdd.t74 vdd.t3 7.37315
R142 vdd.t3 vdd.t121 46.2471
R143 vdd.t121 vdd.t1 22.1185
R144 vdd.t1 vdd.t35 153.486
R145 vdd.t107 vdd.t35 7.37315
R146 vdd.t38 vdd.t107 46.2471
R147 vdd.t105 vdd.t38 22.1185
R148 vdd.n59 vdd.t105 40.215
R149 vdd.n59 vdd.t99 113.272
R150 vdd.t99 vdd.t86 7.37315
R151 vdd.t86 vdd.t98 46.2471
R152 vdd.t98 vdd.t84 22.1185
R153 vdd.t84 vdd.t95 153.486
R154 vdd.t103 vdd.t95 7.37315
R155 vdd.t77 vdd.t103 46.2471
R156 vdd.t101 vdd.t77 22.1185
R157 vdd.n61 vdd.t101 117.963
R158 vdd.n61 vdd.t0 35.5233
R159 vdd.t0 vdd.t25 7.37315
R160 vdd.t25 vdd.t92 46.2471
R161 vdd.t92 vdd.t23 22.1185
R162 vdd.t23 vdd.t27 153.486
R163 vdd.t27 vdd.t47 53.6198
R164 vdd.t119 vdd.t47 146.113
R165 vdd.t115 vdd.t119 53.6198
R166 vdd.n63 vdd.t115 18.097
R167 vdd.n63 vdd.t57 128.017
R168 vdd.t57 vdd.t55 53.6198
R169 vdd.t55 vdd.t90 146.113
R170 vdd.t90 vdd.t53 53.6198
R171 vdd.n29 vdd.t19 438.584
R172 vdd.t19 vdd.t5 505.781
R173 vdd.t5 vdd.t100 505.781
R174 vdd.t20 vdd.t100 505.781
R175 vdd.n50 vdd.t20 411.851
R176 vdd.n50 vdd.t21 411.851
R177 vdd.t21 vdd.t88 505.781
R178 vdd.t88 vdd.t12 505.781
R179 vdd.t22 vdd.t12 505.781
R180 vdd.n51 vdd.t22 411.851
R181 vdd.n51 vdd.t8 484.104
R182 vdd.t8 vdd.t6 650.289
R183 vdd.t17 vdd.t6 650.289
R184 vdd.n52 vdd.t17 484.104
R185 vdd.n52 vdd.t78 484.104
R186 vdd.t78 vdd.t71 526.013
R187 vdd.t71 vdd.t93 401.735
R188 vdd.t109 vdd.t93 401.735
R189 vdd.t111 vdd.t109 401.735
R190 vdd.n53 vdd.t111 359.827
R191 vdd.n53 vdd.t113 359.827
R192 vdd.t113 vdd.t36 1104.05
R193 vdd.n54 vdd.t36 1062.14
R194 vdd.n54 vdd.t89 375.724
R195 vdd.t89 vdd.t73 433.526
R196 vdd.t73 vdd.t65 433.526
R197 vdd.t69 vdd.t65 433.526
R198 vdd.t67 vdd.t69 433.526
R199 vdd.n55 vdd.t67 375.724
R200 vdd.n55 vdd.t63 375.724
R201 vdd.t63 vdd.t117 417.63
R202 vdd.n56 vdd.t117 382.916
R203 vdd.n47 vdd.n55 23.09
R204 vdd.n43 vdd.n54 23.09
R205 vdd.n40 vdd.n53 23.09
R206 vdd.n34 vdd.n52 23.09
R207 vdd.n30 vdd.n51 23.09
R208 vdd.n29 vdd.n50 23.09
R209 vdd.n49 vdd.t118 18.6345
R210 vdd.n48 vdd.t64 11.2274
R211 vdd.n46 vdd.t68 11.2274
R212 vdd.n45 vdd.t70 11.2274
R213 vdd.n44 vdd.t66 11.2274
R214 vdd.n42 vdd.t37 21.6308
R215 vdd.n41 vdd.t114 13.5844
R216 vdd.n39 vdd.t112 18.6345
R217 vdd.n38 vdd.t110 18.6345
R218 vdd.n37 vdd.t94 13.5844
R219 vdd.n36 vdd.t72 13.5844
R220 vdd.n35 vdd.t79 11.646
R221 vdd.n33 vdd.t18 11.646
R222 vdd.n32 vdd.t7 11.646
R223 vdd.n31 vdd.t9 11.646
R224 vdd.n1 vdd.n0 1.013
R225 vdd.n2 vdd.n1 1.013
R226 vdd.n3 vdd.n2 1.07375
R227 vdd.n4 vdd.n3 0.43475
R228 vdd.n5 vdd.n4 1.013
R229 vdd.n6 vdd.n5 1.013
R230 vdd.n7 vdd.n6 1.07375
R231 vdd.n8 vdd.n7 0.43475
R232 vdd.n9 vdd.n8 1.013
R233 vdd.n10 vdd.n9 1.013
R234 vdd.n11 vdd.n10 1.07375
R235 vdd.n12 vdd.n11 0.43475
R236 vdd.n13 vdd.n12 1.013
R237 vdd.n14 vdd.n13 1.013
R238 vdd.n15 vdd.n14 1.07375
R239 vdd.n16 vdd.n15 0.43475
R240 vdd.n17 vdd.n16 1.013
R241 vdd.n18 vdd.n17 1.013
R242 vdd.n19 vdd.n18 1.07375
R243 vdd.n20 vdd.n19 0.43475
R244 vdd.n21 vdd.n20 1.013
R245 vdd.n22 vdd.n21 1.013
R246 vdd.n28 vdd.n22 1.07375
R247 vdd.n82 vdd.n28 37.2583
R248 vdd.n0 vdd.t96 152.468
R249 vdd.t96 vdd.t10 167.162
R250 vdd.t75 vdd.t10 167.162
R251 vdd.n23 vdd.t75 124.444
R252 vdd.n23 vdd.t61 124.444
R253 vdd.t61 vdd.t59 167.162
R254 vdd.t43 vdd.t59 167.162
R255 vdd.n24 vdd.t43 124.444
R256 vdd.n24 vdd.t31 124.444
R257 vdd.t31 vdd.t49 167.162
R258 vdd.t15 vdd.t49 167.162
R259 vdd.n25 vdd.t15 124.444
R260 vdd.n25 vdd.t29 124.444
R261 vdd.t29 vdd.t82 167.162
R262 vdd.t80 vdd.t82 167.162
R263 vdd.n26 vdd.t80 124.444
R264 vdd.n26 vdd.t41 124.444
R265 vdd.t41 vdd.t33 167.162
R266 vdd.t51 vdd.t33 167.162
R267 vdd.n27 vdd.t51 124.444
R268 vdd.n27 vdd.t45 124.444
R269 vdd.t45 vdd.t39 167.162
R270 vdd.t13 vdd.t39 167.162
R271 vdd.n28 vdd.t13 152.032
R272 vdd.n19 vdd.n27 27.59
R273 vdd.n15 vdd.n26 27.59
R274 vdd.n11 vdd.n25 27.59
R275 vdd.n7 vdd.n24 27.59
R276 vdd.n3 vdd.n23 27.59
R277 vdd.n22 vdd.t14 16.146
R278 vdd.n21 vdd.t40 16.146
R279 vdd.n20 vdd.t46 16.146
R280 vdd.n18 vdd.t52 16.146
R281 vdd.n17 vdd.t34 16.146
R282 vdd.n16 vdd.t42 16.146
R283 vdd.n14 vdd.t81 16.146
R284 vdd.n13 vdd.t83 16.146
R285 vdd.n12 vdd.t30 16.146
R286 vdd.n10 vdd.t16 16.146
R287 vdd.n9 vdd.t50 16.146
R288 vdd.n8 vdd.t32 16.146
R289 vdd.n6 vdd.t44 16.146
R290 vdd.n5 vdd.t60 16.146
R291 vdd.n4 vdd.t62 12.6482
R292 vdd.n2 vdd.t76 12.6482
R293 vdd.n1 vdd.t11 12.6482
R294 vdd.n0 vdd.t97 12.6482
R295 vss.n107 vss.n106 4.5005
R296 vss vss.n107 17.4357
R297 vss.n107 vss.n0 16.25
R298 vss.n2 vss.n1 0.43025
R299 vss.n3 vss.n2 0.995
R300 vss.n4 vss.n3 0.995
R301 vss.n5 vss.n4 1.06025
R302 vss.n6 vss.n5 0.43025
R303 vss.n7 vss.n6 0.995
R304 vss.n105 vss.n7 0.14225
R305 vss.n8 vss.n105 0.85325
R306 vss.n9 vss.n8 1.06025
R307 vss.n10 vss.n9 0.43025
R308 vss.n11 vss.n10 0.995
R309 vss.n12 vss.n11 0.995
R310 vss.n13 vss.n12 1.06025
R311 vss.n14 vss.n13 0.43025
R312 vss.n15 vss.n14 1.7645
R313 vss.n16 vss.n15 0.77
R314 vss.n17 vss.n16 0.83525
R315 vss.n18 vss.n17 0.43025
R316 vss.n26 vss.n18 1.36175
R317 vss.n19 vss.n26 0.08375
R318 vss.n20 vss.n19 0.608
R319 vss.n21 vss.n20 0.608
R320 vss.n22 vss.n21 0.67325
R321 vss.n23 vss.n22 0.43025
R322 vss.n24 vss.n23 0.6575
R323 vss.n106 vss.n24 2.70275
R324 vss.n106 vss.n25 0.1175
R325 vss.n105 vss.t37 13.992
R326 vss.n28 vss.n27 10.4005
R327 vss.n30 vss.n29 10.4005
R328 vss.n32 vss.n31 10.4005
R329 vss.n91 vss.n90 10.4005
R330 vss.n26 vss.n28 26.0292
R331 vss.n28 vss.n104 0.344
R332 vss.n104 vss.n103 0.3485
R333 vss.n103 vss.n102 0.1655
R334 vss.n102 vss.n30 0.344
R335 vss.n30 vss.n101 0.005
R336 vss.n101 vss.n100 0.1655
R337 vss.n100 vss.n99 0.3485
R338 vss.n99 vss.n98 0.1655
R339 vss.n98 vss.n97 0.3485
R340 vss.n97 vss.n96 0.1655
R341 vss.n96 vss.n32 0.005
R342 vss.n32 vss.n95 0.344
R343 vss.n95 vss.n94 0.6125
R344 vss.n94 vss.n91 0.245
R345 vss.n91 vss.n93 0.038
R346 vss.n93 vss.n92 0.1655
R347 vss.n104 vss.t71 3.85787
R348 vss.n103 vss.t95 3.85787
R349 vss.n102 vss.t93 3.85787
R350 vss.n101 vss.t24 3.85787
R351 vss.n100 vss.t22 3.85787
R352 vss.n99 vss.t100 3.85787
R353 vss.n98 vss.t98 3.85787
R354 vss.n97 vss.t142 3.85787
R355 vss.n96 vss.t73 3.85787
R356 vss.n95 vss.t57 3.85787
R357 vss.n94 vss.t136 4.97103
R358 vss.n93 vss.t138 4.97103
R359 vss.n92 vss.t144 3.59261
R360 vss.n92 vss.t75 3.87461
R361 vss.n27 vss.n36 397.483
R362 vss.n27 vss.t145 661.692
R363 vss.t145 vss.t70 25.7199
R364 vss.t70 vss.t111 161.332
R365 vss.t111 vss.t94 77.1588
R366 vss.t94 vss.t54 535.433
R367 vss.t92 vss.t54 25.7199
R368 vss.t55 vss.t92 161.332
R369 vss.t23 vss.t55 77.1588
R370 vss.n29 vss.t23 144.964
R371 vss.n29 vss.t130 390.469
R372 vss.t130 vss.t21 25.7199
R373 vss.t21 vss.t129 161.332
R374 vss.t129 vss.t99 77.1588
R375 vss.t99 vss.t82 535.433
R376 vss.t97 vss.t82 25.7199
R377 vss.t106 vss.t97 161.332
R378 vss.t141 vss.t106 77.1588
R379 vss.n31 vss.t141 416.188
R380 vss.n31 vss.t86 119.246
R381 vss.t86 vss.t72 25.7199
R382 vss.t72 vss.t85 161.332
R383 vss.t85 vss.t56 77.1588
R384 vss.t56 vss.t105 535.433
R385 vss.t105 vss.t128 187.05
R386 vss.t135 vss.t128 509.712
R387 vss.t137 vss.t135 187.05
R388 vss.n90 vss.t137 67.8063
R389 vss.n90 vss.t143 441.906
R390 vss.t143 vss.t74 187.05
R391 vss.n36 vss.t17 273.3
R392 vss.t17 vss.t48 470.005
R393 vss.t120 vss.t48 470.005
R394 vss.n33 vss.t120 426.486
R395 vss.n33 vss.t126 445.635
R396 vss.t126 vss.t39 489.154
R397 vss.t39 vss.t35 532.673
R398 vss.t35 vss.t36 595.341
R399 vss.t133 vss.t36 532.673
R400 vss.n34 vss.t133 426.486
R401 vss.n34 vss.t134 426.486
R402 vss.t134 vss.n35 426.486
R403 vss.n35 vss.n89 29.5934
R404 vss.n89 vss.t74 11006.1
R405 vss.n50 vss.n42 21.9812
R406 vss.n54 vss.n43 21.9812
R407 vss.n55 vss.n44 21.9812
R408 vss.n61 vss.n45 21.9812
R409 vss.n67 vss.t65 3.46717
R410 vss.n68 vss.t112 3.46717
R411 vss.n69 vss.t0 3.46717
R412 vss.n70 vss.t87 3.46717
R413 vss.n71 vss.t27 10.4005
R414 vss.n72 vss.t67 10.4005
R415 vss.n73 vss.t117 10.4005
R416 vss.n74 vss.t26 10.4005
R417 vss.n75 vss.t50 10.4005
R418 vss.n76 vss.t25 10.4005
R419 vss.n77 vss.t96 10.4005
R420 vss.n78 vss.t88 10.4005
R421 vss.n79 vss.t13 10.4005
R422 vss.n80 vss.t140 10.4005
R423 vss.n81 vss.t45 10.4005
R424 vss.n82 vss.t14 10.4005
R425 vss.n83 vss.t29 10.4005
R426 vss.n84 vss.t58 10.4005
R427 vss.n85 vss.t28 10.4005
R428 vss.n86 vss.t113 10.4005
R429 vss.n87 vss.t51 8.68176
R430 vss.n47 vss.t65 112.921
R431 vss.t65 vss.t52 29.3254
R432 vss.t52 vss.t112 115.49
R433 vss.t112 vss.t41 44.531
R434 vss.t41 vss.t0 100.284
R435 vss.t0 vss.t118 59.7365
R436 vss.t118 vss.t87 85.079
R437 vss.t87 vss.n42 34.756
R438 vss.n42 vss.t76 119.835
R439 vss.t27 vss.t76 80.7346
R440 vss.t27 vss.t90 79.2864
R441 vss.t67 vss.t90 29.3254
R442 vss.t67 vss.t80 130.696
R443 vss.t117 vss.t80 86.5272
R444 vss.t117 vss.t114 46.3411
R445 vss.t114 vss.t26 62.2707
R446 vss.t26 vss.n43 30.4116
R447 vss.n43 vss.t50 78.2003
R448 vss.t50 vss.t66 14.482
R449 vss.t66 vss.t25 94.1299
R450 vss.t25 vss.t78 7.60326
R451 vss.t78 vss.t107 97.7503
R452 vss.t96 vss.t107 3.25883
R453 vss.t96 vss.t79 94.492
R454 vss.t88 vss.t79 14.1199
R455 vss.t88 vss.t108 83.6309
R456 vss.n44 vss.t108 88.6994
R457 vss.n44 vss.t13 44.893
R458 vss.t13 vss.t83 43.8069
R459 vss.t83 vss.t140 64.805
R460 vss.t140 vss.t115 32.9458
R461 vss.t115 vss.t45 75.6661
R462 vss.t45 vss.t122 22.0847
R463 vss.t122 vss.t14 86.5272
R464 vss.t14 vss.t131 11.2236
R465 vss.t131 vss.t29 97.3883
R466 vss.t29 vss.t68 31.4977
R467 vss.t68 vss.t58 77.1142
R468 vss.t58 vss.n45 42.7208
R469 vss.n45 vss.t28 65.8911
R470 vss.t28 vss.t46 53.9439
R471 vss.t46 vss.t113 54.668
R472 vss.t113 vss.t63 105.353
R473 vss.t51 vss.t63 3.25883
R474 vss.n87 vss.t30 9.27483
R475 vss.t30 vss.t15 48.1513
R476 vss.t15 vss.n46 119.835
R477 vss.n46 vss.n89 2677.22
R478 vss.n67 vss.n68 0.947868
R479 vss.n68 vss.n69 0.947868
R480 vss.n69 vss.n70 0.947868
R481 vss.n70 vss.n71 1.53997
R482 vss.n71 vss.n72 0.711026
R483 vss.n72 vss.n73 1.42155
R484 vss.n73 vss.n74 0.711026
R485 vss.n74 vss.n75 0.711026
R486 vss.n75 vss.n76 0.711026
R487 vss.n76 vss.n77 0.711026
R488 vss.n77 vss.n78 0.711026
R489 vss.n78 vss.n79 1.42155
R490 vss.n79 vss.n80 0.711026
R491 vss.n80 vss.n81 0.711026
R492 vss.n81 vss.n82 0.711026
R493 vss.n82 vss.n83 0.711026
R494 vss.n83 vss.n84 0.711026
R495 vss.n84 vss.n85 0.711026
R496 vss.n85 vss.n86 0.711026
R497 vss.n86 vss.n87 1.59954
R498 vss.n88 vss.n67 36.2627
R499 vss.n0 vss.n88 12.308
R500 vss.n88 vss.t31 19.9788
R501 vss.n66 vss.n46 21.9812
R502 vss.n48 vss.n47 0.995
R503 vss.n49 vss.n48 0.995
R504 vss.n50 vss.n49 1.06025
R505 vss.n51 vss.n50 0.43025
R506 vss.n52 vss.n51 0.995
R507 vss.n53 vss.n52 0.995
R508 vss.n54 vss.n53 1.71725
R509 vss.n55 vss.n54 3.5825
R510 vss.n56 vss.n55 0.43025
R511 vss.n57 vss.n56 0.608
R512 vss.n58 vss.n57 0.608
R513 vss.n59 vss.n58 0.608
R514 vss.n60 vss.n59 0.608
R515 vss.n61 vss.n60 1.06025
R516 vss.n62 vss.n61 0.43025
R517 vss.n63 vss.n62 0.995
R518 vss.n64 vss.n63 0.995
R519 vss.n66 vss.n64 1.06025
R520 vss.n65 vss.n66 5.324
R521 vss.n0 vss.n65 10.1863
R522 vss.n65 vss.t1 13.9313
R523 vss.n64 vss.t16 11.1876
R524 vss.n63 vss.t64 11.1876
R525 vss.n62 vss.t47 11.1876
R526 vss.n60 vss.t69 11.1876
R527 vss.n59 vss.t132 20.4058
R528 vss.n58 vss.t123 20.4058
R529 vss.n57 vss.t116 20.4058
R530 vss.n56 vss.t84 20.4058
R531 vss.n53 vss.t81 11.1876
R532 vss.n52 vss.t91 11.1876
R533 vss.n51 vss.t77 11.1876
R534 vss.n49 vss.t119 11.1876
R535 vss.n48 vss.t42 11.1876
R536 vss.n47 vss.t53 11.1876
R537 vss.n1 vss.t33 216.732
R538 vss.t33 vss.t139 234.049
R539 vss.t139 vss.t89 234.049
R540 vss.t34 vss.t89 234.049
R541 vss.n37 vss.t34 192.304
R542 vss.n37 vss.t43 226.522
R543 vss.t43 vss.t103 302.486
R544 vss.t101 vss.t103 302.486
R545 vss.n38 vss.t101 226.522
R546 vss.n38 vss.t7 226.522
R547 vss.t7 vss.t9 302.486
R548 vss.t61 vss.t9 302.486
R549 vss.n39 vss.t61 226.522
R550 vss.n39 vss.t3 226.522
R551 vss.t3 vss.t59 302.486
R552 vss.t11 vss.t59 302.486
R553 vss.n40 vss.t11 226.522
R554 vss.n40 vss.t5 226.522
R555 vss.t5 vss.t32 268.267
R556 vss.t32 vss.t19 234.049
R557 vss.t109 vss.t19 234.049
R558 vss.n41 vss.t109 192.304
R559 vss.n41 vss.t124 294.957
R560 vss.t124 vss.n36 204.623
R561 vss.n17 vss.n41 20.8562
R562 vss.n13 vss.n40 20.8562
R563 vss.n9 vss.n39 20.8562
R564 vss.n5 vss.n38 20.8562
R565 vss.n1 vss.n37 20.8562
R566 vss.n25 vss.n35 21.9588
R567 vss.n25 vss.n34 20.8562
R568 vss.n22 vss.n33 20.8562
R569 vss.n24 vss.t40 19.2808
R570 vss.n23 vss.t127 11.6644
R571 vss.n21 vss.t121 19.2808
R572 vss.n20 vss.t49 19.2808
R573 vss.n19 vss.t18 19.2808
R574 vss.n18 vss.t125 21.857
R575 vss.n16 vss.t110 11.2319
R576 vss.n15 vss.t20 11.2319
R577 vss.n14 vss.t6 13.7073
R578 vss.n12 vss.t12 13.7073
R579 vss.n11 vss.t60 13.7073
R580 vss.n10 vss.t4 13.7073
R581 vss.n8 vss.t62 13.7073
R582 vss.n7 vss.t10 13.7073
R583 vss.n6 vss.t8 13.7073
R584 vss.n4 vss.t102 13.7073
R585 vss.n3 vss.t104 13.7073
R586 vss.n2 vss.t44 13.7073
R587 a_21564_n100.t2 a_21564_n100.n0 0.8195
R588 a_21564_n100.n0 a_21564_n100.t3 0.8195
R589 a_21564_n100.n0 a_21564_n100.n1 7.26555
R590 a_21564_n100.n1 a_21564_n100.t0 8.48955
R591 a_21564_n100.n1 a_21564_n100.t1 8.06655
R592 a_20880_0.n0 a_20880_0.t1 0.8195
R593 a_20880_0.t0 a_20880_0.n0 0.8195
R594 a_20880_0.n0 a_20880_0.n1 7.36905
R595 a_20880_0.n1 a_20880_0.t3 9.85078
R596 a_20880_0.n1 a_20880_0.t2 9.75178
R597 a_20196_0.t0 a_20196_0.n1 9.85078
R598 a_20196_0.n1 a_20196_0.n0 7.36905
R599 a_20196_0.n0 a_20196_0.t1 0.8195
R600 a_20196_0.n0 a_20196_0.t3 0.8195
R601 a_20196_0.n1 a_20196_0.t2 9.75178
R602 a_19512_0.t0 a_19512_0.n0 0.8195
R603 a_19512_0.n0 a_19512_0.t1 0.8195
R604 a_19512_0.n0 a_19512_0.n1 7.36905
R605 a_19512_0.n1 a_19512_0.t3 9.85078
R606 a_19512_0.n1 a_19512_0.t2 9.75178
R607 a_18828_0.n0 a_18828_0.t3 0.8195
R608 a_18828_0.t0 a_18828_0.n0 0.8195
R609 a_18828_0.n0 a_18828_0.n1 7.36905
R610 a_18828_0.n1 a_18828_0.t1 9.85078
R611 a_18828_0.n1 a_18828_0.t2 9.75178
R612 a_18144_0.t0 a_18144_0.n0 0.8195
R613 a_18144_0.n0 a_18144_0.t1 0.8195
R614 a_18144_0.n0 a_18144_0.n1 7.36905
R615 a_18144_0.n1 a_18144_0.t3 9.85078
R616 a_18144_0.n1 a_18144_0.t2 9.75178
R617 nb.n0 nb.t4 0.9105
R618 nb.n0 nb.t5 0.9105
R619 nb.n9 nb.n0 11.3929
R620 nb nb.n9 0.2855
R621 nb.n7 nb.n6 4.5005
R622 nb nb.n7 0.2915
R623 nb.n7 nb.n8 10.2408
R624 nb.n8 nb.t8 58.7685
R625 nb.n8 nb.t9 58.5791
R626 nb.n6 nb.n5 5.29503
R627 nb.n5 nb.t6 58.7685
R628 nb.n5 nb.t7 58.5791
R629 nb.n6 nb.n4 4.87676
R630 nb.n4 nb.t10 58.7685
R631 nb.n4 nb.t11 58.5791
R632 nb.n9 nb.n3 5.3705
R633 nb.n3 nb.n2 7.67955
R634 nb.n2 nb.t2 0.8195
R635 nb.n2 nb.t3 0.8195
R636 nb.n3 nb.n1 6.89289
R637 nb.n1 nb.t0 0.9105
R638 nb.n1 nb.t1 0.9105
R639 r4.n0 r4.t1 0.607167
R640 r4.n0 r4.t0 0.607167
R641 r4.n1 r4.n0 6.55734
R642 r4.n1 r4.n5 8.43066
R643 r4.n5 r4.t3 1.0925
R644 r4.n5 r4.t2 1.0925
R645 r4 r4.n1 5.3705
R646 r4 r4.n4 5.3705
R647 r4.n4 r4.n3 5.05503
R648 r4.n3 r4.t4 39.215
R649 r4.n3 r4.t5 39.0255
R650 r4.n4 r4.n2 5.11676
R651 r4.n2 r4.t6 58.7685
R652 r4.n2 r4.t7 58.5791
R653 r5.t2 r5.n0 0.607167
R654 r5.n0 r5.t3 0.607167
R655 r5.n1 r5.n0 6.31734
R656 r5.n8 r5.n1 4.5005
R657 r5.n1 r5.n9 8.67066
R658 r5.n9 r5.t0 1.0925
R659 r5.n9 r5.t1 1.0925
R660 r5.n8 r5.n7 5.2145
R661 r5.n7 r5.n6 5.29503
R662 r5.n6 r5.t4 45.7328
R663 r5.n6 r5.t5 45.5434
R664 r5.n7 r5.n5 4.87676
R665 r5.n5 r5.t8 45.7328
R666 r5.n5 r5.t9 45.5434
R667 r5 r5.n8 0.2675
R668 r5 r5.n4 5.5115
R669 r5.n4 r5.n3 5.29503
R670 r5.n3 r5.t6 39.215
R671 r5.n3 r5.t7 39.0255
R672 r5.n4 r5.n2 4.87676
R673 r5.n2 r5.t11 58.5791
R674 r5.n2 r5.t10 58.7685
R675 r3.t0 r3.n0 0.607167
R676 r3.n0 r3.t3 0.607167
R677 r3.n1 r3.n0 6.31734
R678 r3.n1 r3.n5 8.67066
R679 r3.n5 r3.t2 1.0925
R680 r3.n5 r3.t1 1.0925
R681 r3 r3.n1 5.3705
R682 r3 r3.n4 5.3705
R683 r3.n4 r3.n3 5.29503
R684 r3.n3 r3.t4 39.215
R685 r3.n3 r3.t5 39.0255
R686 r3.n4 r3.n2 4.87676
R687 r3.n2 r3.t6 58.7685
R688 r3.n2 r3.t7 58.5791
R689 r1.t0 r1.n0 0.607167
R690 r1.n0 r1.t1 0.607167
R691 r1.n1 r1.n0 6.79734
R692 r1.n1 r1.n5 8.19066
R693 r1.n5 r1.t2 1.0925
R694 r1.n5 r1.t3 1.0925
R695 r1 r1.n1 5.6495
R696 r1 r1.n4 5.6555
R697 r1.n4 r1.n3 4.81503
R698 r1.n3 r1.t4 39.215
R699 r1.n3 r1.t5 39.0255
R700 r1.n4 r1.n2 5.35676
R701 r1.n2 r1.t7 58.5791
R702 r1.n2 r1.t6 58.7685
R703 r2.n0 r2.t3 0.607167
R704 r2.n0 r2.t0 0.607167
R705 r2.n1 r2.n0 6.55734
R706 r2.n1 r2.n5 8.43066
R707 r2.n5 r2.t1 1.0925
R708 r2.n5 r2.t2 1.0925
R709 r2 r2.n1 5.1365
R710 r2 r2.n4 5.1425
R711 r2.n4 r2.n3 5.05503
R712 r2.n3 r2.t4 39.215
R713 r2.n3 r2.t5 39.0255
R714 r2.n4 r2.n2 5.11676
R715 r2.n2 r2.t7 58.5791
R716 r2.n2 r2.t6 58.7685
R717 a_20876_1144.t2 a_20876_1144.n1 7.22309
R718 a_20876_1144.n1 a_20876_1144.t3 7.12409
R719 a_20876_1144.n1 a_20876_1144.n0 6.20245
R720 a_20876_1144.n0 a_20876_1144.t1 0.3645
R721 a_20876_1144.n0 a_20876_1144.t0 0.3645
R722 a_20192_1144.t1 a_20192_1144.n1 7.12409
R723 a_20192_1144.n1 a_20192_1144.t0 7.22309
R724 a_20192_1144.n1 a_20192_1144.n0 6.20245
R725 a_20192_1144.n0 a_20192_1144.t3 0.3645
R726 a_20192_1144.n0 a_20192_1144.t2 0.3645
R727 a_19508_1144.t2 a_19508_1144.n1 7.22309
R728 a_19508_1144.n1 a_19508_1144.t3 7.12409
R729 a_19508_1144.n1 a_19508_1144.n0 6.20245
R730 a_19508_1144.n0 a_19508_1144.t1 0.3645
R731 a_19508_1144.n0 a_19508_1144.t0 0.3645
R732 a_18824_1144.t1 a_18824_1144.n1 7.12409
R733 a_18824_1144.n1 a_18824_1144.t0 7.22309
R734 a_18824_1144.n1 a_18824_1144.n0 6.20245
R735 a_18824_1144.n0 a_18824_1144.t3 0.3645
R736 a_18824_1144.n0 a_18824_1144.t2 0.3645
R737 a_18140_1144.t2 a_18140_1144.n1 7.22309
R738 a_18140_1144.n1 a_18140_1144.t3 7.12409
R739 a_18140_1144.n1 a_18140_1144.n0 6.20245
R740 a_18140_1144.n0 a_18140_1144.t1 0.3645
R741 a_18140_1144.n0 a_18140_1144.t0 0.3645
R742 vi.n2 vi.t3 12.1319
R743 vi vi.n0 6.16325
R744 vi.n0 vi.n1 0.77
R745 vi.n1 vi.n2 0.365
R746 vi.n2 vi.t4 13.2344
R747 vi.n1 vi.t2 12.1319
R748 vi.n0 vi.t1 12.1319
R749 vi vi.t0 23.0066
R750 vnt.n0 vnt.t3 12.1814
R751 vnt.n1 vnt.n0 0.77
R752 vnt.n2 vnt.n1 0.77
R753 vnt vnt.n2 5.01125
R754 vnt vnt.n3 2.35175
R755 vnt.n3 vnt.n4 1.49
R756 vnt.n4 vnt.n5 1.9895
R757 vnt.n5 vnt.t1 15.3768
R758 vnt.n5 vnt.t2 13.8873
R759 vnt.n4 vnt.t0 13.8873
R760 vnt.n3 vnt.t5 13.8873
R761 vnt.n2 vnt.t4 11.4119
R762 vnt.n1 vnt.t6 11.4119
R763 vnt.n0 vnt.t7 11.4119
R764 vbn_vco.t3 vbn_vco.n12 13.7474
R765 vbn_vco.n11 vbn_vco.n12 14.3443
R766 vbn_vco vbn_vco.n3 18.3279
R767 vbn_vco vbn_vco.n1 0.683375
R768 vbn_vco.n1 vbn_vco.n11 0.00725
R769 vbn_vco.n3 vbn_vco.n5 0.9965
R770 vbn_vco.n5 vbn_vco.n7 0.9965
R771 vbn_vco.n7 vbn_vco.n9 0.9965
R772 vbn_vco.n9 vbn_vco.n10 10.4541
R773 vbn_vco.n10 vbn_vco.t5 29.8501
R774 vbn_vco.n10 vbn_vco.t6 29.6085
R775 vbn_vco.n9 vbn_vco.n8 9.45808
R776 vbn_vco.n8 vbn_vco.t7 29.8501
R777 vbn_vco.n8 vbn_vco.t8 29.6085
R778 vbn_vco.n7 vbn_vco.n6 9.45808
R779 vbn_vco.n6 vbn_vco.t9 29.8501
R780 vbn_vco.n6 vbn_vco.t10 29.6085
R781 vbn_vco.n5 vbn_vco.n4 9.45808
R782 vbn_vco.n4 vbn_vco.t11 29.8501
R783 vbn_vco.n4 vbn_vco.t12 29.6085
R784 vbn_vco.n3 vbn_vco.n2 9.45808
R785 vbn_vco.n2 vbn_vco.t13 29.8501
R786 vbn_vco.n2 vbn_vco.t14 29.6085
R787 vbn_vco.n11 vbn_vco.t0 21.1415
R788 vbn_vco.n1 vbn_vco.n0 11.0368
R789 vbn_vco.n0 vbn_vco.t2 1.88813
R790 vbn_vco.n0 vbn_vco.t1 44.5424
R791 vbn_vco.n12 vbn_vco.t4 14.4224
R792 vst.t1 vst.n0 13.2614
R793 vst vst.n0 0.88925
R794 vst vst.n2 0.0725
R795 vst.n2 vst.n1 1.148
R796 vst.n2 vst.t2 37.6845
R797 vst.n1 vst.t0 20.9795
R798 vst.n1 vst.t4 14.827
R799 vst.n0 vst.t3 12.4919
R800 vbh.t5 vbh.n5 11.5919
R801 vbh vbh.n5 2.03338
R802 vbh vbh.n4 17.8689
R803 vbh.n4 vbh.n1 0.0275
R804 vbh.n1 vbh.n2 1.013
R805 vbh.n2 vbh.n3 12.0492
R806 vbh.n3 vbh.t3 1.83599
R807 vbh.n3 vbh.t2 12.2744
R808 vbh.n2 vbh.t6 22.759
R809 vbh.n1 vbh.t7 22.759
R810 vbh.n4 vbh.n0 11.8648
R811 vbh.n0 vbh.t1 1.83599
R812 vbh.n0 vbh.t0 12.2744
R813 vbh.n5 vbh.t4 13.9004
R814 vbl.t4 vbl.n7 11.5874
R815 vbl.n7 vbl.n0 1.283
R816 vbl.n1 vbl.n7 2.363
R817 vbl.n6 vbl.n1 15.0755
R818 vbl vbl.n3 0.919625
R819 vbl vbl.n4 0.075875
R820 vbl.n4 vbl.n6 1.32125
R821 vbl.n6 vbl.n5 11.1312
R822 vbl.n5 vbl.t3 3.47655
R823 vbl.n5 vbl.t2 8.58548
R824 vbl.n4 vbl.t8 19.4863
R825 vbl.n3 vbl.t9 19.4863
R826 vbl.n3 vbl.n2 12.2945
R827 vbl.n2 vbl.t1 3.47655
R828 vbl.n2 vbl.t0 8.58548
R829 vbl.n1 vbl.t7 11.5874
R830 vbl.n0 vbl.t5 11.5874
R831 vbl.n0 vbl.t6 13.9499
R832 vbp_vco.t5 vbp_vco.n0 13.9544
R833 vbp_vco vbp_vco.n16 17.5111
R834 vbp_vco vbp_vco.n1 0.055625
R835 vbp_vco.n1 vbp_vco.n0 1.66775
R836 vbp_vco.n16 vbp_vco.n10 0.7955
R837 vbp_vco.n10 vbp_vco.n12 0.9965
R838 vbp_vco.n12 vbp_vco.n14 0.9965
R839 vbp_vco.n14 vbp_vco.n15 10.4558
R840 vbp_vco.n15 vbp_vco.t7 51.8961
R841 vbp_vco.n15 vbp_vco.t8 51.6545
R842 vbp_vco.n14 vbp_vco.n13 9.45982
R843 vbp_vco.n13 vbp_vco.t9 51.8961
R844 vbp_vco.n13 vbp_vco.t10 51.6545
R845 vbp_vco.n12 vbp_vco.n11 9.45982
R846 vbp_vco.n11 vbp_vco.t11 51.8961
R847 vbp_vco.n11 vbp_vco.t12 51.6545
R848 vbp_vco.n10 vbp_vco.n9 9.45982
R849 vbp_vco.n9 vbp_vco.t13 51.8961
R850 vbp_vco.n9 vbp_vco.t14 51.6545
R851 vbp_vco.n16 vbp_vco.n8 9.61057
R852 vbp_vco.n8 vbp_vco.t15 51.8961
R853 vbp_vco.n8 vbp_vco.t16 51.6545
R854 vbp_vco.n1 vbp_vco.n7 13.7075
R855 vbp_vco.n4 vbp_vco.n3 0.6755
R856 vbp_vco.n6 vbp_vco.n4 1.00175
R857 vbp_vco.n7 vbp_vco.n6 0.00725
R858 vbp_vco.n7 vbp_vco.t6 21.5933
R859 vbp_vco.n6 vbp_vco.n5 11.9233
R860 vbp_vco.n5 vbp_vco.t3 1.6447
R861 vbp_vco.n5 vbp_vco.t2 51.9932
R862 vbp_vco.n4 vbp_vco.t17 63.6952
R863 vbp_vco.n3 vbp_vco.t18 63.6952
R864 vbp_vco.n3 vbp_vco.n2 12.767
R865 vbp_vco.n2 vbp_vco.t1 1.6447
R866 vbp_vco.n2 vbp_vco.t0 51.9932
R867 vbp_vco.n0 vbp_vco.t4 12.8519
R868 vs.n0 vs.t1 13.2614
R869 vs vs.n0 1.53838
R870 vs vs.t0 74.8056
R871 vs.n0 vs.t2 12.4919
R872 vcl.t0 vcl.n2 14.0676
R873 vcl.n1 vcl.n0 0.995
R874 vcl.n2 vcl.n1 0.995
R875 vcl vcl.n2 35.5482
R876 vcl vcl.t3 35.965
R877 vcl.n1 vcl.t2 14.0676
R878 vcl.n0 vcl.t1 14.0676
R879 vcl.n0 vcl.t4 15.5571
R880 up_b.t1 up_b 20.9925
R881 up_b up_b.n0 0.100625
R882 up_b.n0 up_b.t0 71.5708
R883 up_b.n0 up_b.t2 54.6402
R884 en_b.t1 en_b.n0 18.5456
R885 en_b.n5 en_b.n0 10.4585
R886 en_b.n3 en_b.n2 0.608
R887 en_b en_b.n3 0.968
R888 en_b en_b.n4 0.7925
R889 en_b.n4 en_b.n5 10.418
R890 en_b.n4 en_b.t2 44.486
R891 en_b.n3 en_b.t3 44.486
R892 en_b.n2 en_b.t4 44.486
R893 en_b.n2 en_b.t5 45.0936
R894 en_b.n5 en_b.n1 32.315
R895 en_b.n1 en_b.t0 22.9257
R896 en_b.n1 en_b.t7 47.1298
R897 en_b.n0 en_b.t6 14.7589
R898 t1c.t0 t1c 17.1746
R899 t1c t1c.t1 17.1746
R900 vdump.t15 vdump.n0 1.68292
R901 vdump.n0 vdump.t14 30.1453
R902 vdump.n15 vdump.n0 10.2695
R903 vdump.n2 vdump.n15 3.254
R904 vdump.n3 vdump.n2 0.995
R905 vdump vdump.n3 6.67962
R906 vdump vdump.n14 20.1841
R907 vdump.n8 vdump.n6 2.858
R908 vdump.n10 vdump.n8 0.788
R909 vdump.n11 vdump.n10 3.308
R910 vdump.n12 vdump.n11 1.013
R911 vdump.n13 vdump.n12 9.788
R912 vdump.n14 vdump.n13 9.32225
R913 vdump.n13 vdump.t17 12.366
R914 vdump.n12 vdump.t3 12.366
R915 vdump.n11 vdump.t2 12.366
R916 vdump.n10 vdump.n9 10.3032
R917 vdump.n9 vdump.t11 1.6447
R918 vdump.n9 vdump.t10 30.2254
R919 vdump.n8 vdump.n7 10.3032
R920 vdump.n7 vdump.t9 1.6447
R921 vdump.n7 vdump.t8 30.2254
R922 vdump.n6 vdump.n5 10.3032
R923 vdump.n5 vdump.t7 1.6447
R924 vdump.n5 vdump.t6 30.2254
R925 vdump.n6 vdump.n4 11.0908
R926 vdump.n4 vdump.t5 1.6447
R927 vdump.n4 vdump.t4 30.2254
R928 vdump.n14 vdump.t16 52.8618
R929 vdump.n3 vdump.t1 14.4273
R930 vdump.n2 vdump.t0 14.4273
R931 vdump.n15 vdump.n1 11.039
R932 vdump.n1 vdump.t13 1.68292
R933 vdump.n1 vdump.t12 30.1453
R934 dn_b.t1 dn_b 20.8598
R935 dn_b dn_b.n0 44.7654
R936 dn_b.n0 dn_b.t0 21.4858
R937 dn_b.n0 dn_b.t2 46.1242
R938 dn_s.t0 dn_s.n1 11.7276
R939 dn_s dn_s.n1 1.0085
R940 dn_s dn_s.n0 1.346
R941 dn_s.n0 dn_s.t1 16.5243
R942 dn_s.n0 dn_s.t2 15.3723
R943 dn_s.n1 dn_s.t3 13.2171
R944 vref.n12 vref.t1 12.7444
R945 vref.n1 vref.n0 1.49
R946 vref.n2 vref.n1 0.995
R947 vref.n3 vref.n2 0.995
R948 vref.n4 vref.n3 1.49
R949 vref.n12 vref.n4 0.19625
R950 vref.n5 vref.n12 1.34375
R951 vref vref.n5 0.4505
R952 vref vref.n6 0.32
R953 vref.n6 vref.n7 3.59375
R954 vref.n7 vref.n11 24.6087
R955 vref.n11 vref.t2 45.2912
R956 vref.n9 vref.n8 0.995
R957 vref.n10 vref.n9 0.995
R958 vref.n11 vref.n10 17.7507
R959 vref.n10 vref.t11 35.5713
R960 vref.n9 vref.t12 35.5713
R961 vref.n8 vref.t13 35.5713
R962 vref.n8 vref.t14 37.0608
R963 vref.n7 vref.t0 20.3608
R964 vref.n6 vref.t3 40.5582
R965 vref.n5 vref.t4 40.5582
R966 vref.n4 vref.t5 19.6663
R967 vref.n3 vref.t6 19.6663
R968 vref.n2 vref.t7 19.6663
R969 vref.n1 vref.t8 19.6663
R970 vref.n0 vref.t9 19.6663
R971 vref.n0 vref.t10 20.6608
R972 t1b t1b.t1 24.9832
R973 t1b t1b.t0 55.3781
R974 va.t0 va.n1 19.6407
R975 va va.n0 3.77487
R976 va va.n1 0.750875
R977 va.n1 va.t2 77.6362
R978 va.n0 va.t3 36.4132
R979 va.n0 va.t1 17.4896
R980 t1a t1a.t1 24.7807
R981 t1a t1a.t0 59.2481
R982 t2 t2.t2 25.0169
R983 t2 t2.n0 36.9939
R984 t2.n0 t2.t1 17.226
R985 t2.n0 t2.t0 23.2785
R986 vcp_n.t11 vcp_n.n0 1.64987
R987 vcp_n.n0 vcp_n.t10 23.1665
R988 vcp_n.n13 vcp_n.n0 9.71825
R989 vcp_n.n3 vcp_n.n2 0.995
R990 vcp_n.n4 vcp_n.n3 1.49
R991 vcp_n.n5 vcp_n.n4 0.995
R992 vcp_n.n13 vcp_n.n5 0.82625
R993 vcp_n.n6 vcp_n.n13 2.417
R994 vcp_n.n7 vcp_n.n6 0.608
R995 vcp_n.n8 vcp_n.n7 1.2155
R996 vcp_n.n9 vcp_n.n8 2.318
R997 vcp_n vcp_n.n9 1.20537
R998 vcp_n vcp_n.n12 40.4656
R999 vcp_n.n11 vcp_n.n10 8.078
R1000 vcp_n.n12 vcp_n.n11 2.5205
R1001 vcp_n.n12 vcp_n.t1 17.046
R1002 vcp_n.n11 vcp_n.t4 17.046
R1003 vcp_n.n10 vcp_n.t3 17.046
R1004 vcp_n.n10 vcp_n.t2 19.566
R1005 vcp_n.n9 vcp_n.t0 20.5858
R1006 vcp_n.n8 vcp_n.t6 15.0123
R1007 vcp_n.n7 vcp_n.t7 15.0123
R1008 vcp_n.n6 vcp_n.t5 15.0123
R1009 vcp_n.n5 vcp_n.t12 32.6913
R1010 vcp_n.n4 vcp_n.t13 32.6913
R1011 vcp_n.n3 vcp_n.t14 32.6913
R1012 vcp_n.n2 vcp_n.t15 32.6913
R1013 vcp_n.n2 vcp_n.n1 10.8815
R1014 vcp_n.n1 vcp_n.t9 1.64987
R1015 vcp_n.n1 vcp_n.t8 23.1665
R1016 vbt.n9 vbt.t4 11.4074
R1017 vbt.n1 vbt.n0 0.788
R1018 vbt.n2 vbt.n1 0.788
R1019 vbt.n3 vbt.n2 1.283
R1020 vbt.n4 vbt.n3 0.788
R1021 vbt.n5 vbt.n4 0.788
R1022 vbt.n9 vbt.n5 0.788
R1023 vbt vbt.n9 7.35463
R1024 vbt vbt.n8 55.3741
R1025 vbt.n7 vbt.n6 10.598
R1026 vbt.n8 vbt.n7 2.0255
R1027 vbt.n8 vbt.t0 16.686
R1028 vbt.n7 vbt.t10 16.686
R1029 vbt.n6 vbt.t9 16.686
R1030 vbt.n6 vbt.t11 19.206
R1031 vbt.n5 vbt.t8 11.4074
R1032 vbt.n4 vbt.t7 11.4074
R1033 vbt.n3 vbt.t3 11.4074
R1034 vbt.n2 vbt.t2 11.4074
R1035 vbt.n1 vbt.t6 11.4074
R1036 vbt.n0 vbt.t5 11.4074
R1037 vbt.n0 vbt.t1 12.1949
R1038 vbp.t1 vbp.n0 15.3229
R1039 vbp vbp.n0 0.921875
R1040 vbp vbp.n15 14.5074
R1041 vbp.n15 vbp.t2 35.1743
R1042 vbp.n2 vbp.n1 1.508
R1043 vbp.n3 vbp.n2 1.013
R1044 vbp.n4 vbp.n3 1.013
R1045 vbp.n5 vbp.n4 1.508
R1046 vbp.n7 vbp.n5 0.84425
R1047 vbp.n8 vbp.n7 1.18175
R1048 vbp.n9 vbp.n8 1.508
R1049 vbp.n10 vbp.n9 1.013
R1050 vbp.n11 vbp.n10 1.013
R1051 vbp.n12 vbp.n11 1.508
R1052 vbp.n13 vbp.n12 1.013
R1053 vbp.n14 vbp.n13 1.013
R1054 vbp.n15 vbp.n14 33.3838
R1055 vbp.n14 vbp.t5 27.079
R1056 vbp.n13 vbp.t6 27.079
R1057 vbp.n12 vbp.t7 27.079
R1058 vbp.n11 vbp.t8 27.079
R1059 vbp.n10 vbp.t9 27.079
R1060 vbp.n9 vbp.t10 27.079
R1061 vbp.n8 vbp.t11 27.079
R1062 vbp.n7 vbp.n6 15.0305
R1063 vbp.n6 vbp.t4 1.83599
R1064 vbp.n6 vbp.t3 12.2744
R1065 vbp.n5 vbp.t12 27.079
R1066 vbp.n4 vbp.t13 27.079
R1067 vbp.n3 vbp.t14 27.079
R1068 vbp.n2 vbp.t15 27.079
R1069 vbp.n1 vbp.t16 27.079
R1070 vbp.n1 vbp.t17 28.0915
R1071 vbp.n0 vbp.t0 22.037
R1072 up_s.t0 up_s.n0 14.0207
R1073 up_s up_s.n0 60.9541
R1074 up_s up_s.n1 3.12463
R1075 up_s.n1 up_s.t2 13.806
R1076 up_s.n1 up_s.t1 14.481
R1077 up_s.n0 up_s.t3 13.0082
R1078 vcp_p.t3 vcp_p.n0 3.11042
R1079 vcp_p.n0 vcp_p.t2 50.5496
R1080 vcp_p.n6 vcp_p.n0 9.71825
R1081 vcp_p.n3 vcp_p.n2 1.013
R1082 vcp_p.n6 vcp_p.n3 1.33925
R1083 vcp_p.n5 vcp_p.n6 34.2793
R1084 vcp_p vcp_p.n5 25.4514
R1085 vcp_p vcp_p.t6 25.5971
R1086 vcp_p.n5 vcp_p.n4 23.7852
R1087 vcp_p.n4 vcp_p.t5 11.5476
R1088 vcp_p.n4 vcp_p.t4 15.0261
R1089 vcp_p.n3 vcp_p.t7 60.139
R1090 vcp_p.n2 vcp_p.t8 60.139
R1091 vcp_p.n2 vcp_p.n1 10.8995
R1092 vcp_p.n1 vcp_p.t1 3.11042
R1093 vcp_p.n1 vcp_p.t0 50.5496
C0 va pll_en 0.16696f
C1 vs vi 0.63187f
C2 vcl vcp_n 0.71459f
C3 up_b pfd_up 4.79731f
C4 vdump vbt 1.90382f
C5 r5 r1 0.35907f
C6 va vdd 1.28488f
C7 bias_ref vcp_n 0.01134f
C8 vs t1c 0
C9 pfd_dn cp_trim1 0.07807f
C10 vnt vbp 0.00573f
C11 vdd r3 0.42478f
C12 dn_b vdump 0.69544f
C13 up_s cp_trim1 0.04398f
C14 vs t1b 0
C15 a_13800_12098# a_15000_12098# 0.00585f
C16 vs t2 0
C17 r5 r4 0.56361f
C18 pfd_dn up_s 0.21386f
C19 vbh pll_en 0
C20 vctrl vi 1.00494f
C21 a_13200_19550# vfilt 0.09187f
C22 pfd_up vfilt 2.62965f
C23 vbh vdd 4.21052f
C24 vbn_vco vs 0.0529f
C25 r2 r3 0.5427f
C26 vcl dn_s 0
C27 vdump en_b 0.36868f
C28 vst vctrl 0.25615f
C29 vctrl t1c 0.06547f
C30 vctrl t1b 0.03178f
C31 cp_trim0 t1c 1.30308f
C32 vctrl t2 0.03527f
C33 vbt vcp_p 0.19693f
C34 t1b cp_trim0 0.05636f
C35 vctrl vbl 6.4837f
C36 t2 cp_trim0 3.57794f
C37 vcl pll_en 1.94211f
C38 up_b vref 0.23265f
C39 dn_b vcp_p 0.13657f
C40 pll_en a_12600_12098# 0.00109f
C41 bias_ref pll_en 0.10573f
C42 vbn_vco vctrl 0.2681f
C43 vcl vdd 0.36941f
C44 vbp vdump 0.6054f
C45 bias_ref vdd 1.05675f
C46 vctrl nb 0.05431f
C47 vs va 0.22142f
C48 en_b vcp_p 0.21476f
C49 pfd_dn vi 0
C50 up_s vi 0
C51 vfilt vref 8.57295f
C52 vctrl a_4200_12098# 0.00482f
C53 cp_trim1 t1c 0.19875f
C54 pfd_dn vst 0.09192f
C55 t1b cp_trim1 3.48909f
C56 vco_out vctrl 0
C57 pfd_dn t1c 0.06526f
C58 vst up_s 0.03829f
C59 cp_trim1 t2 3.16382f
C60 pfd_dn t1b 0.03182f
C61 vs a_14400_19550# 0.00168f
C62 t1a vbt 0.08464f
C63 a_11400_12098# vfilt 0.02959f
C64 up_s t1b 0.07239f
C65 vbt vbp_vco 0.25097f
C66 pfd_dn t2 0.0356f
C67 up_s t2 0.87416f
C68 up_b vfilt 2.53803f
C69 t1a dn_b 3.47496f
C70 dn_b vbp_vco 0.24978f
C71 vnt vref 1.62742f
C72 va vctrl 2.21895f
C73 vbp_vco r1 0.02988f
C74 vbp vcp_p 5.04214f
C75 a_13800_12098# a_12600_12098# 0.00585f
C76 va cp_trim0 0.04427f
C77 pfd_dn vbn_vco 0.12369f
C78 vbn_vco up_s 0.12369f
C79 pfd_up vdump 2.66583f
C80 a_13200_19550# a_12000_19550# 0.00585f
C81 r4 vbp_vco 0.03255f
C82 vctrl a_14400_19550# 0.00289f
C83 en_b vbp_vco 1.13169f
C84 t1a en_b 0.11315f
C85 a_6000_12098# a_4200_12098# 0.00234f
C86 vctrl vbh 4.19048f
C87 vcl a_10800_19550# 0.00132f
C88 vbt vcp_n 1.14217f
C89 vs vcl 4.10167f
C90 bias_ref a_10800_19550# 0.01034f
C91 vs bias_ref 2.82208f
C92 dn_b vcp_n 0.11855f
C93 vst vi 0.15249f
C94 va cp_trim1 0.04398f
C95 pfd_dn va 0.05123f
C96 pfd_up vcp_p 0.1129f
C97 up_s va 4.2646f
C98 t1a vbp 1.29955f
C99 vbp vbp_vco 0.35286f
C100 vi vbl 0.04207f
C101 vcl vctrl 0.22182f
C102 vdump vref 4.09415f
C103 t1b t1c 0.70676f
C104 en_b vcp_n 0.61516f
C105 t2 t1c 0.07621f
C106 vcl cp_trim0 0.19176f
C107 t1b t2 1.6636f
C108 a_12000_19550# vref 0.00106f
C109 a_7800_18230# vfilt 0.10189f
C110 vctrl bias_ref 0.13449f
C111 vbn_vco vi 0.12248f
C112 bias_ref cp_trim0 0.00247f
C113 dn_b dn_s 0.03125f
C114 up_b vdump 0.17918f
C115 pfd_dn vbh 0
C116 vst vbn_vco 0.03569f
C117 vbt pll_en 0.18756f
C118 dn_b pll_en 0.27593f
C119 vbt vdd 10.8341f
C120 vbp vcp_n 8.256f
C121 vfilt a_2000_12098# 0.04747f
C122 pll_en r1 0.00709f
C123 t1a pfd_up 0.29054f
C124 pfd_up vbp_vco 0.29529f
C125 vcp_p vref 0.47805f
C126 dn_b vdd 0.36927f
C127 vdump vfilt 3.14f
C128 vcl cp_trim1 0.21458f
C129 r4 pll_en 0.01395f
C130 pfd_dn vcl 0.18225f
C131 a_12000_19550# vfilt 0.09187f
C132 up_s vcl 0.08986f
C133 vdd r1 0.37029f
C134 bias_ref cp_trim1 0.00516f
C135 pll_en en_b 3.80209f
C136 up_b vcp_p 0.10688f
C137 va vi 0.22778f
C138 pfd_dn bias_ref 0.10304f
C139 up_s bias_ref 0.04496f
C140 r4 vdd 0.39172f
C141 vst va 0.16628f
C142 vdd en_b 3.3467f
C143 va t1b 2.07934f
C144 vnt vdump 0.95014f
C145 va t2 0.1324f
C146 r2 r1 0.40043f
C147 vco_out nb 0.59878f
C148 vbh vi 0.09345f
C149 pfd_up vcp_n 0.09611f
C150 vcp_p vfilt 8.05097f
C151 r2 r4 0.01867f
C152 vbp pll_en 2.5856f
C153 t1a vref 0.23043f
C154 vbp_vco vref 0.13806f
C155 vbn_vco va 0.12607f
C156 vbn_vco r3 0.06267f
C157 vbp vdd 24.9438f
C158 vbh vbl 0.49955f
C159 up_b t1a 0.09881f
C160 up_b vbp_vco 0.24995f
C161 a_13800_12098# en_b 0.00374f
C162 vs vbt 0.04884f
C163 vs dn_b 0.04035f
C164 vcl t1c 0
C165 vcl t1b 0.1954f
C166 vcl t2 0.20531f
C167 a_7200_12098# vfilt 0.02959f
C168 vref vcp_n 0.22767f
C169 bias_ref t1c 0.01673f
C170 pfd_up pll_en 0.27016f
C171 t1a vfilt 3.74692f
C172 vbp_vco vfilt 0.01454f
C173 vctrl vbt 3.7475f
C174 vs en_b 0.62155f
C175 a_13800_12098# vbp 0
C176 vbt cp_trim0 0.04427f
C177 dn_b vctrl 0.1384f
C178 pfd_up vdd 1.087f
C179 up_b vcp_n 0.09708f
C180 dn_b cp_trim0 0.07842f
C181 vctrl r1 0.00156f
C182 a_11400_12098# a_10200_12098# 0.00585f
C183 r4 vctrl 0.00579f
C184 dn_s vref 0.00898f
C185 bias_ref nb 0
C186 vctrl en_b 3.8083f
C187 vdump vcp_p 5.69911f
C188 vs vbp 0.154f
C189 a_1200_19730# vfilt 0.16254f
C190 en_b cp_trim0 0.11308f
C191 vfilt vcp_n 9.83485f
C192 vco_out bias_ref 0.04772f
C193 pll_en vref 0.41611f
C194 vbt cp_trim1 0.04398f
C195 pfd_dn vbt 0.08866f
C196 a_10200_12098# vfilt 0.02959f
C197 up_s vbt 3.9404f
C198 dn_b cp_trim1 0.07838f
C199 vcl va 0.08358f
C200 pfd_dn dn_b 9.22973f
C201 up_s dn_b 0.1377f
C202 vdd vref 0.4762f
C203 up_b pll_en 0.27031f
C204 r5 vbp_vco 0.0448f
C205 va bias_ref 0.045f
C206 vbp vctrl 0.32712f
C207 vbp cp_trim0 0.02918f
C208 vcl a_14400_19550# 0.00132f
C209 up_b vdd 0.77244f
C210 dn_s vfilt 2.7126f
C211 cp_trim1 en_b 0.11308f
C212 vs a_13200_19550# 0.00168f
C213 bias_ref a_14400_19550# 0
C214 t1a vdump 0.07541f
C215 vdump vbp_vco 0.38939f
C216 pfd_dn en_b 0.25986f
C217 vs pfd_up 0.09515f
C218 up_s en_b 1.13635f
C219 vfilt a_400_12098# 0.04747f
C220 a_6600_18230# vref 0.00948f
C221 pll_en vfilt 2.38963f
C222 vdd vfilt 30.4242f
C223 vctrl a_13200_19550# 0.00289f
C224 vbp cp_trim1 0.03063f
C225 vctrl pfd_up 0.14358f
C226 pfd_dn vbp 0.10454f
C227 pfd_up cp_trim0 0.07656f
C228 up_s vbp 0.72835f
C229 dn_b vi 0
C230 vst vbt 0.09192f
C231 vcl bias_ref 0.38063f
C232 t1a vcp_p 0.31156f
C233 vcp_p vbp_vco 0.25082f
C234 vdump vcp_n 0.08851f
C235 t1b vbt 0.07242f
C236 vst dn_b 0.09192f
C237 vbt t2 0.11771f
C238 a_10800_19550# vref 0.00106f
C239 vs vref 0.55225f
C240 dn_b t1c 0.06526f
C241 a_6600_18230# vfilt 0.10189f
C242 vbt vbl 2.37982f
C243 dn_b t1b 0.03197f
C244 dn_b t2 0.03616f
C245 a_13800_12098# vfilt 0.02959f
C246 up_b vs 0.0502f
C247 en_b vi 0.16247f
C248 vbn_vco vbt 0.12369f
C249 vst en_b 1.43079f
C250 vbn_vco dn_b 0.12369f
C251 pfd_up cp_trim1 0.07714f
C252 vdump dn_s 0.32243f
C253 r5 pll_en 0.17497f
C254 t1b en_b 0.11326f
C255 pfd_dn pfd_up 3.21485f
C256 vctrl vref 0.70441f
C257 en_b t2 0.11314f
C258 up_s pfd_up 0.2114f
C259 a_400_12098# a_2000_12098# 0.00585f
C260 vcp_p vcp_n 5.19512f
C261 vbn_vco r1 0.10187f
C262 cp_trim0 vref 0.20263f
C263 r5 vdd 0.84038f
C264 vdump pll_en 0.36336f
C265 a_10800_19550# vfilt 0.09186f
C266 vbn_vco r4 0.03827f
C267 a_7800_18230# a_6600_18230# 0.00585f
C268 up_b vctrl 2.46068f
C269 vs vfilt 8.06781f
C270 nb r1 0
C271 vbn_vco en_b 1.34962f
C272 vbp vi 0.13419f
C273 up_b cp_trim0 0.08985f
C274 r4 nb 0.0025f
C275 vdump vdd 3.05092f
C276 vst vbp 0.61997f
C277 vbp t1b 1.28638f
C278 va vbt 4.73054f
C279 en_b a_15000_12098# 0.00353f
C280 vbp t2 2.55606f
C281 dn_b va 0
C282 dn_s vcp_p 1.08144f
C283 vctrl vfilt 12.3242f
C284 cp_trim1 vref 0.1982f
C285 cp_trim0 vfilt 3.24502f
C286 pfd_dn vref 0.24922f
C287 t1a vcp_n 0.48869f
C288 up_s vref 0.04904f
C289 vbn_vco vbp 0.24329f
C290 r3 r1 0.20322f
C291 pll_en vcp_p 2.60986f
C292 vbh vbt 0.25043f
C293 up_b cp_trim1 0.15662f
C294 va en_b 0.51423f
C295 r4 r3 0.27551f
C296 pfd_up vi 0
C297 pfd_dn up_b 0.1327f
C298 vbp a_15000_12098# 0
C299 dn_b vbh 0.00104f
C300 up_b up_s 3.19093f
C301 vnt vctrl 2.59472f
C302 vdd vcp_p 13.3089f
C303 vst pfd_up 0.09209f
C304 pfd_up t1c 0
C305 pfd_up t1b 0.07799f
C306 pfd_up t2 0.07723f
C307 vcl vbt 1.20127f
C308 cp_trim1 vfilt 3.23126f
C309 a_1200_19730# vcp_n 0
C310 a_6000_12098# vfilt 0.02959f
C311 pfd_dn vfilt 3.74566f
C312 up_s vfilt 1.09241f
C313 va vbp 3.21616f
C314 dn_b vcl 0.18203f
C315 bias_ref vbt 0.04507f
C316 vs vdump 0.15159f
C317 vbn_vco pfd_up 0.12381f
C318 t1a pll_en 0.0832f
C319 pll_en vbp_vco 2.59827f
C320 dn_b bias_ref 0.05016f
C321 a_12000_19550# a_10800_19550# 0.00585f
C322 vs a_12000_19550# 0.00168f
C323 a_13800_12098# vcp_p 0
C324 r5 vctrl 0.07107f
C325 vi vref 3.67725f
C326 vdd vbp_vco 7.066f
C327 t1a vdd 0.96471f
C328 vcl en_b 0.21271f
C329 vst vref 1.66334f
C330 vctrl a_2000_12098# 0.00842f
C331 t1c vref 0
C332 t1b vref 0.20495f
C333 up_b vi 0
C334 vctrl vdump 16.8389f
C335 dn_s vcp_n 1.31867f
C336 bias_ref en_b 0.05077f
C337 t2 vref 0.20491f
C338 vdump cp_trim0 0.06411f
C339 vref vbl 0.02086f
C340 vctrl a_12000_19550# 0.00289f
C341 vst up_b 0.10323f
C342 up_b t1c 0.00874f
C343 vs vcp_p 0.03675f
C344 r2 vbp_vco 0.03534f
C345 up_b t1b 2.60305f
C346 va pfd_up 0.04936f
C347 up_b t2 0.19121f
C348 pll_en vcp_n 0.07745f
C349 vbn_vco vref 0.59189f
C350 vcl vbp 0.09496f
C351 a_13200_19550# a_14400_19550# 0.00585f
C352 vdd vcp_n 5.39367f
C353 vbn_vco up_b 0.12369f
C354 vbp a_12600_12098# 0.00185f
C355 vbp bias_ref 0.0396f
C356 vst vfilt 0.0014f
C357 vfilt t1c 0.73568f
C358 vbh pfd_up 0.02874f
C359 vctrl vcp_p 0.15148f
C360 t1b vfilt 3.61933f
C361 vdump cp_trim1 0.07768f
C362 vcp_p cp_trim0 0.09913f
C363 t2 vfilt 4.21524f
C364 pfd_dn vdump 0.18478f
C365 up_s vdump 0.37424f
C366 vnt vi 0.03813f
C367 t1a vs 0
C368 vs vbp_vco 0.27025f
C369 vst vnt 0
C370 va vref 0.77429f
C371 vbn_vco vfilt 0.01648f
C372 vcl a_13200_19550# 0.00132f
C373 vcl pfd_up 0.28309f
C374 vnt vbl 0.17164f
C375 a_15000_12098# vfilt 0.02959f
C376 up_b va 0.17458f
C377 vref a_14400_19550# 0.00106f
C378 bias_ref a_13200_19550# 0
C379 pfd_up bias_ref 0.11322f
C380 pll_en vdd 3.09598f
C381 a_4200_12098# vfilt 0.02959f
C382 cp_trim1 vcp_p 0.113f
C383 t1a vctrl 0.03574f
C384 vctrl vbp_vco 0.34585f
C385 vbh vref 0.12756f
C386 pfd_dn vcp_p 2.16442f
C387 up_s vcp_p 5.99509f
C388 t1a cp_trim0 3.16826f
C389 vs vcp_n 0.01252f
C390 up_b vbh 0.01882f
C391 dn_b vbt 0.0347f
C392 va vfilt 0.58782f
C393 vdump vi 2.99007f
C394 r2 vdd 0.38363f
C395 a_13800_12098# pll_en 0
C396 vst vdump 0.24403f
C397 vcl vref 9.3069f
C398 vdump t1c 0.06526f
C399 vfilt a_14400_19550# 0.09186f
C400 vdump t1b 0.03159f
C401 vctrl a_1200_19730# 0.01597f
C402 vdump t2 0.03503f
C403 vbt en_b 0.10539f
C404 a_8400_12098# vfilt 0.02959f
C405 bias_ref vref 2.89684f
C406 vctrl vcp_n 0.0975f
C407 r5 vbn_vco 0.02169f
C408 vnt va 0.49711f
C409 a_7200_12098# a_6000_12098# 0.00585f
C410 vdump vbl 2.06937f
C411 t1a cp_trim1 0.113f
C412 cp_trim0 vcp_n 0.63011f
C413 up_b vcl 0.22657f
C414 vs dn_s 0
C415 dn_b en_b 0.21994f
C416 pfd_dn t1a 0.05422f
C417 pfd_dn vbp_vco 0.24935f
C418 t1a up_s 0.08418f
C419 up_s vbp_vco 0.85419f
C420 a_11400_12098# a_12600_12098# 0.00585f
C421 r4 r1 0.25847f
C422 r5 nb 0.29278f
C423 up_b bias_ref 0.06044f
C424 vbn_vco vdump 0.24382f
C425 vs pll_en 0.27779f
C426 vcp_p vi 0
C427 r5 vco_out 0
C428 vnt vbh 1.9816f
C429 a_4200_12098# a_2000_12098# 0.00234f
C430 vbp vbt 8.66996f
C431 vst vcp_p 0.09192f
C432 vcp_p t1c 0.06526f
C433 vctrl dn_s 0.52018f
C434 vs vdd 2.82244f
C435 vcl vfilt 7.8094f
C436 t1b vcp_p 0.10449f
C437 dn_b vbp 0.0996f
C438 t2 vcp_p 0.14354f
C439 a_12600_12098# vfilt 0.02959f
C440 bias_ref vfilt 4.89881f
C441 vctrl a_400_12098# 0.00842f
C442 cp_trim1 vcp_n 1.08654f
C443 r5 r3 0.02161f
C444 pfd_dn vcp_n 0.17646f
C445 up_s vcp_n 0.19636f
C446 vctrl pll_en 5.22508f
C447 pll_en cp_trim0 0.0832f
C448 vbn_vco vcp_p 0.12369f
C449 va vdump 0.04207f
C450 vbp en_b 5.58365f
C451 vctrl vdd 6.09116f
C452 vdd cp_trim0 0.05536f
C453 vcp_p a_15000_12098# 0
C454 vbp_vco vi 0.78785f
C455 pfd_up vbt 0.14847f
C456 vst vbp_vco 0
C457 t1a t1c 0.06526f
C458 t1a t1b 1.68146f
C459 dn_b pfd_up 2.40289f
C460 pfd_dn dn_s 0.08801f
C461 t1a t2 2.73231f
C462 vbh vdump 2.02187f
C463 bias_ref a_7800_18230# 0.00948f
C464 cp_trim1 pll_en 0.0832f
C465 pfd_dn pll_en 0.27106f
C466 up_s pll_en 0.1392f
C467 va vcp_p 0.037f
C468 vs a_10800_19550# 0.00168f
C469 vbn_vco vbp_vco 3.08295f
C470 pfd_up en_b 2.21352f
C471 cp_trim1 vdd 0.05642f
C472 pfd_dn vdd 0.58949f
C473 up_s vdd 3.33029f
C474 vcl vdump 0.17602f
C475 t1c vcp_n 0.4099f
C476 vcl a_12000_19550# 0.00132f
C477 bias_ref vdump 0.0396f
C478 t1b vcp_n 0.1537f
C479 vbt vref 0.0427f
C480 vbh vcp_p 0
C481 t2 vcp_n 3.42614f
C482 bias_ref a_12000_19550# 0
C483 dn_b vref 0.33483f
C484 vctrl a_10800_19550# 0.00289f
C485 vs vctrl 0.60808f
C486 vs cp_trim0 0
C487 up_b vbt 2.54639f
C488 vbp pfd_up 0.11915f
C489 t1a va 2.22823f
C490 up_b dn_b 0.07278f
C491 va vbp_vco 0.208f
C492 r3 vbp_vco 0.06543f
C493 en_b vref 0.94942f
C494 vcl vcp_p 0.22344f
C495 pll_en vi 0.24853f
C496 a_7200_12098# a_8400_12098# 0.00585f
C497 bias_ref vcp_p 0.0396f
C498 vcp_p a_12600_12098# 0
C499 vctrl cp_trim0 0.06417f
C500 vbt vfilt 2.37297f
C501 vst pll_en 0.09192f
C502 up_b en_b 0.22371f
C503 t1b pll_en 0.08342f
C504 vdd vi 0.09093f
C505 dn_b vfilt 3.38839f
C506 pll_en t2 0.0833f
C507 vs cp_trim1 0
C508 pfd_dn vs 0.08543f
C509 up_s vs 0.03976f
C510 vst vdd 0.76722f
C511 vdd t1c 0.00742f
C512 t1b vdd 0.96214f
C513 va vcp_n 0.21547f
C514 vbp vref 0.53741f
C515 vdd t2 1.88179f
C516 vdd vbl 1.00568f
C517 vbn_vco pll_en 0.1473f
C518 en_b vfilt 2.66904f
C519 t1a vcl 0.20602f
C520 up_b vbp 0.10591f
C521 pll_en nb 0.46728f
C522 vctrl cp_trim1 0.0778f
C523 pll_en a_15000_12098# 0
C524 vbn_vco vdd 1.60693f
C525 a_6000_12098# vctrl 0.00279f
C526 pfd_dn vctrl 3.70147f
C527 cp_trim1 cp_trim0 0.30197f
C528 up_s vctrl 0.42997f
C529 pfd_dn cp_trim0 0.065f
C530 up_s cp_trim0 0.04427f
C531 vco_out pll_en 0.49532f
C532 vdd nb 1.33377f
C533 a_10200_12098# a_8400_12098# 0.00234f
C534 vbn_vco r2 0.13825f
C535 a_13200_19550# vref 0.00106f
C536 vco_out vdd 0.64948f
C537 vbp vfilt 7.06378f
C538 pfd_up vref 0.30548f
C539 vco_out vss 0.97205f
C540 bias_ref vss 13.71948f
C541 pll_en vss 9.30691f
C542 pfd_up vss 4.14087f
C543 vctrl vss 27.86865f
C544 cp_trim1 vss 5.82211f
C545 cp_trim0 vss 5.66925f
C546 pfd_dn vss 4.46581f
C547 vdd vss 0.48078p
C548 nb vss 1.11839f
C549 r4 vss 0.89424f
C550 r5 vss 1.32126f
C551 r3 vss 0.90183f
C552 r1 vss 1.01002f
C553 r2 vss 0.92063f
C554 vi vss 5.3274f
C555 vnt vss 6.52207f
C556 vbn_vco vss 8.25391f
C557 vst vss 5.44068f
C558 vbh vss 5.14399f
C559 vbl vss 7.45711f
C560 vbp_vco vss 6.33113f
C561 a_15000_12098# vss 0.67694f
C562 a_14400_19550# vss 0.68276f
C563 a_13800_12098# vss 0.66937f
C564 a_13200_19550# vss 0.67329f
C565 a_12600_12098# vss 0.66937f
C566 a_12000_19550# vss 0.67329f
C567 a_11400_12098# vss 0.66937f
C568 a_10800_19550# vss 0.67329f
C569 a_10200_12098# vss 0.67529f
C570 a_8400_12098# vss 0.67529f
C571 a_7800_18230# vss 0.66004f
C572 a_7200_12098# vss 0.66937f
C573 a_6600_18230# vss 0.66004f
C574 a_6000_12098# vss 0.68001f
C575 a_4200_12098# vss 0.68519f
C576 vs vss 15.14161f
C577 a_2000_12098# vss 1.08757f
C578 a_1200_19730# vss 1.08608f
C579 a_400_12098# vss 1.10395f
C580 vcl vss 16.42893f
C581 up_b vss 5.61982f
C582 en_b vss 8.38093f
C583 t1c vss 2.95009f
C584 vdump vss 12.52298f
C585 dn_b vss 14.61567f
C586 dn_s vss 3.45362f
C587 vref vss 25.59895f
C588 t1b vss 14.45813f
C589 va vss 5.36529f
C590 t1a vss 14.84638f
C591 t2 vss 11.50812f
C592 vcp_n vss 21.48068f
C593 vbt vss 13.13344f
C594 vbp vss 10.17787f
C595 up_s vss 11.44002f
C596 vcp_p vss 10.00977f
C597 vcp_p.t3 vss 4.92736f
C598 vcp_p.n0 vss 2.09167f
C599 vcp_p.t1 vss 4.92736f
C600 vcp_p.n1 vss 2.11511f
C601 vcp_p.n2 vss 1.89157f
C602 vcp_p.n3 vss 1.71512f
C603 vcp_p.t4 vss 2.37511f
C604 vcp_p.t5 vss 2.25229f
C605 vcp_p.n4 vss 3.3163f
C606 vcp_p.n5 vss 6.96616f
C607 vcp_p.t6 vss 0.62681f
C608 vcp_p.n6 vss 3.47287f
C609 up_s.t0 vss 6.52709f
C610 up_s.t3 vss 6.49436f
C611 up_s.n0 vss 8.61145f
C612 up_s.t1 vss 1.22917f
C613 up_s.t2 vss 1.20778f
C614 up_s.n1 vss 1.66761f
C615 vbp.t1 vss 1.30603f
C616 vbp.t0 vss 0.66765f
C617 vbp.n0 vss 1.6668f
C618 vbp.n1 vss 3.53423f
C619 vbp.n2 vss 1.9033f
C620 vbp.n3 vss 1.82948f
C621 vbp.n4 vss 1.9033f
C622 vbp.n5 vss 1.87814f
C623 vbp.t4 vss 1.00879f
C624 vbp.n6 vss 1.80424f
C625 vbp.n7 vss 1.21462f
C626 vbp.n8 vss 1.92846f
C627 vbp.n9 vss 1.9033f
C628 vbp.n10 vss 1.82948f
C629 vbp.n11 vss 1.9033f
C630 vbp.n12 vss 1.9033f
C631 vbp.n13 vss 1.82948f
C632 vbp.n14 vss 5.57621f
C633 vbp.t2 vss 1.69306f
C634 vbp.n15 vss 8.96424f
C635 vbt.t4 vss 1.07741f
C636 vbt.t1 vss 1.10569f
C637 vbt.t5 vss 1.42719f
C638 vbt.n0 vss 0.82258f
C639 vbt.t6 vss 1.42719f
C640 vbt.n1 vss 0.481f
C641 vbt.t2 vss 1.07741f
C642 vbt.n2 vss 0.56321f
C643 vbt.t3 vss 1.07741f
C644 vbt.n3 vss 0.56321f
C645 vbt.t7 vss 1.42719f
C646 vbt.n4 vss 0.481f
C647 vbt.t8 vss 1.42719f
C648 vbt.n5 vss 0.481f
C649 vbt.t11 vss 2.85805f
C650 vbt.t9 vss 2.62207f
C651 vbt.n6 vss 4.67198f
C652 vbt.t10 vss 2.62207f
C653 vbt.n7 vss 3.22906f
C654 vbt.t0 vss 2.62207f
C655 vbt.n8 vss 9.01628f
C656 vbt.n9 vss 1.57156f
C657 vcp_n.t11 vss 1.77368f
C658 vcp_n.n0 vss 1.08592f
C659 vcp_n.t9 vss 1.77368f
C660 vcp_n.n1 vss 1.10807f
C661 vcp_n.n2 vss 1.00246f
C662 vcp_n.n3 vss 0.85021f
C663 vcp_n.n4 vss 0.85021f
C664 vcp_n.n5 vss 0.78349f
C665 vcp_n.t5 vss 0.60492f
C666 vcp_n.n6 vss 0.65071f
C667 vcp_n.t7 vss 0.60787f
C668 vcp_n.n7 vss 0.52992f
C669 vcp_n.t6 vss 0.58647f
C670 vcp_n.n8 vss 0.70183f
C671 vcp_n.t0 vss 0.43952f
C672 vcp_n.n9 vss 0.77728f
C673 vcp_n.t2 vss 2.16294f
C674 vcp_n.t3 vss 2.03591f
C675 vcp_n.n10 vss 2.64856f
C676 vcp_n.t4 vss 2.03591f
C677 vcp_n.n11 vss 1.78929f
C678 vcp_n.t1 vss 2.03591f
C679 vcp_n.n12 vss 4.03894f
C680 vcp_n.n13 vss 0.40715f
C681 t2.t2 vss 2.12865f
C682 t2.t0 vss 3.69288f
C683 t2.t1 vss 3.00373f
C684 t2.n0 vss 10.1893f
C685 t1a.t1 vss 2.06368f
C686 t1a.t0 vss 8.81333f
C687 va.t0 vss 0.40539f
C688 va.t1 vss 1.07788f
C689 va.n0 vss 2.37322f
C690 va.t2 vss 9.99585f
C691 va.n1 vss 10.6303f
C692 t1b.t1 vss 2.04004f
C693 t1b.t0 vss 7.78333f
C694 vref.t1 vss 1.00421f
C695 vref.n0 vss 1.23694f
C696 vref.n1 vss 0.70516f
C697 vref.n2 vss 0.65335f
C698 vref.n3 vss 0.70516f
C699 vref.n4 vss 0.62155f
C700 vref.n5 vss 0.63598f
C701 vref.n6 vss 0.85784f
C702 vref.t0 vss 0.35791f
C703 vref.n7 vss 2.67316f
C704 vref.n8 vss 2.5307f
C705 vref.n9 vss 1.28585f
C706 vref.n10 vss 2.58958f
C707 vref.t2 vss 1.66972f
C708 vref.n11 vss 6.66586f
C709 vref.n12 vss 0.42438f
C710 dn_s.t0 vss 2.40248f
C711 dn_s.t3 vss 2.44555f
C712 dn_s.t2 vss 0.86826f
C713 dn_s.n0 vss 1.28541f
C714 dn_s.t1 vss 0.84442f
C715 dn_s.n1 vss 0.82742f
C716 dn_b.t1 vss 1.71346f
C717 dn_b.t0 vss 0.72993f
C718 dn_b.n0 vss 10.7016f
C719 vdump.t15 vss 0.94887f
C720 vdump.n0 vss 0.98443f
C721 vdump.t13 vss 0.94887f
C722 vdump.n1 vss 1.00968f
C723 vdump.t0 vss 0.97653f
C724 vdump.n2 vss 1.14331f
C725 vdump.t1 vss 0.97653f
C726 vdump.n3 vss 1.70249f
C727 vdump.t16 vss 5.29039f
C728 vdump.t5 vss 0.95617f
C729 vdump.n4 vss 1.05067f
C730 vdump.t7 vss 0.95617f
C731 vdump.n5 vss 1.02435f
C732 vdump.n6 vss 1.1666f
C733 vdump.t9 vss 0.95617f
C734 vdump.n7 vss 1.02435f
C735 vdump.n8 vss 0.82233f
C736 vdump.t11 vss 0.95617f
C737 vdump.n9 vss 1.02435f
C738 vdump.n10 vss 0.89578f
C739 vdump.t2 vss 1.5161f
C740 vdump.n11 vss 1.05892f
C741 vdump.t3 vss 1.5161f
C742 vdump.n12 vss 2.11668f
C743 vdump.t17 vss 1.14629f
C744 vdump.n13 vss 3.12552f
C745 vdump.n14 vss 9.8679f
C746 vdump.n15 vss 1.21541f
C747 t1c.t0 vss 1.11723f
C748 t1c.t1 vss 1.1198f
C749 en_b.t1 vss 1.11464f
C750 en_b.n0 vss 3.9218f
C751 en_b.t0 vss 2.14277f
C752 en_b.n1 vss 7.76832f
C753 en_b.n2 vss 2.23906f
C754 en_b.n3 vss 1.23522f
C755 en_b.n4 vss 1.91796f
C756 en_b.n5 vss 6.92814f
C757 up_b.t1 vss 1.44132f
C758 up_b.n0 vss 10.7492f
C759 up_b.t0 vss 9.03037f
C760 vcl.t0 vss 3.55825f
C761 vcl.t4 vss 3.67972f
C762 vcl.t1 vss 3.55825f
C763 vcl.n0 vss 2.07549f
C764 vcl.t2 vss 3.55825f
C765 vcl.n1 vss 1.0786f
C766 vcl.t3 vss 1.72393f
C767 vcl.n2 vss 5.45071f
C768 vs.t1 vss 1.36543f
C769 vs.t2 vss 1.3302f
C770 vs.n0 vss 1.46232f
C771 vs.t0 vss 7.29556f
C772 vbp_vco.t5 vss 1.08487f
C773 vbp_vco.t4 vss 1.03841f
C774 vbp_vco.n0 vss 1.17724f
C775 vbp_vco.n1 vss 0.82242f
C776 vbp_vco.t1 vss 0.56266f
C777 vbp_vco.n2 vss 0.94366f
C778 vbp_vco.n3 vss 1.4596f
C779 vbp_vco.n4 vss 1.01452f
C780 vbp_vco.t3 vss 0.56266f
C781 vbp_vco.n5 vss 0.91076f
C782 vbp_vco.n6 vss 0.50722f
C783 vbp_vco.t6 vss 0.55164f
C784 vbp_vco.n7 vss 1.45506f
C785 vbp_vco.n8 vss 0.35254f
C786 vbp_vco.n9 vss 0.35146f
C787 vbp_vco.n10 vss 0.17597f
C788 vbp_vco.n11 vss 0.35146f
C789 vbp_vco.n12 vss 0.19023f
C790 vbp_vco.n13 vss 0.35146f
C791 vbp_vco.n14 vss 0.30417f
C792 vbp_vco.n15 vss 0.36345f
C793 vbp_vco.n16 vss 1.05409f
C794 vbl.t4 vss 0.75988f
C795 vbl.t6 vss 0.83842f
C796 vbl.t5 vss 0.75988f
C797 vbl.n0 vss 0.92919f
C798 vbl.t7 vss 0.75988f
C799 vbl.n1 vss 1.19352f
C800 vbl.t1 vss 0.41254f
C801 vbl.n2 vss 0.68962f
C802 vbl.n3 vss 1.01442f
C803 vbl.n4 vss 0.59378f
C804 vbl.t3 vss 0.41254f
C805 vbl.n5 vss 0.65353f
C806 vbl.n6 vss 0.99485f
C807 vbl.n7 vss 0.56698f
C808 vbh.t5 vss 0.73686f
C809 vbh.t4 vss 0.81219f
C810 vbh.t1 vss 0.74663f
C811 vbh.n0 vss 0.89125f
C812 vbh.n1 vss 0.60244f
C813 vbh.n2 vss 1.06398f
C814 vbh.t3 vss 0.74663f
C815 vbh.n3 vss 0.89816f
C816 vbh.n4 vss 1.18591f
C817 vbh.n5 vss 0.99648f
C818 vst.t1 vss 0.97908f
C819 vst.t3 vss 0.96097f
C820 vst.n0 vss 0.68127f
C821 vst.n1 vss 0.94882f
C822 vst.t0 vss 0.36191f
C823 vst.n2 vss 1.23117f
C824 vst.t2 vss 2.67771f
C825 vbn_vco.t3 vss 1.01894f
C826 vbn_vco.t4 vss 1.0405f
C827 vbn_vco.t2 vss 0.33878f
C828 vbn_vco.n0 vss 0.56503f
C829 vbn_vco.n1 vss 0.28038f
C830 vbn_vco.t0 vss 0.3716f
C831 vbn_vco.n2 vss 0.19241f
C832 vbn_vco.n3 vss 0.9768f
C833 vbn_vco.n4 vss 0.19241f
C834 vbn_vco.n5 vss 0.15029f
C835 vbn_vco.n6 vss 0.19241f
C836 vbn_vco.n7 vss 0.15029f
C837 vbn_vco.n8 vss 0.19241f
C838 vbn_vco.n9 vss 0.24034f
C839 vbn_vco.n10 vss 0.2019f
C840 vbn_vco.n11 vss 1.0637f
C841 vbn_vco.n12 vss 1.4467f
C842 vnt.t3 vss 0.68794f
C843 vnt.t7 vss 1.0191f
C844 vnt.n0 vss 0.48797f
C845 vnt.t6 vss 1.0191f
C846 vnt.n1 vss 0.28538f
C847 vnt.t4 vss 0.66977f
C848 vnt.n2 vss 0.7169f
C849 vnt.t5 vss 0.71521f
C850 vnt.n3 vss 0.60532f
C851 vnt.t0 vss 0.71521f
C852 vnt.n4 vss 0.56847f
C853 vnt.t2 vss 0.71521f
C854 vnt.n5 vss 0.90737f
C855 vnt.t1 vss 0.75156f
C856 vi.t3 vss 1.04907f
C857 vi.t0 vss 1.51142f
C858 vi.t1 vss 0.98421f
C859 vi.n0 vss 1.26603f
C860 vi.t2 vss 0.98465f
C861 vi.n1 vss 0.44962f
C862 vi.t4 vss 1.09344f
C863 vi.n2 vss 0.91622f
C864 a_18140_1144.t2 vss 0.34962f
C865 a_18140_1144.t1 vss 0.23676f
C866 a_18140_1144.t0 vss 0.23709f
C867 a_18140_1144.n0 vss 0.33237f
C868 a_18140_1144.n1 vss 0.46214f
C869 a_18140_1144.t3 vss 0.34765f
C870 a_18824_1144.t1 vss 0.34365f
C871 a_18824_1144.t3 vss 0.23513f
C872 a_18824_1144.t2 vss 0.23545f
C873 a_18824_1144.n0 vss 0.32514f
C874 a_18824_1144.n1 vss 0.45209f
C875 a_18824_1144.t0 vss 0.34556f
C876 a_19508_1144.t2 vss 0.34126f
C877 a_19508_1144.t1 vss 0.23442f
C878 a_19508_1144.t0 vss 0.23474f
C879 a_19508_1144.n0 vss 0.322f
C880 a_19508_1144.n1 vss 0.44772f
C881 a_19508_1144.t3 vss 0.33936f
C882 a_20192_1144.t1 vss 0.33939f
C883 a_20192_1144.t3 vss 0.23504f
C884 a_20192_1144.t2 vss 0.23536f
C885 a_20192_1144.n0 vss 0.32473f
C886 a_20192_1144.n1 vss 0.45151f
C887 a_20192_1144.t0 vss 0.34132f
C888 a_20876_1144.t2 vss 0.3388f
C889 a_20876_1144.t1 vss 0.23381f
C890 a_20876_1144.t0 vss 0.23414f
C891 a_20876_1144.n0 vss 0.31931f
C892 a_20876_1144.n1 vss 0.44398f
C893 a_20876_1144.t3 vss 0.33692f
C894 r2.t0 vss 0.12805f
C895 r2.n0 vss 0.25193f
C896 r2.n1 vss 0.31988f
C897 r2.n2 vss 0.21102f
C898 r2.n3 vss 0.17095f
C899 r2.n4 vss 0.19034f
C900 r2.t1 vss 0.07207f
C901 r2.t2 vss 0.07224f
C902 r2.n5 vss 0.10121f
C903 r2.t3 vss 0.12791f
C904 r1.t0 vss 0.12603f
C905 r1.n0 vss 0.26659f
C906 r1.n1 vss 0.34201f
C907 r1.n2 vss 0.223f
C908 r1.n3 vss 0.17338f
C909 r1.n4 vss 0.20891f
C910 r1.t2 vss 0.07066f
C911 r1.t3 vss 0.07082f
C912 r1.n5 vss 0.10072f
C913 r1.t1 vss 0.12617f
C914 r3.t0 vss 0.12627f
C915 r3.n0 vss 0.24875f
C916 r3.n1 vss 0.32861f
C917 r3.n2 vss 0.20922f
C918 r3.n3 vss 0.17692f
C919 r3.n4 vss 0.19628f
C920 r3.t2 vss 0.07099f
C921 r3.t1 vss 0.07115f
C922 r3.n5 vss 0.10661f
C923 r3.t3 vss 0.12641f
C924 r5.t2 vss 0.12449f
C925 r5.n0 vss 0.24005f
C926 r5.n1 vss 0.30358f
C927 r5.n2 vss 0.20191f
C928 r5.n3 vss 0.17074f
C929 r5.n4 vss 0.19319f
C930 r5.n5 vss 0.17974f
C931 r5.n6 vss 0.18189f
C932 r5.n7 vss 0.18572f
C933 r5.n8 vss 0.14684f
C934 r5.t0 vss 0.07015f
C935 r5.t1 vss 0.07031f
C936 r5.n9 vss 0.10288f
C937 r5.t3 vss 0.12463f
C938 r4.t0 vss 0.12679f
C939 r4.n0 vss 0.25339f
C940 r4.n1 vss 0.32721f
C941 r4.n2 vss 0.21224f
C942 r4.n3 vss 0.17195f
C943 r4.n4 vss 0.1969f
C944 r4.t3 vss 0.07125f
C945 r4.t2 vss 0.07141f
C946 r4.n5 vss 0.10179f
C947 r4.t1 vss 0.12665f
C948 nb.t5 vss 0.09634f
C949 nb.n0 vss 0.18487f
C950 nb.t0 vss 0.08422f
C951 nb.t1 vss 0.08437f
C952 nb.n1 vss 0.13535f
C953 nb.t2 vss 0.084f
C954 nb.t3 vss 0.08414f
C955 nb.n2 vss 0.14001f
C956 nb.n3 vss 0.2957f
C957 nb.n4 vss 0.1887f
C958 nb.n5 vss 0.19053f
C959 nb.n6 vss 0.16438f
C960 nb.n7 vss 0.19471f
C961 nb.n8 vss 0.23022f
C962 nb.n9 vss 0.23309f
C963 nb.t4 vss 0.09615f
C964 a_18144_0.t0 vss 0.08484f
C965 a_18144_0.n0 vss 0.07675f
C966 a_18144_0.t2 vss 0.12017f
C967 a_18144_0.t3 vss 0.12094f
C968 a_18144_0.n1 vss 0.29097f
C969 a_18144_0.t1 vss 0.08511f
C970 a_18828_0.t0 vss 0.08649f
C971 a_18828_0.n0 vss 0.08186f
C972 a_18828_0.t2 vss 0.12682f
C973 a_18828_0.t1 vss 0.12764f
C974 a_18828_0.n1 vss 0.31034f
C975 a_18828_0.t3 vss 0.08622f
C976 a_19512_0.t0 vss 0.086f
C977 a_19512_0.n0 vss 0.08106f
C978 a_19512_0.t2 vss 0.12498f
C979 a_19512_0.t3 vss 0.1258f
C980 a_19512_0.n1 vss 0.30731f
C981 a_19512_0.t1 vss 0.08628f
C982 a_20196_0.t0 vss 0.12497f
C983 a_20196_0.t2 vss 0.12414f
C984 a_20196_0.t1 vss 0.08616f
C985 a_20196_0.t3 vss 0.08643f
C986 a_20196_0.n0 vss 0.08162f
C987 a_20196_0.n1 vss 0.30944f
C988 a_20880_0.t0 vss 0.08325f
C989 a_20880_0.n0 vss 0.06988f
C990 a_20880_0.t2 vss 0.11326f
C991 a_20880_0.t3 vss 0.11395f
C992 a_20880_0.n1 vss 0.26491f
C993 a_20880_0.t1 vss 0.08298f
C994 a_21564_n100.t2 vss 0.07425f
C995 a_21564_n100.n0 vss 0.05604f
C996 a_21564_n100.t1 vss 0.1302f
C997 a_21564_n100.n1 vss 0.1898f
C998 a_21564_n100.t0 vss 0.13314f
C999 a_21564_n100.t3 vss 0.07443f
C1000 vss.t44 vss 0.29709f
C1001 vss.t104 vss 0.43699f
C1002 vss.t102 vss 0.43699f
C1003 vss.t8 vss 0.29709f
C1004 vss.t10 vss 0.43638f
C1005 vss.t62 vss 0.42294f
C1006 vss.t4 vss 0.42294f
C1007 vss.t60 vss 0.42294f
C1008 vss.t12 vss 0.42294f
C1009 vss.t6 vss 0.42294f
C1010 vss.t20 vss 0.33048f
C1011 vss.t110 vss 0.33048f
C1012 vss.t125 vss 0.4822f
C1013 vss.t18 vss 0.13277f
C1014 vss.t49 vss 0.12548f
C1015 vss.t121 vss 0.12548f
C1016 vss.t127 vss 0.1068f
C1017 vss.t40 vss 0.12548f
C1018 vss.t53 vss 0.95536f
C1019 vss.t42 vss 1.06614f
C1020 vss.t119 vss 1.06614f
C1021 vss.t77 vss 1.06614f
C1022 vss.t91 vss 1.06614f
C1023 vss.t81 vss 0.95536f
C1024 vss.t84 vss 2.09957f
C1025 vss.t116 vss 0.16926f
C1026 vss.t123 vss 0.20197f
C1027 vss.t132 vss 1.4523f
C1028 vss.t69 vss 1.21036f
C1029 vss.t47 vss 1.18538f
C1030 vss.t64 vss 1.18538f
C1031 vss.t16 vss 1.18538f
C1032 vss.t1 vss 76.2319f
C1033 vss.t75 vss 0.05885f
C1034 vss.t144 vss 0.05873f
C1035 vss.t138 vss 0.05908f
C1036 vss.t136 vss 0.0589f
C1037 vss.t57 vss 0.06436f
C1038 vss.t73 vss 0.06409f
C1039 vss.t142 vss 0.06436f
C1040 vss.t98 vss 0.06409f
C1041 vss.t100 vss 0.06436f
C1042 vss.t22 vss 0.06409f
C1043 vss.t24 vss 0.06436f
C1044 vss.t93 vss 0.06409f
C1045 vss.t95 vss 0.06436f
C1046 vss.t71 vss 0.06409f
C1047 vss.t37 vss 66.1003f
C1048 vdd.t97 vss 3.05372f
C1049 vdd.n0 vss 2.55622f
C1050 vdd.t11 vss 3.18683f
C1051 vdd.n1 vss 0.09765f
C1052 vdd.t76 vss 3.18683f
C1053 vdd.n2 vss 0.09925f
C1054 vdd.n3 vss 0.28336f
C1055 vdd.t62 vss 3.05372f
C1056 vdd.n4 vss 0.08249f
C1057 vdd.t60 vss 1.31568f
C1058 vdd.n5 vss 0.21697f
C1059 vdd.t44 vss 1.28519f
C1060 vdd.n6 vss 0.21856f
C1061 vdd.n7 vss 0.28336f
C1062 vdd.t32 vss 1.28519f
C1063 vdd.n8 vss 0.20181f
C1064 vdd.t50 vss 1.28519f
C1065 vdd.n9 vss 0.21697f
C1066 vdd.t16 vss 1.28519f
C1067 vdd.n10 vss 0.21856f
C1068 vdd.n11 vss 0.28336f
C1069 vdd.t30 vss 1.28519f
C1070 vdd.n12 vss 0.20181f
C1071 vdd.t83 vss 0.89493f
C1072 vdd.n13 vss 0.21697f
C1073 vdd.t81 vss 1.28519f
C1074 vdd.n14 vss 0.21856f
C1075 vdd.n15 vss 0.28336f
C1076 vdd.t42 vss 1.28519f
C1077 vdd.n16 vss 0.20181f
C1078 vdd.t34 vss 1.28519f
C1079 vdd.n17 vss 0.21697f
C1080 vdd.t52 vss 1.28519f
C1081 vdd.n18 vss 0.21856f
C1082 vdd.n19 vss 0.28336f
C1083 vdd.t46 vss 1.28519f
C1084 vdd.n20 vss 0.20181f
C1085 vdd.t40 vss 1.28519f
C1086 vdd.n21 vss 0.21697f
C1087 vdd.t14 vss 1.28519f
C1088 vdd.n22 vss 0.21856f
C1089 vdd.n23 vss 2.77568f
C1090 vdd.n24 vss 2.77568f
C1091 vdd.n25 vss 2.77568f
C1092 vdd.n26 vss 2.77568f
C1093 vdd.n27 vss 2.77568f
C1094 vdd.t10 vss 3.57385f
C1095 vdd.t13 vss 3.61009f
C1096 vdd.t15 vss 3.11719f
C1097 vdd.t29 vss 3.11719f
C1098 vdd.t31 vss 3.11719f
C1099 vdd.t33 vss 3.57385f
C1100 vdd.t39 vss 3.57385f
C1101 vdd.t41 vss 3.11719f
C1102 vdd.t43 vss 3.11719f
C1103 vdd.t45 vss 3.11719f
C1104 vdd.t49 vss 3.57385f
C1105 vdd.t51 vss 3.11719f
C1106 vdd.t59 vss 3.57385f
C1107 vdd.t61 vss 3.11719f
C1108 vdd.t75 vss 3.11719f
C1109 vdd.t80 vss 3.11719f
C1110 vdd.t82 vss 3.57385f
C1111 vdd.t96 vss 3.61715f
C1112 vdd.n28 vss 3.29527f
C1113 vdd.n29 vss 1.06566f
C1114 vdd.n30 vss 0.18484f
C1115 vdd.t9 vss 0.61538f
C1116 vdd.n31 vss 0.0738f
C1117 vdd.t7 vss 0.74885f
C1118 vdd.n32 vss 0.08896f
C1119 vdd.t18 vss 0.74885f
C1120 vdd.n33 vss 0.09056f
C1121 vdd.n34 vss 0.1174f
C1122 vdd.t79 vss 0.61538f
C1123 vdd.n35 vss 0.0738f
C1124 vdd.t72 vss 0.3287f
C1125 vdd.n36 vss 0.09377f
C1126 vdd.t94 vss 0.54455f
C1127 vdd.n37 vss 0.08362f
C1128 vdd.t110 vss 0.17888f
C1129 vdd.n38 vss 0.09652f
C1130 vdd.t112 vss 0.17121f
C1131 vdd.n39 vss 0.09811f
C1132 vdd.n40 vss 0.10725f
C1133 vdd.t114 vss 0.19876f
C1134 vdd.n41 vss 0.0786f
C1135 vdd.t37 vss 2.10196f
C1136 vdd.n42 vss 0.1609f
C1137 vdd.n43 vss 0.17977f
C1138 vdd.t66 vss 0.31419f
C1139 vdd.n44 vss 0.06737f
C1140 vdd.t70 vss 0.36479f
C1141 vdd.n45 vss 0.06484f
C1142 vdd.t68 vss 0.36479f
C1143 vdd.n46 vss 0.06643f
C1144 vdd.n47 vss 0.10855f
C1145 vdd.t64 vss 0.31419f
C1146 vdd.n48 vss 0.05852f
C1147 vdd.t118 vss 0.17198f
C1148 vdd.n49 vss 0.09941f
C1149 vdd.n50 vss 0.62693f
C1150 vdd.n51 vss 0.67797f
C1151 vdd.n52 vss 0.729f
C1152 vdd.n53 vss 0.55343f
C1153 vdd.n54 vss 1.06075f
C1154 vdd.n55 vss 0.57589f
C1155 vdd.t5 vss 0.71453f
C1156 vdd.t6 vss 0.91869f
C1157 vdd.t8 vss 0.8013f
C1158 vdd.t12 vss 0.71453f
C1159 vdd.t17 vss 0.8013f
C1160 vdd.t19 vss 0.69004f
C1161 vdd.t20 vss 0.64818f
C1162 vdd.t21 vss 0.64818f
C1163 vdd.t22 vss 0.64818f
C1164 vdd.t36 vss 1.53012f
C1165 vdd.t63 vss 0.5604f
C1166 vdd.t65 vss 0.61246f
C1167 vdd.t67 vss 0.57163f
C1168 vdd.t69 vss 0.61246f
C1169 vdd.t71 vss 0.65533f
C1170 vdd.t73 vss 0.61246f
C1171 vdd.t78 vss 0.71351f
C1172 vdd.t88 vss 0.71453f
C1173 vdd.t89 vss 0.57163f
C1174 vdd.t93 vss 0.56754f
C1175 vdd.t100 vss 0.71453f
C1176 vdd.t109 vss 0.56754f
C1177 vdd.t111 vss 0.53794f
C1178 vdd.t113 vss 1.03403f
C1179 vdd.t117 vss 0.58691f
C1180 vdd.n56 vss 0.82071f
C1181 vdd.n57 vss 0.27766f
C1182 vdd.n58 vss 1.47174f
C1183 vdd.n59 vss 0.51874f
C1184 vdd.n60 vss 0.04095f
C1185 vdd.n61 vss 0.51874f
C1186 vdd.n62 vss 0.04095f
C1187 vdd.n63 vss 0.49453f
C1188 vdd.n64 vss 0.03705f
C1189 vdd.t0 vss 0.14085f
C1190 vdd.t1 vss 0.57662f
C1191 vdd.t3 vss 0.17607f
C1192 vdd.t23 vss 0.57662f
C1193 vdd.t25 vss 0.17607f
C1194 vdd.t27 vss 0.68006f
C1195 vdd.t35 vss 0.5282f
C1196 vdd.t38 vss 0.22449f
C1197 vdd.t47 vss 0.65585f
C1198 vdd.t53 vss 1.3161f
C1199 vdd.t55 vss 0.65585f
C1200 vdd.t57 vss 0.59643f
C1201 vdd.t74 vss 0.73748f
C1202 vdd.t77 vss 0.22449f
C1203 vdd.t84 vss 0.57662f
C1204 vdd.t86 vss 0.17607f
C1205 vdd.t90 vss 0.65585f
C1206 vdd.t92 vss 0.22449f
C1207 vdd.t95 vss 0.5282f
C1208 vdd.t98 vss 0.22449f
C1209 vdd.t99 vss 0.39615f
C1210 vdd.t101 vss 0.45997f
C1211 vdd.t103 vss 0.17607f
C1212 vdd.t105 vss 0.20468f
C1213 vdd.t107 vss 0.17607f
C1214 vdd.t119 vss 0.65585f
C1215 vdd.t115 vss 0.23549f
C1216 vdd.t121 vss 0.22449f
C1217 vdd.t4 vss 0.2577f
C1218 vdd.n65 vss 0.10634f
C1219 vdd.t2 vss 0.25802f
C1220 vdd.n66 vss 0.09545f
C1221 vdd.t108 vss 0.2577f
C1222 vdd.n67 vss 0.09483f
C1223 vdd.t106 vss 0.25802f
C1224 vdd.n68 vss 0.07518f
C1225 vdd.t87 vss 0.2577f
C1226 vdd.n69 vss 0.09545f
C1227 vdd.t85 vss 0.25802f
C1228 vdd.n70 vss 0.09545f
C1229 vdd.t104 vss 0.2577f
C1230 vdd.n71 vss 0.09545f
C1231 vdd.t102 vss 0.25802f
C1232 vdd.n72 vss 0.09545f
C1233 vdd.t26 vss 0.2577f
C1234 vdd.n73 vss 0.07483f
C1235 vdd.t24 vss 0.25802f
C1236 vdd.n74 vss 0.09518f
C1237 vdd.t28 vss 0.1115f
C1238 vdd.n75 vss 0.13499f
C1239 vdd.t48 vss 0.11165f
C1240 vdd.n76 vss 0.13499f
C1241 vdd.t120 vss 0.12344f
C1242 vdd.n77 vss 0.13242f
C1243 vdd.t116 vss 0.12363f
C1244 vdd.n78 vss 0.12056f
C1245 vdd.t58 vss 0.14949f
C1246 vdd.n79 vss 0.12795f
C1247 vdd.t56 vss 0.14961f
C1248 vdd.n80 vss 0.12795f
C1249 vdd.t91 vss 0.14949f
C1250 vdd.n81 vss 0.25998f
C1251 vdd.t54 vss 0.15792f
C1252 vdd.n82 vss 1.42434f
C1253 pfd_dn.n0 vss 11.9821f
C1254 pfd_dn.n1 vss 11.3246f
C1255 cp_trim0.n0 vss 9.24656f
C1256 cp_trim1.n0 vss 8.97157f
C1257 vctrl.t1 vss 1.02552f
C1258 vctrl.t0 vss 0.62157f
C1259 vctrl.n0 vss 2.04711f
C1260 vctrl.n1 vss 0.36227f
C1261 vctrl.n2 vss 0.20289f
C1262 vctrl.n3 vss 0.20662f
C1263 vctrl.t2 vss 0.39614f
C1264 vctrl.n4 vss 0.57722f
C1265 vctrl.n5 vss 0.39046f
C1266 vctrl.n6 vss 0.52646f
C1267 vctrl.n7 vss 0.90616f
C1268 vctrl.n8 vss 0.69655f
C1269 vctrl.n9 vss 0.12965f
C1270 vctrl.n10 vss 0.50216f
C1271 pfd_up.n0 vss 5.19255f
C1272 pfd_up.n1 vss 11.4888f
C1273 pll_en.n0 vss 0.23531f
C1274 pll_en.n1 vss 0.2185f
C1275 pll_en.n2 vss 0.21952f
C1276 pll_en.n3 vss 1.64279f
C1277 pll_en.n4 vss 2.38237f
C1278 pll_en.n5 vss 2.59013f
C1279 pll_en.n6 vss 2.45207f
C1280 pll_en.n7 vss 9.19534f
C1281 pll_en.n8 vss 2.52021f
C1282 pll_en.n9 vss 2.52473f
C1283 bias_ref.t1 vss 0.37461f
C1284 bias_ref.t0 vss 0.2152f
C1285 bias_ref.n0 vss 7.64878f
C1286 vco_out.t4 vss 0.10819f
C1287 vco_out.t1 vss 0.10832f
C1288 vco_out.n0 vss 0.26056f
C1289 vco_out.n1 vss 0.48251f
C1290 vco_out.t3 vss 0.10819f
C1291 vco_out.t2 vss 0.10832f
C1292 vco_out.n2 vss 0.2036f
C1293 vco_out.t5 vss 0.10803f
C1294 vco_out.t0 vss 0.10816f
C1295 vco_out.n3 vss 0.19908f
C1296 vco_out.n4 vss 0.26789f
.ends
