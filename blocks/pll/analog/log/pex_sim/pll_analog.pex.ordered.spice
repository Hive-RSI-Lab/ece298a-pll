* NGSPICE file created from pll_analog.ext - technology: gf180mcuD

.subckt pll_analog vco_out pfd_up pfd_dn pll_en cp_trim0 cp_trim1 vctrl bias_ref vdd vss
X0 t2.t2 vbp.t9 vdd.t87 vdd.t86 pfet_03v3 ad=2.6p pd=9.3u as=2.6p ps=9.3u w=4u l=2u
X1 a_17304_0.t0 r2.t4 r3.t1 vss.t71 nfet_03v3 ad=0.915p pd=4.22u as=0.39p ps=2.02u w=1.5u l=0.28u
X2 vbl.t3 vbl.t2 vss.t110 vss.t109 nfet_03v3 ad=1.22p pd=5.22u as=1.22p ps=5.22u w=2u l=2u
X3 vss.t87 vbn_vco.t13 a_17304_0.t1 vss.t86 nfet_03v3 ad=1.22p pd=5.22u as=0.52p ps=2.52u w=2u l=0.5u
X4 vst.t1 vref.t3 vss.t62 vss.t61 nfet_03v3 ad=3.05p pd=11.22u as=3.05p ps=11.22u w=5u l=1u
X5 vbp_vco.t2 pll_en.t4 vi.t1 vss.t43 nfet_03v3 ad=3.05p pd=11.22u as=3.05p ps=11.22u w=5u l=0.28u
X6 vcp_n.t9 vbp.t16 vdd.t68 vdd.t67 pfet_03v3 ad=2.6p pd=9.3u as=2.6p ps=9.3u w=4u l=2u
X7 a_12000_19550# a_11400_12098# vss.t51 ppolyf_u r_width=1u r_length=36.6u
X8 r3.t2 r2.t5 a_17304_0.t3 vss.t90 nfet_03v3 ad=0.39p pd=2.02u as=0.915p ps=4.22u w=1.5u l=0.28u
X9 vco_out.t3 nb.t11 vdd.t80 vdd.t79 pfet_03v3 ad=0.78p pd=3.52u as=1.95p ps=7.3u w=3u l=0.28u
X10 vst.t0 en_b.t5 vss.t24 vss.t23 nfet_03v3 ad=0.61p pd=3.22u as=0.61p ps=3.22u w=1u l=0.28u
X11 vnt.t4 vref.t6 vss.t108 vss.t107 nfet_03v3 ad=1.22p pd=5.22u as=1.22p ps=5.22u w=2u l=2u
X12 vdd.t106 vbp_vco.t15 a_17300_1144.t2 vdd.t105 pfet_03v3 ad=3.25p pd=11.3u as=1.3p ps=5.52u w=5u l=0.5u
X13 a_1200_19730# a_2000_12098# vss.t145 ppolyf_u r_width=2u r_length=37.5u
X14 a_20036_1144.t3 r4.t6 r5.t1 vdd.t75 pfet_03v3 ad=1.95p pd=7.3u as=0.78p ps=3.52u w=3u l=0.28u
X15 vdump.t3 vdump.t2 vnt.t0 vss.t16 nfet_03v3 ad=3.05p pd=11.22u as=3.05p ps=11.22u w=5u l=1u
X16 vbl.t4 vctrl.t10 vbt.t9 vdd.t102 pfet_03v3 ad=3.25p pd=11.3u as=3.25p ps=11.3u w=5u l=1u
X17 r5.t2 r4.t5 a_20040_0.t1 vss.t33 nfet_03v3 ad=0.39p pd=2.02u as=0.915p ps=4.22u w=1.5u l=0.28u
X18 a_17988_0.t2 r1.t4 r2.t1 vss.t74 nfet_03v3 ad=0.915p pd=4.22u as=0.39p ps=2.02u w=1.5u l=0.28u
X19 vbp_vco.t1 pll_en.t5 vi.t0 vss.t42 nfet_03v3 ad=3.05p pd=11.22u as=3.05p ps=11.22u w=5u l=0.28u
X20 vctrl.t0 up_b.t2 up_s.t2 vdd.t19 pfet_03v3 ad=2.6p pd=9.3u as=2.6p ps=9.3u w=4u l=0.5u
X21 vss.t100 vbn_vco.t5 a_20040_0.t2 vss.t99 nfet_03v3 ad=1.22p pd=5.22u as=0.52p ps=2.52u w=2u l=0.5u
X22 r2.t0 r1.t5 a_17988_0.t3 vss.t137 nfet_03v3 ad=0.39p pd=2.02u as=0.915p ps=4.22u w=1.5u l=0.28u
X23 nb.t1 pll_en.t3 vdd.t49 vdd.t48 pfet_03v3 ad=0.52p pd=2.52u as=1.3p ps=5.3u w=2u l=0.28u
X24 vdump.t9 vdump.t8 vbt.t0 vdd.t33 pfet_03v3 ad=3.25p pd=11.3u as=3.25p ps=11.3u w=5u l=1u
X25 vss.t77 vbn_vco.t7 a_19356_0.t1 vss.t76 nfet_03v3 ad=1.22p pd=5.22u as=0.52p ps=2.52u w=2u l=0.5u
X26 vctrl.t2 pfd_dn.t2 dn_s.t2 vss.t102 nfet_03v3 ad=1.22p pd=5.22u as=1.22p ps=5.22u w=2u l=0.5u
X27 vcp_n.t1 vbp.t8 vdd.t53 vdd.t52 pfet_03v3 ad=2.6p pd=9.3u as=2.6p ps=9.3u w=4u l=2u
X28 vdump.t13 vbl.t8 vss.t131 vss.t130 nfet_03v3 ad=1.22p pd=5.22u as=1.22p ps=5.22u w=2u l=2u
X29 a_18672_0.t2 r3.t4 r4.t2 vss.t123 nfet_03v3 ad=0.915p pd=4.22u as=0.39p ps=2.02u w=1.5u l=0.28u
X30 vss.t47 pll_en.t0 a_20724_n100.t1 vss.t46 nfet_03v3 ad=1.22p pd=5.22u as=0.52p ps=2.52u w=2u l=0.28u
X31 vcp_p.t5 vcp_n.t15 vss.t36 vss.t35 nfet_03v3 ad=6.1p pd=21.22u as=6.1p ps=21.22u w=10u l=2u
X32 vdump.t14 dn_b.t2 dn_s.t3 vss.t15 nfet_03v3 ad=1.22p pd=5.22u as=1.22p ps=5.22u w=2u l=0.5u
X33 vctrl.t3 vss.t119 cap_mim_2f0_m4m5_noshield c_width=32u c_length=32u
X34 vdump.t5 vdump.t4 vnt.t1 vss.t17 nfet_03v3 ad=3.05p pd=11.22u as=3.05p ps=11.22u w=5u l=1u
X35 a_7800_18230# a_7200_12098# vss.t98 ppolyf_u r_width=1u r_length=30u
X36 a_19356_0.t3 r5.t6 r1.t3 vss.t139 nfet_03v3 ad=0.915p pd=4.22u as=0.39p ps=2.02u w=1.5u l=0.28u
X37 vi.t4 vctrl.t4 vs.t2 vss.t118 nfet_03v3 ad=3.05p pd=11.22u as=3.05p ps=11.22u w=5u l=1u
X38 en_b.t0 pll_en.t7 vdd.t45 vdd.t44 pfet_03v3 ad=1.3p pd=5.3u as=1.3p ps=5.3u w=2u l=0.28u
X39 vdd.t55 vbp_vco.t7 a_20036_1144.t0 vdd.t54 pfet_03v3 ad=3.25p pd=11.3u as=1.3p ps=5.52u w=5u l=0.5u
X40 vbh.t4 vctrl.t7 vnt.t7 vss.t115 nfet_03v3 ad=3.05p pd=11.22u as=3.05p ps=11.22u w=5u l=1u
X41 a_18672_0.t1 vbn_vco.t10 vss.t97 vss.t96 nfet_03v3 ad=0.52p pd=2.52u as=1.22p ps=5.22u w=2u l=0.5u
X42 r1.t0 r5.t11 a_19352_1144.t0 vdd.t100 pfet_03v3 ad=0.78p pd=3.52u as=1.95p ps=7.3u w=3u l=0.28u
X43 en_b.t1 pll_en.t10 vss.t41 vss.t40 nfet_03v3 ad=0.61p pd=3.22u as=0.61p ps=3.22u w=1u l=0.28u
X44 vdd.t9 vbp_vco.t13 a_17984_1144.t0 vdd.t8 pfet_03v3 ad=3.25p pd=11.3u as=1.3p ps=5.52u w=5u l=0.5u
X45 vnt.t3 vref.t8 vss.t53 vss.t52 nfet_03v3 ad=1.22p pd=5.22u as=1.22p ps=5.22u w=2u l=2u
X46 a_13200_19550# a_13800_12098# vss.t27 ppolyf_u r_width=1u r_length=36.6u
X47 vcl.t2 a_4200_12098# vss.t85 ppolyf_u r_width=1u r_length=17.5u
X48 vbp.t0 pll_en.t8 vdd.t43 vdd.t42 pfet_03v3 ad=0.65p pd=3.3u as=0.65p ps=3.3u w=1u l=0.28u
X49 vbl.t6 vctrl.t9 vbt.t10 vdd.t103 pfet_03v3 ad=3.25p pd=11.3u as=3.25p ps=11.3u w=5u l=1u
X50 dn_s.t1 vcp_n.t14 vss.t73 vss.t72 nfet_03v3 ad=6.1p pd=21.22u as=6.1p ps=21.22u w=10u l=2u
X51 vdd.t15 nb.t8 vco_out.t1 vdd.t14 pfet_03v3 ad=1.95p pd=7.3u as=0.78p ps=3.52u w=3u l=0.28u
X52 vref.t1 en_b.t3 vss.t19 vss.t18 nfet_03v3 ad=0.61p pd=3.22u as=0.61p ps=3.22u w=1u l=0.28u
X53 vbp.t2 vst.t4 vss.t3 vss.t2 nfet_03v3 ad=0.305p pd=2.22u as=0.305p ps=2.22u w=0.5u l=2u
X54 vcl.t1 vref.t11 vss.t7 vss.t6 nfet_03v3 ad=6.1p pd=21.22u as=6.1p ps=21.22u w=10u l=2u
X55 vst.t2 en_b.t6 vdd.t99 vdd.t98 pfet_03v3 ad=0.325p pd=2.3u as=0.325p ps=2.3u w=0.5u l=10u
X56 dn_s.t0 vcp_n.t13 vss.t13 vss.t12 nfet_03v3 ad=6.1p pd=21.22u as=6.1p ps=21.22u w=10u l=2u
X57 vfilt a_2000_12098# vss.t20 ppolyf_u r_width=2u r_length=37.5u
X58 vbp.t1 va.t3 vref.t2 vss.t60 nfet_03v3 ad=2.44p pd=9.22u as=2.44p ps=9.22u w=4u l=1u
X59 vco_out.t2 nb.t9 vdd.t35 vdd.t34 pfet_03v3 ad=0.78p pd=3.52u as=1.95p ps=7.3u w=3u l=0.28u
X60 a_10800_19550# a_10200_12098# vss.t75 ppolyf_u r_width=1u r_length=36.6u
X61 r5.t0 r4.t7 a_20036_1144.t2 vdd.t109 pfet_03v3 ad=0.78p pd=3.52u as=1.95p ps=7.3u w=3u l=0.28u
X62 a_19352_1144.t3 vbp_vco.t10 vdd.t84 vdd.t83 pfet_03v3 ad=1.3p pd=5.52u as=3.25p ps=11.3u w=5u l=0.5u
X63 va.t0 en_b.t4 vss.t122 vss.t121 nfet_03v3 ad=0.61p pd=3.22u as=0.61p ps=3.22u w=1u l=0.28u
X64 vcp_n.t10 cp_trim1.t1 t2.t1 vss.t83 nfet_03v3 ad=1.22p pd=5.22u as=1.22p ps=5.22u w=2u l=0.28u
X65 vbn_vco.t4 vbp_vco.t18 vdd.t91 vdd.t90 pfet_03v3 ad=3.25p pd=11.3u as=3.25p ps=11.3u w=5u l=0.5u
X66 a_17300_1144.t1 r2.t6 r3.t3 vdd.t85 pfet_03v3 ad=1.95p pd=7.3u as=0.78p ps=3.52u w=3u l=0.28u
X67 vss.t11 a_15000_12098# vss.t10 ppolyf_u r_width=1u r_length=36.6u
X68 vbh.t5 vctrl.t6 vnt.t6 vss.t116 nfet_03v3 ad=3.05p pd=11.22u as=3.05p ps=11.22u w=5u l=1u
X69 a_6600_18230# a_6000_12098# vss.t91 ppolyf_u r_width=1u r_length=30u
X70 vbp_vco.t0 pll_en.t6 vdd.t51 vdd.t50 pfet_03v3 ad=0.65p pd=3.3u as=0.65p ps=3.3u w=1u l=0.28u
X71 up_b.t1 pfd_up.t2 vss.t126 vss.t125 nfet_03v3 ad=0.61p pd=3.22u as=0.61p ps=3.22u w=1u l=0.28u
X72 dn_b.t0 pfd_dn.t0 vdd.t97 vdd.t96 pfet_03v3 ad=1.3p pd=5.3u as=1.3p ps=5.3u w=2u l=0.28u
X73 vdump.t7 vdump.t6 vbt.t1 vdd.t18 pfet_03v3 ad=3.25p pd=11.3u as=3.25p ps=11.3u w=5u l=1u
X74 r3.t0 r2.t7 a_17300_1144.t0 vdd.t4 pfet_03v3 ad=0.78p pd=3.52u as=1.95p ps=7.3u w=3u l=0.28u
X75 vdump.t12 vbl.t9 vss.t133 vss.t132 nfet_03v3 ad=1.22p pd=5.22u as=1.22p ps=5.22u w=2u l=2u
X76 vcp_n.t2 en_b.t7 vss.t141 vss.t140 nfet_03v3 ad=0.61p pd=3.22u as=0.61p ps=3.22u w=1u l=0.28u
X77 vbl.t1 vbl.t0 vss.t136 vss.t135 nfet_03v3 ad=1.22p pd=5.22u as=1.22p ps=5.22u w=2u l=2u
X78 a_20036_1144.t1 vbp_vco.t8 vdd.t57 vdd.t56 pfet_03v3 ad=1.3p pd=5.52u as=3.25p ps=11.3u w=5u l=0.5u
X79 a_12000_19550# a_12600_12098# vss.t34 ppolyf_u r_width=1u r_length=36.6u
X80 a_20040_0.t3 vbn_vco.t6 vss.t143 vss.t142 nfet_03v3 ad=0.52p pd=2.52u as=1.22p ps=5.22u w=2u l=0.5u
X81 vdump.t15 vbh.t7 vdd.t23 vdd.t22 pfet_03v3 ad=2.6p pd=9.3u as=2.6p ps=9.3u w=4u l=2u
X82 nb.t3 r5.t9 vdd.t61 vdd.t60 pfet_03v3 ad=0.52p pd=2.52u as=1.3p ps=5.3u w=2u l=0.28u
X83 a_18668_1144.t1 r3.t6 r4.t1 vdd.t62 pfet_03v3 ad=1.95p pd=7.3u as=0.78p ps=3.52u w=3u l=0.28u
X84 vbp_vco.t4 vbp_vco.t3 vdd.t121 vdd.t120 pfet_03v3 ad=3.25p pd=11.3u as=3.25p ps=11.3u w=5u l=0.5u
X85 nb.t5 r5.t5 a_20724_n100.t3 vss.t138 nfet_03v3 ad=0.52p pd=2.52u as=1.22p ps=5.22u w=2u l=0.28u
X86 vcp_p.t4 pll_en.t9 vdd.t41 vdd.t40 pfet_03v3 ad=0.65p pd=3.3u as=0.65p ps=3.3u w=1u l=0.28u
X87 vfilt vss.t81 cap_mim_2f0_m4m5_noshield c_width=100u c_length=100u
X88 vss.t57 vbn_vco.t11 a_17988_0.t0 vss.t56 nfet_03v3 ad=1.22p pd=5.22u as=0.52p ps=2.52u w=2u l=0.5u
X89 vdd.t30 r5.t8 nb.t0 vdd.t29 pfet_03v3 ad=1.3p pd=5.3u as=0.52p ps=2.52u w=2u l=0.28u
X90 vbp_vco.t6 vbp_vco.t5 vdd.t119 vdd.t118 pfet_03v3 ad=3.25p pd=11.3u as=3.25p ps=11.3u w=5u l=0.5u
X91 a_7800_18230# a_8400_12098# vss.t21 ppolyf_u r_width=1u r_length=30u
X92 a_17300_1144.t3 vbp_vco.t16 vdd.t108 vdd.t107 pfet_03v3 ad=1.3p pd=5.52u as=3.25p ps=11.3u w=5u l=0.5u
X93 vdump.t1 vdump.t0 vbt.t3 vdd.t17 pfet_03v3 ad=3.25p pd=11.3u as=3.25p ps=11.3u w=5u l=1u
X94 a_20040_0.t0 r4.t4 r5.t3 vss.t32 nfet_03v3 ad=0.915p pd=4.22u as=0.39p ps=2.02u w=1.5u l=0.28u
X95 a_17984_1144.t3 r1.t6 r2.t3 vdd.t115 pfet_03v3 ad=1.95p pd=7.3u as=0.78p ps=3.52u w=3u l=0.28u
X96 a_14400_19550# a_13800_12098# vss.t101 ppolyf_u r_width=1u r_length=36.6u
X97 a_17304_0.t2 vbn_vco.t14 vss.t89 vss.t88 nfet_03v3 ad=0.52p pd=2.52u as=1.22p ps=5.22u w=2u l=0.5u
X98 t1a.t1 vbp.t12 vdd.t74 vdd.t73 pfet_03v3 ad=2.6p pd=9.3u as=2.6p ps=9.3u w=4u l=2u
X99 vdump.t17 pfd_up.t0 up_s.t3 vdd.t112 pfet_03v3 ad=2.6p pd=9.3u as=2.6p ps=9.3u w=4u l=0.5u
X100 vdump.t16 vbh.t6 vdd.t3 vdd.t2 pfet_03v3 ad=2.6p pd=9.3u as=2.6p ps=9.3u w=4u l=2u
X101 r2.t2 r1.t7 a_17984_1144.t2 vdd.t28 pfet_03v3 ad=0.78p pd=3.52u as=1.95p ps=7.3u w=3u l=0.28u
X102 vbh.t1 vbh.t0 vdd.t1 vdd.t0 pfet_03v3 ad=2.6p pd=9.3u as=2.6p ps=9.3u w=4u l=2u
X103 r4.t3 r3.t5 a_18672_0.t3 vss.t124 nfet_03v3 ad=0.39p pd=2.02u as=0.915p ps=4.22u w=1.5u l=0.28u
X104 vcp_p.t6 vcp_n.t12 vss.t68 vss.t67 nfet_03v3 ad=6.1p pd=21.22u as=6.1p ps=21.22u w=10u l=2u
X105 a_10800_19550# a_11400_12098# vss.t127 ppolyf_u r_width=1u r_length=36.6u
X106 vnt.t2 vref.t5 vss.t49 vss.t48 nfet_03v3 ad=1.22p pd=5.22u as=1.22p ps=5.22u w=2u l=2u
X107 a_20724_n100.t2 r5.t4 nb.t4 vss.t134 nfet_03v3 ad=1.22p pd=5.22u as=0.52p ps=2.52u w=2u l=0.28u
X108 vnt.t5 vref.t9 vss.t112 vss.t111 nfet_03v3 ad=1.22p pd=5.22u as=1.22p ps=5.22u w=2u l=2u
X109 vi.t2 vref.t10 vss.t55 vss.t54 nfet_03v3 ad=1.22p pd=5.22u as=1.22p ps=5.22u w=2u l=2u
X110 r1.t2 r5.t7 a_19356_0.t0 vss.t39 nfet_03v3 ad=0.39p pd=2.02u as=0.915p ps=4.22u w=1.5u l=0.28u
X111 vss.t5 nb.t6 vco_out.t0 vss.t4 nfet_03v3 ad=1.83p pd=7.22u as=0.78p ps=3.52u w=3u l=0.28u
X112 vdd.t25 vbp_vco.t11 a_18668_1144.t2 vdd.t24 pfet_03v3 ad=3.25p pd=11.3u as=1.3p ps=5.52u w=5u l=0.5u
X113 vi.t3 vctrl.t5 vs.t1 vss.t117 nfet_03v3 ad=3.05p pd=11.22u as=3.05p ps=11.22u w=5u l=1u
X114 up_s.t1 vcp_p.t8 vdd.t93 vdd.t92 pfet_03v3 ad=16.25p pd=51.3u as=16.25p ps=51.3u w=25u l=2u
X115 vdd.t117 nb.t10 vco_out.t5 vdd.t116 pfet_03v3 ad=1.95p pd=7.3u as=0.78p ps=3.52u w=3u l=0.28u
X116 vcp_p.t1 vcp_p.t0 vdd.t59 vdd.t58 pfet_03v3 ad=16.25p pd=51.3u as=16.25p ps=51.3u w=25u l=2u
X117 vbt.t5 vbp.t15 vdd.t21 vdd.t20 pfet_03v3 ad=2.6p pd=9.3u as=2.6p ps=9.3u w=4u l=2u
X118 a_20724_n100.t0 pll_en.t1 vss.t45 vss.t44 nfet_03v3 ad=0.52p pd=2.52u as=1.22p ps=5.22u w=2u l=0.28u
X119 a_6600_18230# a_7200_12098# vss.t144 ppolyf_u r_width=1u r_length=30u
X120 vcp_n.t11 cp_trim1.t0 t1c.t1 vss.t84 nfet_03v3 ad=1.22p pd=5.22u as=1.22p ps=5.22u w=2u l=0.28u
X121 vbh.t3 vbh.t2 vdd.t114 vdd.t113 pfet_03v3 ad=2.6p pd=9.3u as=2.6p ps=9.3u w=4u l=2u
X122 a_19356_0.t2 vbn_vco.t8 vss.t79 vss.t78 nfet_03v3 ad=0.52p pd=2.52u as=1.22p ps=5.22u w=2u l=0.5u
X123 vco_out.t4 nb.t7 vss.t114 vss.t113 nfet_03v3 ad=0.78p pd=3.52u as=1.83p ps=7.22u w=3u l=0.28u
X124 r4.t0 r3.t7 a_18668_1144.t0 vdd.t16 pfet_03v3 ad=0.78p pd=3.52u as=1.95p ps=7.3u w=3u l=0.28u
X125 a_17984_1144.t1 vbp_vco.t14 vdd.t11 vdd.t10 pfet_03v3 ad=1.3p pd=5.52u as=3.25p ps=11.3u w=5u l=0.5u
X126 vbt.t7 vbp.t7 vdd.t77 vdd.t76 pfet_03v3 ad=2.6p pd=9.3u as=2.6p ps=9.3u w=4u l=2u
X127 vcp_n.t6 vcp_n.t5 vss.t38 vss.t37 nfet_03v3 ad=6.1p pd=21.22u as=6.1p ps=21.22u w=10u l=2u
X128 vst.t3 vref.t4 vss.t129 vss.t128 nfet_03v3 ad=3.05p pd=11.22u as=3.05p ps=11.22u w=5u l=1u
X129 va.t2 vref.t7 vss.t70 vss.t69 nfet_03v3 ad=1.22p pd=5.22u as=1.22p ps=5.22u w=2u l=2u
X130 vctrl.t1 a_400_12098# vss.t22 ppolyf_u r_width=2u r_length=37.5u
X131 up_s.t0 vcp_p.t7 vdd.t7 vdd.t6 pfet_03v3 ad=16.25p pd=51.3u as=16.25p ps=51.3u w=25u l=2u
X132 vcp_n.t0 vbp.t14 vdd.t32 vdd.t31 pfet_03v3 ad=2.6p pd=9.3u as=2.6p ps=9.3u w=4u l=2u
X133 a_13200_19550# a_12600_12098# vss.t26 ppolyf_u r_width=1u r_length=36.6u
X134 vcl.t3 vref.t14 vss.t93 vss.t92 nfet_03v3 ad=6.1p pd=21.22u as=6.1p ps=21.22u w=10u l=2u
X135 vs.t0 a_4200_12098# vss.t50 ppolyf_u r_width=1u r_length=17.5u
X136 vdd.t47 pll_en.t2 nb.t2 vdd.t46 pfet_03v3 ad=1.3p pd=5.3u as=0.52p ps=2.52u w=2u l=0.28u
X137 vss.t95 vbn_vco.t9 a_18672_0.t0 vss.t94 nfet_03v3 ad=1.22p pd=5.22u as=0.52p ps=2.52u w=2u l=0.5u
X138 vcp_n.t7 vbp.t6 vdd.t64 vdd.t63 pfet_03v3 ad=2.6p pd=9.3u as=2.6p ps=9.3u w=4u l=2u
X139 vcl.t0 vref.t13 vss.t1 vss.t0 nfet_03v3 ad=6.1p pd=21.22u as=6.1p ps=21.22u w=10u l=2u
X140 vbl.t5 vctrl.t11 vbt.t8 vdd.t101 pfet_03v3 ad=3.25p pd=11.3u as=3.25p ps=11.3u w=5u l=1u
X141 vbl.t7 vctrl.t8 vbt.t11 vdd.t104 pfet_03v3 ad=3.25p pd=11.3u as=3.25p ps=11.3u w=5u l=1u
X142 vdd.t82 vbp_vco.t9 a_19352_1144.t2 vdd.t81 pfet_03v3 ad=3.25p pd=11.3u as=1.3p ps=5.52u w=5u l=0.5u
X143 vcp_p.t3 vcp_p.t2 vdd.t95 vdd.t94 pfet_03v3 ad=16.25p pd=51.3u as=16.25p ps=51.3u w=25u l=2u
X144 dn_b.t1 pfd_dn.t1 vss.t104 vss.t103 nfet_03v3 ad=0.61p pd=3.22u as=0.61p ps=3.22u w=1u l=0.28u
X145 bias_ref.t1 a_10200_12098# vss.t29 ppolyf_u r_width=1u r_length=36.6u
X146 vbn_vco.t1 vbn_vco.t0 vss.t9 vss.t8 nfet_03v3 ad=2.44p pd=9.22u as=2.44p ps=9.22u w=4u l=0.5u
X147 t2.t0 vbp.t13 vdd.t70 vdd.t69 pfet_03v3 ad=2.6p pd=9.3u as=2.6p ps=9.3u w=4u l=2u
X148 vbp.t4 vbp.t3 vdd.t39 vdd.t38 pfet_03v3 ad=2.6p pd=9.3u as=2.6p ps=9.3u w=4u l=2u
X149 a_1200_19730# a_400_12098# vss.t14 ppolyf_u r_width=2u r_length=37.5u
X150 bias_ref.t0 a_8400_12098# vss.t28 ppolyf_u r_width=1u r_length=30u
X151 a_18668_1144.t3 vbp_vco.t12 vdd.t27 vdd.t26 pfet_03v3 ad=1.3p pd=5.52u as=3.25p ps=11.3u w=5u l=0.5u
X152 vcp_n.t4 vcp_n.t3 vss.t64 vss.t63 nfet_03v3 ad=6.1p pd=21.22u as=6.1p ps=21.22u w=10u l=2u
X153 a_17988_0.t1 vbn_vco.t12 vss.t59 vss.t58 nfet_03v3 ad=0.52p pd=2.52u as=1.22p ps=5.22u w=2u l=0.5u
X154 t1b.t0 vbp.t10 vdd.t37 vdd.t36 pfet_03v3 ad=2.6p pd=9.3u as=2.6p ps=9.3u w=4u l=2u
X155 vbt.t4 vbp.t5 vdd.t13 vdd.t12 pfet_03v3 ad=2.6p pd=9.3u as=2.6p ps=9.3u w=4u l=2u
X156 vdump.t11 vdump.t10 vbt.t2 vdd.t5 pfet_03v3 ad=3.25p pd=11.3u as=3.25p ps=11.3u w=5u l=1u
X157 vbn_vco.t2 en_b.t2 vss.t31 vss.t30 nfet_03v3 ad=0.61p pd=3.22u as=0.61p ps=3.22u w=1u l=0.28u
X158 up_b.t0 pfd_up.t1 vdd.t111 vdd.t110 pfet_03v3 ad=1.3p pd=5.3u as=1.3p ps=5.3u w=2u l=0.28u
X159 vcp_n.t8 cp_trim0.t1 t1a.t0 vss.t65 nfet_03v3 ad=1.22p pd=5.22u as=1.22p ps=5.22u w=2u l=0.28u
X160 vbn_vco.t3 vbp_vco.t17 vdd.t89 vdd.t88 pfet_03v3 ad=3.25p pd=11.3u as=3.25p ps=11.3u w=5u l=0.5u
X161 vbt.t6 vbp.t17 vdd.t72 vdd.t71 pfet_03v3 ad=2.6p pd=9.3u as=2.6p ps=9.3u w=4u l=2u
X162 va.t1 vbp.t11 vdd.t66 vdd.t65 pfet_03v3 ad=2.6p pd=9.3u as=2.6p ps=9.3u w=4u l=2u
X163 vcl.t4 vref.t12 vss.t106 vss.t105 nfet_03v3 ad=6.1p pd=21.22u as=6.1p ps=21.22u w=10u l=2u
X164 a_14400_19550# a_15000_12098# vss.t80 ppolyf_u r_width=1u r_length=36.6u
X165 t1c.t0 cp_trim0.t0 t1b.t1 vss.t66 nfet_03v3 ad=1.22p pd=5.22u as=1.22p ps=5.22u w=2u l=0.28u
X166 vref.t0 a_6000_12098# vss.t25 ppolyf_u r_width=1u r_length=30u
X167 a_19352_1144.t1 r5.t10 r1.t1 vdd.t78 pfet_03v3 ad=1.95p pd=7.3u as=0.78p ps=3.52u w=3u l=0.28u
R0 vco_out vco_out.n1 8.3015
R1 vco_out.n1 vco_out.n4 5.3705
R2 vco_out.n4 vco_out.n3 6.71734
R3 vco_out.n3 vco_out.t4 0.5465
R4 vco_out.n3 vco_out.t0 0.5465
R5 vco_out.n4 vco_out.n2 6.55734
R6 vco_out.n2 vco_out.t3 0.607167
R7 vco_out.n2 vco_out.t5 0.607167
R8 vco_out.n1 vco_out.n0 11.0573
R9 vco_out.n0 vco_out.t2 0.607167
R10 vco_out.n0 vco_out.t1 0.607167
R11 bias_ref bias_ref.n0 55.8478
R12 bias_ref.n0 bias_ref.t1 21.0588
R13 bias_ref.n0 bias_ref.t0 23.8937
R14 pll_en pll_en.n0 10.1405
R15 pll_en.n0 pll_en.n9 4.7075
R16 pll_en.n9 pll_en.n8 4.81503
R17 pll_en.n8 pll_en.t0 45.7328
R18 pll_en.n8 pll_en.t1 45.5434
R19 pll_en.n9 pll_en.n7 5.35676
R20 pll_en.n7 pll_en.t2 45.7328
R21 pll_en.n7 pll_en.t3 45.5434
R22 pll_en.n4 pll_en.n3 4.5005
R23 pll_en.n0 pll_en.n6 11.7185
R24 pll_en.n6 pll_en.n4 4.1675
R25 pll_en.n6 pll_en.n5 5.1665
R26 pll_en.n5 pll_en.t4 96.3364
R27 pll_en.n5 pll_en.t5 95.7289
R28 pll_en.n2 pll_en.n1 1.121
R29 pll_en.n3 pll_en.n2 8.411
R30 pll_en.n3 pll_en.t6 44.7698
R31 pll_en.n2 pll_en.t7 57.513
R32 pll_en.n1 pll_en.t8 44.7023
R33 pll_en.n1 pll_en.t9 45.3278
R34 pll_en.n4 pll_en.t10 79.1968
R35 pfd_up.n1 pfd_up.n0 5.5535
R36 pfd_up pfd_up.n1 6.953
R37 pfd_up.n1 pfd_up.t2 87.3193
R38 pfd_up.n0 pfd_up.t0 55.1802
R39 pfd_up.n0 pfd_up.t1 64.4475
R40 vctrl vctrl.n10 17.9758
R41 vctrl.n10 vctrl.n6 3.9875
R42 vctrl.n6 vctrl.n0 11.903
R43 vctrl.n8 vctrl.n7 20.075
R44 vctrl.n9 vctrl.n8 0.77
R45 vctrl.n10 vctrl.n9 4.622
R46 vctrl.n9 vctrl.t4 40.0182
R47 vctrl.n8 vctrl.t5 40.0182
R48 vctrl.n7 vctrl.t6 40.0182
R49 vctrl.n7 vctrl.t7 42.3267
R50 vctrl.n2 vctrl.n1 1.283
R51 vctrl.n3 vctrl.n2 2.363
R52 vctrl.n5 vctrl.n3 1.4135
R53 vctrl.n4 vctrl.n5 11.0637
R54 vctrl.n6 vctrl.n4 9.27725
R55 vctrl.n5 vctrl.t3 9.23931
R56 vctrl.n4 vctrl.t0 12.186
R57 vctrl.n3 vctrl.t8 40.1274
R58 vctrl.n2 vctrl.t9 40.1274
R59 vctrl.n1 vctrl.t10 40.1274
R60 vctrl.n1 vctrl.t11 42.4899
R61 vctrl.n0 vctrl.t1 41.6334
R62 vctrl.n0 vctrl.t2 41.9313
R63 cp_trim1 cp_trim1.n0 21.9155
R64 cp_trim1.n0 cp_trim1.t0 58.7818
R65 cp_trim1.n0 cp_trim1.t1 59.9968
R66 cp_trim0 cp_trim0.n0 22.523
R67 cp_trim0.n0 cp_trim0.t0 58.4218
R68 cp_trim0.n0 cp_trim0.t1 59.6368
R69 pfd_dn pfd_dn.n0 7.133
R70 pfd_dn.n0 pfd_dn.n1 38.2212
R71 pfd_dn.n1 pfd_dn.t1 45.071
R72 pfd_dn.n1 pfd_dn.t2 47.265
R73 pfd_dn.n0 pfd_dn.t0 69.555
R74 vdd vdd.n82 21.4228
R75 vdd.n30 vdd.n29 3.6455
R76 vdd.n31 vdd.n30 0.43475
R77 vdd.n32 vdd.n31 1.013
R78 vdd.n33 vdd.n32 1.013
R79 vdd.n34 vdd.n33 1.07375
R80 vdd.n35 vdd.n34 0.43475
R81 vdd.n36 vdd.n35 1.013
R82 vdd.n37 vdd.n36 0.626
R83 vdd.n38 vdd.n37 0.626
R84 vdd.n39 vdd.n38 0.626
R85 vdd.n40 vdd.n39 0.68675
R86 vdd.n41 vdd.n40 0.43475
R87 vdd.n42 vdd.n41 0.626
R88 vdd.n43 vdd.n42 2.87375
R89 vdd.n57 vdd.n43 0.113
R90 vdd.n44 vdd.n57 1.67225
R91 vdd.n45 vdd.n44 0.6755
R92 vdd.n46 vdd.n45 0.6755
R93 vdd.n47 vdd.n46 0.73625
R94 vdd.n48 vdd.n47 0.43475
R95 vdd.n49 vdd.n48 0.6755
R96 vdd.n56 vdd.n49 0.68675
R97 vdd.n82 vdd.n56 7.7675
R98 vdd.n57 vdd.n58 24.2593
R99 vdd.n58 vdd.n65 0.344
R100 vdd.n65 vdd.n66 0.3545
R101 vdd.n66 vdd.n67 0.1595
R102 vdd.n67 vdd.n60 0.344
R103 vdd.n60 vdd.n68 0.011
R104 vdd.n68 vdd.n69 0.1595
R105 vdd.n69 vdd.n70 0.3545
R106 vdd.n70 vdd.n71 0.1595
R107 vdd.n71 vdd.n72 0.3545
R108 vdd.n72 vdd.n73 0.1595
R109 vdd.n73 vdd.n62 0.005
R110 vdd.n62 vdd.n74 0.35
R111 vdd.n74 vdd.n75 0.1595
R112 vdd.n75 vdd.n76 0.2885
R113 vdd.n76 vdd.n77 0.1595
R114 vdd.n77 vdd.n64 0.245
R115 vdd.n64 vdd.n78 0.044
R116 vdd.n78 vdd.n79 0.1595
R117 vdd.n79 vdd.n80 0.2885
R118 vdd.n80 vdd.n81 0.1595
R119 vdd.n81 vdd.t15 4.86639
R120 vdd.n81 vdd.t35 4.57839
R121 vdd.n80 vdd.t117 4.57839
R122 vdd.n79 vdd.t80 4.57839
R123 vdd.n78 vdd.t47 5.88015
R124 vdd.n77 vdd.t49 5.88015
R125 vdd.n76 vdd.t30 5.88015
R126 vdd.n75 vdd.t61 5.88015
R127 vdd.n74 vdd.t55 2.01891
R128 vdd.n73 vdd.t57 2.01891
R129 vdd.n72 vdd.t82 2.01891
R130 vdd.n71 vdd.t84 2.01891
R131 vdd.n70 vdd.t25 2.01891
R132 vdd.n69 vdd.t27 2.01891
R133 vdd.n68 vdd.t9 2.01891
R134 vdd.n67 vdd.t11 2.01891
R135 vdd.n66 vdd.t106 2.01891
R136 vdd.n65 vdd.t108 2.01891
R137 vdd.n60 vdd.n59 12.6005
R138 vdd.n62 vdd.n61 12.6005
R139 vdd.n64 vdd.n63 12.6005
R140 vdd.n58 vdd.t4 203.619
R141 vdd.t4 vdd.t107 7.37315
R142 vdd.t107 vdd.t85 46.2471
R143 vdd.t85 vdd.t105 22.1185
R144 vdd.t105 vdd.t28 153.486
R145 vdd.t10 vdd.t28 7.37315
R146 vdd.t115 vdd.t10 46.2471
R147 vdd.t8 vdd.t115 22.1185
R148 vdd.n59 vdd.t8 40.215
R149 vdd.n59 vdd.t16 113.272
R150 vdd.t16 vdd.t26 7.37315
R151 vdd.t26 vdd.t62 46.2471
R152 vdd.t62 vdd.t24 22.1185
R153 vdd.t24 vdd.t100 153.486
R154 vdd.t83 vdd.t100 7.37315
R155 vdd.t78 vdd.t83 46.2471
R156 vdd.t81 vdd.t78 22.1185
R157 vdd.n61 vdd.t81 117.963
R158 vdd.n61 vdd.t109 35.5233
R159 vdd.t109 vdd.t56 7.37315
R160 vdd.t56 vdd.t75 46.2471
R161 vdd.t75 vdd.t54 22.1185
R162 vdd.t54 vdd.t60 153.486
R163 vdd.t60 vdd.t29 53.6198
R164 vdd.t48 vdd.t29 146.113
R165 vdd.t46 vdd.t48 53.6198
R166 vdd.n63 vdd.t46 18.097
R167 vdd.n63 vdd.t79 128.017
R168 vdd.t79 vdd.t116 53.6198
R169 vdd.t116 vdd.t34 146.113
R170 vdd.t34 vdd.t14 53.6198
R171 vdd.n29 vdd.t101 438.584
R172 vdd.t101 vdd.t33 505.781
R173 vdd.t33 vdd.t18 505.781
R174 vdd.t102 vdd.t18 505.781
R175 vdd.n50 vdd.t102 411.851
R176 vdd.n50 vdd.t103 411.851
R177 vdd.t103 vdd.t5 505.781
R178 vdd.t5 vdd.t17 505.781
R179 vdd.t104 vdd.t17 505.781
R180 vdd.n51 vdd.t104 411.851
R181 vdd.n51 vdd.t0 484.104
R182 vdd.t0 vdd.t22 650.289
R183 vdd.t2 vdd.t22 650.289
R184 vdd.n52 vdd.t2 484.104
R185 vdd.n52 vdd.t113 484.104
R186 vdd.t113 vdd.t110 526.013
R187 vdd.t110 vdd.t96 401.735
R188 vdd.t40 vdd.t96 401.735
R189 vdd.t42 vdd.t40 401.735
R190 vdd.n53 vdd.t42 359.827
R191 vdd.n53 vdd.t44 359.827
R192 vdd.t44 vdd.t98 1104.05
R193 vdd.n54 vdd.t98 1062.14
R194 vdd.n54 vdd.t19 375.724
R195 vdd.t19 vdd.t112 433.526
R196 vdd.t112 vdd.t120 433.526
R197 vdd.t90 vdd.t120 433.526
R198 vdd.t88 vdd.t90 433.526
R199 vdd.n55 vdd.t88 375.724
R200 vdd.n55 vdd.t118 375.724
R201 vdd.t118 vdd.t50 417.63
R202 vdd.n56 vdd.t50 382.916
R203 vdd.n47 vdd.n55 23.09
R204 vdd.n43 vdd.n54 23.09
R205 vdd.n40 vdd.n53 23.09
R206 vdd.n34 vdd.n52 23.09
R207 vdd.n30 vdd.n51 23.09
R208 vdd.n29 vdd.n50 23.09
R209 vdd.n49 vdd.t51 18.6345
R210 vdd.n48 vdd.t119 11.2274
R211 vdd.n46 vdd.t89 11.2274
R212 vdd.n45 vdd.t91 11.2274
R213 vdd.n44 vdd.t121 11.2274
R214 vdd.n42 vdd.t99 21.6308
R215 vdd.n41 vdd.t45 13.5844
R216 vdd.n39 vdd.t43 18.6345
R217 vdd.n38 vdd.t41 18.6345
R218 vdd.n37 vdd.t97 13.5844
R219 vdd.n36 vdd.t111 13.5844
R220 vdd.n35 vdd.t114 11.646
R221 vdd.n33 vdd.t3 11.646
R222 vdd.n32 vdd.t23 11.646
R223 vdd.n31 vdd.t1 11.646
R224 vdd.n1 vdd.n0 1.013
R225 vdd.n2 vdd.n1 1.013
R226 vdd.n3 vdd.n2 1.07375
R227 vdd.n4 vdd.n3 0.43475
R228 vdd.n5 vdd.n4 1.013
R229 vdd.n6 vdd.n5 1.013
R230 vdd.n7 vdd.n6 1.07375
R231 vdd.n8 vdd.n7 0.43475
R232 vdd.n9 vdd.n8 1.013
R233 vdd.n10 vdd.n9 1.013
R234 vdd.n11 vdd.n10 1.07375
R235 vdd.n12 vdd.n11 0.43475
R236 vdd.n13 vdd.n12 1.013
R237 vdd.n14 vdd.n13 1.013
R238 vdd.n15 vdd.n14 1.07375
R239 vdd.n16 vdd.n15 0.43475
R240 vdd.n17 vdd.n16 1.013
R241 vdd.n18 vdd.n17 1.013
R242 vdd.n19 vdd.n18 1.07375
R243 vdd.n20 vdd.n19 0.43475
R244 vdd.n21 vdd.n20 1.013
R245 vdd.n22 vdd.n21 1.013
R246 vdd.n28 vdd.n22 1.07375
R247 vdd.n82 vdd.n28 37.2583
R248 vdd.n0 vdd.t58 152.468
R249 vdd.t58 vdd.t92 167.162
R250 vdd.t6 vdd.t92 167.162
R251 vdd.n23 vdd.t6 124.444
R252 vdd.n23 vdd.t94 124.444
R253 vdd.t94 vdd.t71 167.162
R254 vdd.t67 vdd.t71 167.162
R255 vdd.n24 vdd.t67 124.444
R256 vdd.n24 vdd.t20 124.444
R257 vdd.t20 vdd.t31 167.162
R258 vdd.t69 vdd.t31 167.162
R259 vdd.n25 vdd.t69 124.444
R260 vdd.n25 vdd.t73 124.444
R261 vdd.t73 vdd.t38 167.162
R262 vdd.t65 vdd.t38 167.162
R263 vdd.n26 vdd.t65 124.444
R264 vdd.n26 vdd.t36 124.444
R265 vdd.t36 vdd.t86 167.162
R266 vdd.t52 vdd.t86 167.162
R267 vdd.n27 vdd.t52 124.444
R268 vdd.n27 vdd.t76 124.444
R269 vdd.t76 vdd.t63 167.162
R270 vdd.t12 vdd.t63 167.162
R271 vdd.n28 vdd.t12 152.032
R272 vdd.n19 vdd.n27 27.59
R273 vdd.n15 vdd.n26 27.59
R274 vdd.n11 vdd.n25 27.59
R275 vdd.n7 vdd.n24 27.59
R276 vdd.n3 vdd.n23 27.59
R277 vdd.n22 vdd.t13 16.146
R278 vdd.n21 vdd.t64 16.146
R279 vdd.n20 vdd.t77 16.146
R280 vdd.n18 vdd.t53 16.146
R281 vdd.n17 vdd.t87 16.146
R282 vdd.n16 vdd.t37 16.146
R283 vdd.n14 vdd.t66 16.146
R284 vdd.n13 vdd.t39 16.146
R285 vdd.n12 vdd.t74 16.146
R286 vdd.n10 vdd.t70 16.146
R287 vdd.n9 vdd.t32 16.146
R288 vdd.n8 vdd.t21 16.146
R289 vdd.n6 vdd.t68 16.146
R290 vdd.n5 vdd.t72 16.146
R291 vdd.n4 vdd.t95 12.6482
R292 vdd.n2 vdd.t7 12.6482
R293 vdd.n1 vdd.t93 12.6482
R294 vdd.n0 vdd.t59 12.6482
R295 vss.n105 vss.n104 4.5005
R296 vss vss.n105 17.4357
R297 vss.n105 vss.n0 16.25
R298 vss.n2 vss.n1 0.43025
R299 vss.n3 vss.n2 0.995
R300 vss.n4 vss.n3 0.995
R301 vss.n5 vss.n4 1.06025
R302 vss.n6 vss.n5 0.43025
R303 vss.n7 vss.n6 0.995
R304 vss.n103 vss.n7 0.14225
R305 vss.n8 vss.n103 0.85325
R306 vss.n9 vss.n8 1.06025
R307 vss.n10 vss.n9 0.43025
R308 vss.n11 vss.n10 0.995
R309 vss.n12 vss.n11 0.995
R310 vss.n13 vss.n12 1.06025
R311 vss.n14 vss.n13 0.43025
R312 vss.n15 vss.n14 1.7645
R313 vss.n16 vss.n15 0.77
R314 vss.n17 vss.n16 0.83525
R315 vss.n18 vss.n17 0.43025
R316 vss.n25 vss.n18 0.46175
R317 vss.n19 vss.n25 0.53375
R318 vss.n20 vss.n19 0.608
R319 vss.n21 vss.n20 0.608
R320 vss.n22 vss.n21 0.608
R321 vss.n23 vss.n22 0.72275
R322 vss.n24 vss.n23 0.43025
R323 vss.n104 vss.n24 3.15275
R324 vss.n103 vss.t119 13.992
R325 vss.n27 vss.n26 10.4005
R326 vss.n29 vss.n28 10.4005
R327 vss.n31 vss.n30 10.4005
R328 vss.n89 vss.n88 10.4005
R329 vss.n25 vss.n27 25.9993
R330 vss.n27 vss.n102 0.344
R331 vss.n102 vss.n101 0.3485
R332 vss.n101 vss.n100 0.1655
R333 vss.n100 vss.n29 0.344
R334 vss.n29 vss.n99 0.005
R335 vss.n99 vss.n98 0.1655
R336 vss.n98 vss.n97 0.3485
R337 vss.n97 vss.n96 0.1655
R338 vss.n96 vss.n95 0.3485
R339 vss.n95 vss.n94 0.1655
R340 vss.n94 vss.n31 0.005
R341 vss.n31 vss.n93 0.344
R342 vss.n93 vss.n92 0.6125
R343 vss.n92 vss.n89 0.245
R344 vss.n89 vss.n91 0.038
R345 vss.n91 vss.n90 0.1655
R346 vss.n102 vss.t89 3.85787
R347 vss.n101 vss.t87 3.85787
R348 vss.n100 vss.t59 3.85787
R349 vss.n99 vss.t57 3.85787
R350 vss.n98 vss.t97 3.85787
R351 vss.n97 vss.t95 3.85787
R352 vss.n96 vss.t79 3.85787
R353 vss.n95 vss.t77 3.85787
R354 vss.n94 vss.t143 3.85787
R355 vss.n93 vss.t100 3.85787
R356 vss.n92 vss.t45 4.97103
R357 vss.n91 vss.t47 4.97103
R358 vss.n90 vss.t114 3.59261
R359 vss.n90 vss.t5 3.87461
R360 vss.n34 vss.n26 397.483
R361 vss.n26 vss.t90 661.692
R362 vss.t90 vss.t88 25.7199
R363 vss.t88 vss.t71 161.332
R364 vss.t71 vss.t86 77.1588
R365 vss.t86 vss.t137 535.433
R366 vss.t58 vss.t137 25.7199
R367 vss.t74 vss.t58 161.332
R368 vss.t56 vss.t74 77.1588
R369 vss.n28 vss.t56 144.964
R370 vss.n28 vss.t124 390.469
R371 vss.t124 vss.t96 25.7199
R372 vss.t96 vss.t123 161.332
R373 vss.t123 vss.t94 77.1588
R374 vss.t94 vss.t39 535.433
R375 vss.t78 vss.t39 25.7199
R376 vss.t139 vss.t78 161.332
R377 vss.t76 vss.t139 77.1588
R378 vss.n30 vss.t76 416.188
R379 vss.n30 vss.t33 119.246
R380 vss.t33 vss.t142 25.7199
R381 vss.t142 vss.t32 161.332
R382 vss.t32 vss.t99 77.1588
R383 vss.t99 vss.t138 535.433
R384 vss.t138 vss.t134 187.05
R385 vss.t44 vss.t134 509.712
R386 vss.t46 vss.t44 187.05
R387 vss.n88 vss.t46 67.8063
R388 vss.n88 vss.t113 441.906
R389 vss.t113 vss.t4 187.05
R390 vss.n34 vss.t23 656.268
R391 vss.t23 vss.t121 470.005
R392 vss.t121 vss.t18 470.005
R393 vss.t8 vss.t18 489.154
R394 vss.n32 vss.t8 445.635
R395 vss.n32 vss.t30 426.486
R396 vss.t30 vss.t117 532.673
R397 vss.t117 vss.t118 595.341
R398 vss.t42 vss.t118 532.673
R399 vss.t43 vss.t42 470.005
R400 vss.n33 vss.t43 426.486
R401 vss.n33 vss.n87 760.712
R402 vss.n87 vss.t4 7786.09
R403 vss.n48 vss.n40 21.9812
R404 vss.n52 vss.n41 21.9812
R405 vss.n53 vss.n42 21.9812
R406 vss.n59 vss.n43 21.9812
R407 vss.n65 vss.t22 3.46717
R408 vss.n66 vss.t14 3.46717
R409 vss.n67 vss.t145 3.46717
R410 vss.n68 vss.t20 3.46717
R411 vss.n69 vss.t50 10.4005
R412 vss.n70 vss.t85 10.4005
R413 vss.n71 vss.t25 10.4005
R414 vss.n72 vss.t91 10.4005
R415 vss.n73 vss.t144 10.4005
R416 vss.n74 vss.t98 10.4005
R417 vss.n75 vss.t21 10.4005
R418 vss.n76 vss.t28 10.4005
R419 vss.n77 vss.t29 10.4005
R420 vss.n78 vss.t75 10.4005
R421 vss.n79 vss.t127 10.4005
R422 vss.n80 vss.t51 10.4005
R423 vss.n81 vss.t34 10.4005
R424 vss.n82 vss.t26 10.4005
R425 vss.n83 vss.t27 10.4005
R426 vss.n84 vss.t101 10.4005
R427 vss.n85 vss.t80 8.68176
R428 vss.n45 vss.t22 112.921
R429 vss.t22 vss.t63 29.3254
R430 vss.t63 vss.t14 115.49
R431 vss.t14 vss.t35 44.531
R432 vss.t35 vss.t145 100.284
R433 vss.t145 vss.t72 59.7365
R434 vss.t72 vss.t20 85.079
R435 vss.t20 vss.n40 34.756
R436 vss.n40 vss.t12 119.835
R437 vss.t50 vss.t12 80.7346
R438 vss.t50 vss.t67 79.2864
R439 vss.t85 vss.t67 29.3254
R440 vss.t85 vss.t37 130.696
R441 vss.t25 vss.t37 86.5272
R442 vss.t25 vss.t102 46.3411
R443 vss.t102 vss.t91 62.2707
R444 vss.t91 vss.n41 30.4116
R445 vss.n41 vss.t144 78.2003
R446 vss.t144 vss.t15 14.482
R447 vss.t15 vss.t98 94.1299
R448 vss.t98 vss.t65 7.60326
R449 vss.t65 vss.t83 97.7503
R450 vss.t21 vss.t83 3.25883
R451 vss.t21 vss.t66 94.492
R452 vss.t28 vss.t66 14.1199
R453 vss.t28 vss.t84 83.6309
R454 vss.n42 vss.t84 88.6994
R455 vss.n42 vss.t29 44.893
R456 vss.t29 vss.t125 43.8069
R457 vss.t125 vss.t75 64.805
R458 vss.t75 vss.t103 32.9458
R459 vss.t103 vss.t127 75.6661
R460 vss.t127 vss.t140 22.0847
R461 vss.t140 vss.t51 86.5272
R462 vss.t51 vss.t40 11.2236
R463 vss.t40 vss.t34 97.3883
R464 vss.t34 vss.t92 31.4977
R465 vss.t92 vss.t26 77.1142
R466 vss.t26 vss.n43 42.7208
R467 vss.n43 vss.t27 65.8911
R468 vss.t27 vss.t0 53.9439
R469 vss.t0 vss.t101 54.668
R470 vss.t101 vss.t105 105.353
R471 vss.t80 vss.t105 3.25883
R472 vss.n85 vss.t10 9.27483
R473 vss.t10 vss.t6 48.1513
R474 vss.t6 vss.n44 119.835
R475 vss.n44 vss.n87 2677.22
R476 vss.n65 vss.n66 0.947868
R477 vss.n66 vss.n67 0.947868
R478 vss.n67 vss.n68 0.947868
R479 vss.n68 vss.n69 1.53997
R480 vss.n69 vss.n70 0.711026
R481 vss.n70 vss.n71 1.42155
R482 vss.n71 vss.n72 0.711026
R483 vss.n72 vss.n73 0.711026
R484 vss.n73 vss.n74 0.711026
R485 vss.n74 vss.n75 0.711026
R486 vss.n75 vss.n76 0.711026
R487 vss.n76 vss.n77 1.42155
R488 vss.n77 vss.n78 0.711026
R489 vss.n78 vss.n79 0.711026
R490 vss.n79 vss.n80 0.711026
R491 vss.n80 vss.n81 0.711026
R492 vss.n81 vss.n82 0.711026
R493 vss.n82 vss.n83 0.711026
R494 vss.n83 vss.n84 0.711026
R495 vss.n84 vss.n85 1.59954
R496 vss.n86 vss.n65 36.2627
R497 vss.n0 vss.n86 12.308
R498 vss.n86 vss.t11 19.9788
R499 vss.n64 vss.n44 21.9812
R500 vss.n46 vss.n45 0.995
R501 vss.n47 vss.n46 0.995
R502 vss.n48 vss.n47 1.06025
R503 vss.n49 vss.n48 0.43025
R504 vss.n50 vss.n49 0.995
R505 vss.n51 vss.n50 0.995
R506 vss.n52 vss.n51 1.71725
R507 vss.n53 vss.n52 3.5825
R508 vss.n54 vss.n53 0.43025
R509 vss.n55 vss.n54 0.608
R510 vss.n56 vss.n55 0.608
R511 vss.n57 vss.n56 0.608
R512 vss.n58 vss.n57 0.608
R513 vss.n59 vss.n58 1.06025
R514 vss.n60 vss.n59 0.43025
R515 vss.n61 vss.n60 0.995
R516 vss.n62 vss.n61 0.995
R517 vss.n64 vss.n62 1.06025
R518 vss.n63 vss.n64 5.324
R519 vss.n0 vss.n63 10.1863
R520 vss.n63 vss.t81 13.9313
R521 vss.n62 vss.t7 11.1876
R522 vss.n61 vss.t106 11.1876
R523 vss.n60 vss.t1 11.1876
R524 vss.n58 vss.t93 11.1876
R525 vss.n57 vss.t41 20.4058
R526 vss.n56 vss.t141 20.4058
R527 vss.n55 vss.t104 20.4058
R528 vss.n54 vss.t126 20.4058
R529 vss.n51 vss.t38 11.1876
R530 vss.n50 vss.t68 11.1876
R531 vss.n49 vss.t13 11.1876
R532 vss.n47 vss.t73 11.1876
R533 vss.n46 vss.t36 11.1876
R534 vss.n45 vss.t64 11.1876
R535 vss.n1 vss.t115 216.732
R536 vss.t115 vss.t16 234.049
R537 vss.t16 vss.t17 234.049
R538 vss.t116 vss.t17 234.049
R539 vss.n35 vss.t116 192.304
R540 vss.n35 vss.t135 226.522
R541 vss.t135 vss.t132 302.486
R542 vss.t130 vss.t132 302.486
R543 vss.n36 vss.t130 226.522
R544 vss.n36 vss.t109 226.522
R545 vss.t109 vss.t54 302.486
R546 vss.t111 vss.t54 302.486
R547 vss.n37 vss.t111 226.522
R548 vss.n37 vss.t52 226.522
R549 vss.t52 vss.t69 302.486
R550 vss.t107 vss.t69 302.486
R551 vss.n38 vss.t107 226.522
R552 vss.n38 vss.t48 226.522
R553 vss.t48 vss.t60 268.267
R554 vss.t60 vss.t128 234.049
R555 vss.t61 vss.t128 234.049
R556 vss.n39 vss.t61 192.304
R557 vss.n39 vss.n34 212.15
R558 vss.n34 vss.t2 14.3719
R559 vss.n17 vss.n39 20.8562
R560 vss.n13 vss.n38 20.8562
R561 vss.n9 vss.n37 20.8562
R562 vss.n5 vss.n36 20.8562
R563 vss.n1 vss.n35 20.8562
R564 vss.n104 vss.n33 21.1308
R565 vss.n23 vss.n32 20.8562
R566 vss.n24 vss.t31 19.2808
R567 vss.n22 vss.t9 11.6644
R568 vss.n21 vss.t19 19.2808
R569 vss.n20 vss.t122 19.2808
R570 vss.n19 vss.t24 19.2808
R571 vss.n18 vss.t3 21.857
R572 vss.n16 vss.t62 11.2319
R573 vss.n15 vss.t129 11.2319
R574 vss.n14 vss.t49 13.7073
R575 vss.n12 vss.t108 13.7073
R576 vss.n11 vss.t70 13.7073
R577 vss.n10 vss.t53 13.7073
R578 vss.n8 vss.t112 13.7073
R579 vss.n7 vss.t55 13.7073
R580 vss.n6 vss.t110 13.7073
R581 vss.n4 vss.t131 13.7073
R582 vss.n3 vss.t133 13.7073
R583 vss.n2 vss.t136 13.7073
R584 a_20724_n100.n0 a_20724_n100.t0 0.8195
R585 a_20724_n100.t1 a_20724_n100.n0 0.8195
R586 a_20724_n100.n0 a_20724_n100.n1 7.26555
R587 a_20724_n100.n1 a_20724_n100.t3 8.48955
R588 a_20724_n100.n1 a_20724_n100.t2 8.06655
R589 a_20040_0.t0 a_20040_0.n1 9.75178
R590 a_20040_0.n1 a_20040_0.n0 7.36905
R591 a_20040_0.n0 a_20040_0.t3 0.8195
R592 a_20040_0.n0 a_20040_0.t2 0.8195
R593 a_20040_0.n1 a_20040_0.t1 9.85078
R594 a_19356_0.t0 a_19356_0.n1 9.85078
R595 a_19356_0.n1 a_19356_0.n0 7.36905
R596 a_19356_0.n0 a_19356_0.t2 0.8195
R597 a_19356_0.n0 a_19356_0.t1 0.8195
R598 a_19356_0.n1 a_19356_0.t3 9.75178
R599 a_18672_0.n0 a_18672_0.t1 0.8195
R600 a_18672_0.t0 a_18672_0.n0 0.8195
R601 a_18672_0.n0 a_18672_0.n1 7.36905
R602 a_18672_0.n1 a_18672_0.t3 9.85078
R603 a_18672_0.n1 a_18672_0.t2 9.75178
R604 a_17988_0.n0 a_17988_0.t1 0.8195
R605 a_17988_0.t0 a_17988_0.n0 0.8195
R606 a_17988_0.n0 a_17988_0.n1 7.36905
R607 a_17988_0.n1 a_17988_0.t3 9.85078
R608 a_17988_0.n1 a_17988_0.t2 9.75178
R609 a_17304_0.t0 a_17304_0.n1 9.75178
R610 a_17304_0.n1 a_17304_0.n0 7.36905
R611 a_17304_0.n0 a_17304_0.t2 0.8195
R612 a_17304_0.n0 a_17304_0.t1 0.8195
R613 a_17304_0.n1 a_17304_0.t3 9.85078
R614 nb.n0 nb.t1 0.9105
R615 nb.n0 nb.t2 0.9105
R616 nb.n9 nb.n0 11.3929
R617 nb nb.n9 0.2855
R618 nb.n7 nb.n6 4.5005
R619 nb nb.n7 0.2915
R620 nb.n7 nb.n8 10.2408
R621 nb.n8 nb.t8 58.7685
R622 nb.n8 nb.t9 58.5791
R623 nb.n6 nb.n5 5.29503
R624 nb.n5 nb.t6 58.7685
R625 nb.n5 nb.t7 58.5791
R626 nb.n6 nb.n4 4.87676
R627 nb.n4 nb.t10 58.7685
R628 nb.n4 nb.t11 58.5791
R629 nb.n9 nb.n3 5.3705
R630 nb.n3 nb.n2 7.67955
R631 nb.n2 nb.t5 0.8195
R632 nb.n2 nb.t4 0.8195
R633 nb.n3 nb.n1 6.89289
R634 nb.n1 nb.t3 0.9105
R635 nb.n1 nb.t0 0.9105
R636 r4.t0 r4.n0 0.607167
R637 r4.n0 r4.t1 0.607167
R638 r4.n1 r4.n0 6.55734
R639 r4.n1 r4.n5 8.43066
R640 r4.n5 r4.t3 1.0925
R641 r4.n5 r4.t2 1.0925
R642 r4 r4.n1 5.3705
R643 r4 r4.n4 5.3705
R644 r4.n4 r4.n3 5.05503
R645 r4.n3 r4.t4 39.215
R646 r4.n3 r4.t5 39.0255
R647 r4.n4 r4.n2 5.11676
R648 r4.n2 r4.t6 58.7685
R649 r4.n2 r4.t7 58.5791
R650 r5.t0 r5.n0 0.607167
R651 r5.n0 r5.t1 0.607167
R652 r5.n1 r5.n0 6.31734
R653 r5.n8 r5.n1 4.5005
R654 r5.n1 r5.n9 8.67066
R655 r5.n9 r5.t2 1.0925
R656 r5.n9 r5.t3 1.0925
R657 r5.n8 r5.n7 5.2145
R658 r5.n7 r5.n6 5.29503
R659 r5.n6 r5.t4 45.7328
R660 r5.n6 r5.t5 45.5434
R661 r5.n7 r5.n5 4.87676
R662 r5.n5 r5.t8 45.7328
R663 r5.n5 r5.t9 45.5434
R664 r5 r5.n8 0.2675
R665 r5 r5.n4 5.5115
R666 r5.n4 r5.n3 5.29503
R667 r5.n3 r5.t6 39.215
R668 r5.n3 r5.t7 39.0255
R669 r5.n4 r5.n2 4.87676
R670 r5.n2 r5.t11 58.5791
R671 r5.n2 r5.t10 58.7685
R672 r3.t0 r3.n0 0.607167
R673 r3.n0 r3.t3 0.607167
R674 r3.n1 r3.n0 6.31734
R675 r3.n1 r3.n5 8.67066
R676 r3.n5 r3.t2 1.0925
R677 r3.n5 r3.t1 1.0925
R678 r3 r3.n1 5.3705
R679 r3 r3.n4 5.3705
R680 r3.n4 r3.n3 5.29503
R681 r3.n3 r3.t4 39.215
R682 r3.n3 r3.t5 39.0255
R683 r3.n4 r3.n2 4.87676
R684 r3.n2 r3.t6 58.7685
R685 r3.n2 r3.t7 58.5791
R686 r1.t0 r1.n0 0.607167
R687 r1.n0 r1.t1 0.607167
R688 r1.n1 r1.n0 6.79734
R689 r1.n1 r1.n5 8.19066
R690 r1.n5 r1.t2 1.0925
R691 r1.n5 r1.t3 1.0925
R692 r1 r1.n1 5.6495
R693 r1 r1.n4 5.6555
R694 r1.n4 r1.n3 4.81503
R695 r1.n3 r1.t4 39.215
R696 r1.n3 r1.t5 39.0255
R697 r1.n4 r1.n2 5.35676
R698 r1.n2 r1.t7 58.5791
R699 r1.n2 r1.t6 58.7685
R700 r2.t2 r2.n0 0.607167
R701 r2.n0 r2.t3 0.607167
R702 r2.n1 r2.n0 6.55734
R703 r2.n1 r2.n5 8.43066
R704 r2.n5 r2.t0 1.0925
R705 r2.n5 r2.t1 1.0925
R706 r2 r2.n1 5.1365
R707 r2 r2.n4 5.1425
R708 r2.n4 r2.n3 5.05503
R709 r2.n3 r2.t4 39.215
R710 r2.n3 r2.t5 39.0255
R711 r2.n4 r2.n2 5.11676
R712 r2.n2 r2.t7 58.5791
R713 r2.n2 r2.t6 58.7685
R714 a_20036_1144.t2 a_20036_1144.n1 7.22309
R715 a_20036_1144.n1 a_20036_1144.t3 7.12409
R716 a_20036_1144.n1 a_20036_1144.n0 6.20245
R717 a_20036_1144.n0 a_20036_1144.t1 0.3645
R718 a_20036_1144.n0 a_20036_1144.t0 0.3645
R719 a_19352_1144.t1 a_19352_1144.n1 7.12409
R720 a_19352_1144.n1 a_19352_1144.t0 7.22309
R721 a_19352_1144.n1 a_19352_1144.n0 6.20245
R722 a_19352_1144.n0 a_19352_1144.t3 0.3645
R723 a_19352_1144.n0 a_19352_1144.t2 0.3645
R724 a_18668_1144.t1 a_18668_1144.n1 7.12409
R725 a_18668_1144.n1 a_18668_1144.t0 7.22309
R726 a_18668_1144.n1 a_18668_1144.n0 6.20245
R727 a_18668_1144.n0 a_18668_1144.t3 0.3645
R728 a_18668_1144.n0 a_18668_1144.t2 0.3645
R729 a_17984_1144.t2 a_17984_1144.n1 7.22309
R730 a_17984_1144.n1 a_17984_1144.t3 7.12409
R731 a_17984_1144.n1 a_17984_1144.n0 6.20245
R732 a_17984_1144.n0 a_17984_1144.t1 0.3645
R733 a_17984_1144.n0 a_17984_1144.t0 0.3645
R734 a_17300_1144.t1 a_17300_1144.n1 7.12409
R735 a_17300_1144.n1 a_17300_1144.t0 7.22309
R736 a_17300_1144.n1 a_17300_1144.n0 6.20245
R737 a_17300_1144.n0 a_17300_1144.t3 0.3645
R738 a_17300_1144.n0 a_17300_1144.t2 0.3645
R739 vi.n2 vi.t0 12.1319
R740 vi vi.n0 6.18575
R741 vi.n0 vi.n1 0.77
R742 vi.n1 vi.n2 0.365
R743 vi.n2 vi.t1 12.7394
R744 vi.n1 vi.t4 12.1319
R745 vi.n0 vi.t3 12.1319
R746 vi vi.t2 22.5341
R747 vnt.n5 vnt.t0 11.4119
R748 vnt.n0 vnt.n5 0.77
R749 vnt.n1 vnt.n0 0.77
R750 vnt vnt.n1 5.01125
R751 vnt vnt.n2 2.35175
R752 vnt.n2 vnt.n3 1.49
R753 vnt.n3 vnt.n4 1.9895
R754 vnt.n4 vnt.t2 15.3768
R755 vnt.n4 vnt.t4 13.8873
R756 vnt.n3 vnt.t3 13.8873
R757 vnt.n2 vnt.t5 13.8873
R758 vnt.n1 vnt.t6 11.4119
R759 vnt.n0 vnt.t1 11.4119
R760 vnt.n5 vnt.t7 12.1814
R761 vbn_vco.t3 vbn_vco.n0 13.8307
R762 vbn_vco.n12 vbn_vco.n0 14.0675
R763 vbn_vco vbn_vco.n11 18.7036
R764 vbn_vco vbn_vco.n2 0.413375
R765 vbn_vco.n2 vbn_vco.n12 0.77225
R766 vbn_vco.n11 vbn_vco.n5 0.9755
R767 vbn_vco.n5 vbn_vco.n7 0.9965
R768 vbn_vco.n7 vbn_vco.n9 0.9965
R769 vbn_vco.n9 vbn_vco.n10 10.4541
R770 vbn_vco.n10 vbn_vco.t5 29.8501
R771 vbn_vco.n10 vbn_vco.t6 29.6085
R772 vbn_vco.n9 vbn_vco.n8 9.45808
R773 vbn_vco.n8 vbn_vco.t7 29.8501
R774 vbn_vco.n8 vbn_vco.t8 29.6085
R775 vbn_vco.n7 vbn_vco.n6 9.45808
R776 vbn_vco.n6 vbn_vco.t9 29.8501
R777 vbn_vco.n6 vbn_vco.t10 29.6085
R778 vbn_vco.n5 vbn_vco.n4 9.45808
R779 vbn_vco.n4 vbn_vco.t11 29.8501
R780 vbn_vco.n4 vbn_vco.t12 29.6085
R781 vbn_vco.n11 vbn_vco.n3 9.47383
R782 vbn_vco.n3 vbn_vco.t13 29.8501
R783 vbn_vco.n3 vbn_vco.t14 29.6085
R784 vbn_vco.n12 vbn_vco.t2 21.0515
R785 vbn_vco.n2 vbn_vco.n1 11.2168
R786 vbn_vco.n1 vbn_vco.t1 1.88813
R787 vbn_vco.n1 vbn_vco.t0 44.5424
R788 vbn_vco.n0 vbn_vco.t4 14.3392
R789 vst.t1 vst.n2 12.4919
R790 vst vst.n2 0.66425
R791 vst vst.n1 0.2975
R792 vst.n1 vst.n0 0.698
R793 vst.n1 vst.t2 37.6845
R794 vst.n0 vst.t0 20.9795
R795 vst.n0 vst.t4 17.4463
R796 vst.n2 vst.t3 13.2614
R797 vbh.t5 vbh.n5 11.5919
R798 vbh vbh.n5 2.03338
R799 vbh vbh.n4 17.8689
R800 vbh.n4 vbh.n1 0.0275
R801 vbh.n1 vbh.n2 1.013
R802 vbh.n2 vbh.n3 12.0492
R803 vbh.n3 vbh.t3 1.83599
R804 vbh.n3 vbh.t2 12.2744
R805 vbh.n2 vbh.t6 22.759
R806 vbh.n1 vbh.t7 22.759
R807 vbh.n4 vbh.n0 11.8648
R808 vbh.n0 vbh.t1 1.83599
R809 vbh.n0 vbh.t0 12.2744
R810 vbh.n5 vbh.t4 13.9004
R811 vbl.t4 vbl.n7 11.5874
R812 vbl.n0 vbl.n7 1.283
R813 vbl.n1 vbl.n0 2.363
R814 vbl.n6 vbl.n1 15.0755
R815 vbl vbl.n3 0.919625
R816 vbl vbl.n4 0.075875
R817 vbl.n4 vbl.n6 1.32125
R818 vbl.n6 vbl.n5 11.1312
R819 vbl.n5 vbl.t3 3.47655
R820 vbl.n5 vbl.t2 8.58548
R821 vbl.n4 vbl.t8 19.4863
R822 vbl.n3 vbl.t9 19.4863
R823 vbl.n3 vbl.n2 12.2945
R824 vbl.n2 vbl.t1 3.47655
R825 vbl.n2 vbl.t0 8.58548
R826 vbl.n1 vbl.t7 11.5874
R827 vbl.n0 vbl.t6 11.5874
R828 vbl.n7 vbl.t5 13.9499
R829 vbp_vco.t2 vbp_vco.n0 13.4594
R830 vbp_vco vbp_vco.n16 17.4886
R831 vbp_vco vbp_vco.n1 0.978125
R832 vbp_vco.n1 vbp_vco.n0 1.21775
R833 vbp_vco.n16 vbp_vco.n10 0.7355
R834 vbp_vco.n10 vbp_vco.n12 0.9965
R835 vbp_vco.n12 vbp_vco.n14 0.9965
R836 vbp_vco.n14 vbp_vco.n15 10.4558
R837 vbp_vco.n15 vbp_vco.t7 51.8961
R838 vbp_vco.n15 vbp_vco.t8 51.6545
R839 vbp_vco.n14 vbp_vco.n13 9.45982
R840 vbp_vco.n13 vbp_vco.t9 51.8961
R841 vbp_vco.n13 vbp_vco.t10 51.6545
R842 vbp_vco.n12 vbp_vco.n11 9.45982
R843 vbp_vco.n11 vbp_vco.t11 51.8961
R844 vbp_vco.n11 vbp_vco.t12 51.6545
R845 vbp_vco.n10 vbp_vco.n9 9.45982
R846 vbp_vco.n9 vbp_vco.t13 51.8961
R847 vbp_vco.n9 vbp_vco.t14 51.6545
R848 vbp_vco.n16 vbp_vco.n8 9.69082
R849 vbp_vco.n8 vbp_vco.t15 51.8961
R850 vbp_vco.n8 vbp_vco.t16 51.6545
R851 vbp_vco.n1 vbp_vco.n7 13.7075
R852 vbp_vco.n4 vbp_vco.n3 0.6755
R853 vbp_vco.n6 vbp_vco.n4 1.00175
R854 vbp_vco.n7 vbp_vco.n6 0.00725
R855 vbp_vco.n7 vbp_vco.t0 21.5933
R856 vbp_vco.n6 vbp_vco.n5 11.9233
R857 vbp_vco.n5 vbp_vco.t6 1.6447
R858 vbp_vco.n5 vbp_vco.t5 51.9932
R859 vbp_vco.n4 vbp_vco.t17 63.6952
R860 vbp_vco.n3 vbp_vco.t18 63.6952
R861 vbp_vco.n3 vbp_vco.n2 12.767
R862 vbp_vco.n2 vbp_vco.t4 1.6447
R863 vbp_vco.n2 vbp_vco.t3 51.9932
R864 vbp_vco.n0 vbp_vco.t1 12.8519
R865 vs.n0 vs.t1 13.2614
R866 vs vs.n0 1.76337
R867 vs vs.t0 75.0306
R868 vs.n0 vs.t2 12.4919
R869 vcl.t0 vcl.n2 14.0676
R870 vcl.n0 vcl.n2 0.995
R871 vcl.n1 vcl.n0 0.995
R872 vcl vcl.n1 35.5482
R873 vcl vcl.t2 35.965
R874 vcl.n1 vcl.t1 14.0676
R875 vcl.n0 vcl.t4 14.0676
R876 vcl.n2 vcl.t3 15.5571
R877 up_b.t0 up_b 20.9925
R878 up_b up_b.n0 0.100625
R879 up_b.n0 up_b.t1 71.5708
R880 up_b.n0 up_b.t2 54.6402
R881 en_b.t0 en_b.n0 18.5456
R882 en_b.n5 en_b.n0 10.4585
R883 en_b.n3 en_b.n2 0.608
R884 en_b en_b.n3 1.193
R885 en_b en_b.n4 0.5675
R886 en_b.n4 en_b.n5 10.508
R887 en_b.n4 en_b.t2 44.8461
R888 en_b.n3 en_b.t3 44.8461
R889 en_b.n2 en_b.t4 44.8461
R890 en_b.n2 en_b.t5 45.4536
R891 en_b.n5 en_b.n1 32.315
R892 en_b.n1 en_b.t1 22.9257
R893 en_b.n1 en_b.t7 47.1298
R894 en_b.n0 en_b.t6 14.7589
R895 t1c.t0 t1c 17.1746
R896 t1c t1c.t1 17.1746
R897 vdump.t5 vdump.n0 1.68292
R898 vdump.n0 vdump.t4 30.1453
R899 vdump.n15 vdump.n0 10.2695
R900 vdump.n2 vdump.n15 3.254
R901 vdump.n3 vdump.n2 0.995
R902 vdump vdump.n3 6.67962
R903 vdump vdump.n14 20.1841
R904 vdump.n8 vdump.n6 2.858
R905 vdump.n10 vdump.n8 0.788
R906 vdump.n11 vdump.n10 3.308
R907 vdump.n12 vdump.n11 1.013
R908 vdump.n13 vdump.n12 9.788
R909 vdump.n14 vdump.n13 9.32225
R910 vdump.n13 vdump.t17 12.366
R911 vdump.n12 vdump.t16 12.366
R912 vdump.n11 vdump.t15 12.366
R913 vdump.n10 vdump.n9 10.3032
R914 vdump.n9 vdump.t1 1.6447
R915 vdump.n9 vdump.t0 30.2254
R916 vdump.n8 vdump.n7 10.3032
R917 vdump.n7 vdump.t11 1.6447
R918 vdump.n7 vdump.t10 30.2254
R919 vdump.n6 vdump.n5 10.3032
R920 vdump.n5 vdump.t7 1.6447
R921 vdump.n5 vdump.t6 30.2254
R922 vdump.n6 vdump.n4 11.0908
R923 vdump.n4 vdump.t9 1.6447
R924 vdump.n4 vdump.t8 30.2254
R925 vdump.n14 vdump.t14 52.8618
R926 vdump.n3 vdump.t13 14.4273
R927 vdump.n2 vdump.t12 14.4273
R928 vdump.n15 vdump.n1 11.039
R929 vdump.n1 vdump.t3 1.68292
R930 vdump.n1 vdump.t2 30.1453
R931 dn_b.t0 dn_b 20.8598
R932 dn_b dn_b.n0 44.7654
R933 dn_b.n0 dn_b.t1 21.4858
R934 dn_b.n0 dn_b.t2 46.1242
R935 dn_s.t0 dn_s.n1 11.7276
R936 dn_s dn_s.n1 1.0085
R937 dn_s dn_s.n0 1.346
R938 dn_s.n0 dn_s.t3 16.5243
R939 dn_s.n0 dn_s.t2 15.3723
R940 dn_s.n1 dn_s.t1 13.2171
R941 vref.n12 vref.t2 12.7444
R942 vref.n1 vref.n0 1.49
R943 vref.n2 vref.n1 0.995
R944 vref.n3 vref.n2 0.995
R945 vref.n4 vref.n3 1.49
R946 vref.n12 vref.n4 0.19625
R947 vref.n5 vref.n12 1.34375
R948 vref vref.n5 0.4505
R949 vref vref.n6 0.32
R950 vref.n6 vref.n7 3.14375
R951 vref.n7 vref.n11 25.0588
R952 vref.n11 vref.t0 45.2912
R953 vref.n9 vref.n8 0.995
R954 vref.n10 vref.n9 0.995
R955 vref.n11 vref.n10 17.7507
R956 vref.n10 vref.t11 35.5713
R957 vref.n9 vref.t12 35.5713
R958 vref.n8 vref.t13 35.5713
R959 vref.n8 vref.t14 37.0608
R960 vref.n7 vref.t1 20.3608
R961 vref.n6 vref.t3 40.5582
R962 vref.n5 vref.t4 40.5582
R963 vref.n4 vref.t5 19.6663
R964 vref.n3 vref.t6 19.6663
R965 vref.n2 vref.t7 19.6663
R966 vref.n1 vref.t8 19.6663
R967 vref.n0 vref.t9 19.6663
R968 vref.n0 vref.t10 20.6608
R969 t1b t1b.t1 24.9832
R970 t1b t1b.t0 55.3781
R971 va.t0 va.n1 19.6407
R972 va va.n0 3.77487
R973 va va.n1 0.300875
R974 va.n1 va.t1 78.0862
R975 va.n0 va.t3 36.4132
R976 va.n0 va.t2 17.4896
R977 t1a t1a.t0 24.7807
R978 t1a t1a.t1 59.2481
R979 t2 t2.t1 25.0169
R980 t2 t2.n0 36.9939
R981 t2.n0 t2.t2 17.226
R982 t2.n0 t2.t0 23.2785
R983 vcp_n.t6 vcp_n.n0 1.64987
R984 vcp_n.n0 vcp_n.t5 23.1665
R985 vcp_n.n13 vcp_n.n0 9.71825
R986 vcp_n.n3 vcp_n.n2 0.995
R987 vcp_n.n4 vcp_n.n3 1.49
R988 vcp_n.n5 vcp_n.n4 0.995
R989 vcp_n.n13 vcp_n.n5 0.82625
R990 vcp_n.n6 vcp_n.n13 2.417
R991 vcp_n.n7 vcp_n.n6 0.608
R992 vcp_n.n8 vcp_n.n7 1.2155
R993 vcp_n.n9 vcp_n.n8 2.318
R994 vcp_n vcp_n.n9 1.20537
R995 vcp_n vcp_n.n12 40.4656
R996 vcp_n.n11 vcp_n.n10 8.078
R997 vcp_n.n12 vcp_n.n11 2.5205
R998 vcp_n.n12 vcp_n.t7 17.046
R999 vcp_n.n11 vcp_n.t1 17.046
R1000 vcp_n.n10 vcp_n.t0 17.046
R1001 vcp_n.n10 vcp_n.t9 19.566
R1002 vcp_n.n9 vcp_n.t2 20.5858
R1003 vcp_n.n8 vcp_n.t11 15.0123
R1004 vcp_n.n7 vcp_n.t10 15.0123
R1005 vcp_n.n6 vcp_n.t8 15.0123
R1006 vcp_n.n5 vcp_n.t12 32.6913
R1007 vcp_n.n4 vcp_n.t13 32.6913
R1008 vcp_n.n3 vcp_n.t14 32.6913
R1009 vcp_n.n2 vcp_n.t15 32.6913
R1010 vcp_n.n2 vcp_n.n1 10.8815
R1011 vcp_n.n1 vcp_n.t4 1.64987
R1012 vcp_n.n1 vcp_n.t3 23.1665
R1013 vbt.n9 vbt.t3 11.4074
R1014 vbt.n1 vbt.n0 0.788
R1015 vbt.n2 vbt.n1 0.788
R1016 vbt.n3 vbt.n2 1.283
R1017 vbt.n4 vbt.n3 0.788
R1018 vbt.n9 vbt.n4 0.788
R1019 vbt.n5 vbt.n9 0.788
R1020 vbt vbt.n5 7.35463
R1021 vbt vbt.n8 55.3741
R1022 vbt.n7 vbt.n6 10.598
R1023 vbt.n8 vbt.n7 2.0255
R1024 vbt.n8 vbt.t4 16.686
R1025 vbt.n7 vbt.t7 16.686
R1026 vbt.n6 vbt.t5 16.686
R1027 vbt.n6 vbt.t6 19.206
R1028 vbt.n5 vbt.t11 11.4074
R1029 vbt.n4 vbt.t2 11.4074
R1030 vbt.n3 vbt.t10 11.4074
R1031 vbt.n2 vbt.t9 11.4074
R1032 vbt.n1 vbt.t1 11.4074
R1033 vbt.n0 vbt.t0 11.4074
R1034 vbt.n0 vbt.t8 12.1949
R1035 vbp.t1 vbp.n0 14.8729
R1036 vbp vbp.n0 1.37187
R1037 vbp vbp.n15 14.5074
R1038 vbp.n15 vbp.t0 35.1743
R1039 vbp.n2 vbp.n1 1.508
R1040 vbp.n3 vbp.n2 1.013
R1041 vbp.n4 vbp.n3 1.013
R1042 vbp.n5 vbp.n4 1.508
R1043 vbp.n7 vbp.n5 0.84425
R1044 vbp.n8 vbp.n7 1.18175
R1045 vbp.n9 vbp.n8 1.508
R1046 vbp.n10 vbp.n9 1.013
R1047 vbp.n11 vbp.n10 1.013
R1048 vbp.n12 vbp.n11 1.508
R1049 vbp.n13 vbp.n12 1.013
R1050 vbp.n14 vbp.n13 1.013
R1051 vbp.n15 vbp.n14 33.3838
R1052 vbp.n14 vbp.t5 27.079
R1053 vbp.n13 vbp.t6 27.079
R1054 vbp.n12 vbp.t7 27.079
R1055 vbp.n11 vbp.t8 27.079
R1056 vbp.n10 vbp.t9 27.079
R1057 vbp.n9 vbp.t10 27.079
R1058 vbp.n8 vbp.t11 27.079
R1059 vbp.n7 vbp.n6 15.0305
R1060 vbp.n6 vbp.t4 1.83599
R1061 vbp.n6 vbp.t3 12.2744
R1062 vbp.n5 vbp.t12 27.079
R1063 vbp.n4 vbp.t13 27.079
R1064 vbp.n3 vbp.t14 27.079
R1065 vbp.n2 vbp.t15 27.079
R1066 vbp.n1 vbp.t16 27.079
R1067 vbp.n1 vbp.t17 28.0915
R1068 vbp.n0 vbp.t2 22.037
R1069 up_s.t0 up_s.n1 13.0082
R1070 up_s up_s.n1 60.9541
R1071 up_s up_s.n0 3.12463
R1072 up_s.n0 up_s.t3 13.806
R1073 up_s.n0 up_s.t2 14.481
R1074 up_s.n1 up_s.t1 14.0207
R1075 vcp_p.t3 vcp_p.n0 3.11042
R1076 vcp_p.n0 vcp_p.t2 50.5496
R1077 vcp_p.n6 vcp_p.n0 9.71825
R1078 vcp_p.n3 vcp_p.n2 1.013
R1079 vcp_p.n6 vcp_p.n3 1.33925
R1080 vcp_p.n5 vcp_p.n6 34.2793
R1081 vcp_p vcp_p.n5 25.4514
R1082 vcp_p vcp_p.t4 25.5971
R1083 vcp_p.n5 vcp_p.n4 23.7852
R1084 vcp_p.n4 vcp_p.t6 11.5476
R1085 vcp_p.n4 vcp_p.t5 15.0261
R1086 vcp_p.n3 vcp_p.t7 60.139
R1087 vcp_p.n2 vcp_p.t8 60.139
R1088 vcp_p.n2 vcp_p.n1 10.8995
R1089 vcp_p.n1 vcp_p.t1 3.11042
R1090 vcp_p.n1 vcp_p.t0 50.5496
C0 pll_en pfd_up 0.27016f
C1 t2 pfd_up 0.07723f
C2 pfd_up cp_trim0 0.07656f
C3 up_s vfilt 1.09241f
C4 t1b t2 1.6636f
C5 t1b pll_en 0.08342f
C6 t1b cp_trim0 0.05636f
C7 vdd vfilt 30.4242f
C8 a_6600_18230# vref 0.00948f
C9 r5 vco_out 0
C10 vctrl pll_en 5.26221f
C11 vctrl t2 0.03527f
C12 vctrl cp_trim0 0.06417f
C13 bias_ref cp_trim1 0.00516f
C14 bias_ref vbp 0.0396f
C15 va cp_trim1 0.04398f
C16 va vbp 3.21956f
C17 vbt vbl 2.37982f
C18 vs up_b 0.0502f
C19 vcp_p en_b 0.21476f
C20 vcp_p dn_b 0.13657f
C21 vst va 0.16545f
C22 vbp_vco pfd_up 0.29599f
C23 vcp_n up_b 0.09708f
C24 bias_ref a_13200_19550# 0
C25 vdd vco_out 0.64469f
C26 pfd_up vfilt 2.62965f
C27 vcp_p pfd_dn 2.16442f
C28 t1b vfilt 3.61933f
C29 vbp_vco vctrl 0.37885f
C30 vcp_p vbn_vco 0.12404f
C31 vcl up_b 0.22657f
C32 vcp_p vbt 0.19693f
C33 vbh dn_b 0.00104f
C34 vctrl vfilt 12.3242f
C35 bias_ref vref 2.89684f
C36 va vref 0.78258f
C37 a_12000_19550# vs 0.00168f
C38 bias_ref up_s 0.04496f
C39 vcp_p t1c 0.06526f
C40 t2 up_b 0.19121f
C41 va up_s 4.2646f
C42 a_13200_19550# a_14400_19550# 0.00585f
C43 pll_en up_b 0.27031f
C44 cp_trim0 up_b 0.08985f
C45 pfd_dn vbh 0
C46 en_b vbp 5.51926f
C47 bias_ref vdd 1.05352f
C48 vdd va 1.28687f
C49 en_b cp_trim1 0.11308f
C50 cp_trim1 dn_b 0.07838f
C51 vbp dn_b 0.0996f
C52 a_11400_12098# a_10200_12098# 0.00585f
C53 vst en_b 1.43206f
C54 vbh vbt 0.25043f
C55 vcp_p a_12600_12098# 0
C56 vctrl a_4200_12098# 0.00482f
C57 a_8400_12098# vfilt 0.02959f
C58 vst dn_b 0.09192f
C59 nb r4 0.0025f
C60 pfd_dn vbp 0.10454f
C61 vctrl vco_out 0.02226f
C62 pfd_dn cp_trim1 0.07807f
C63 a_12000_19550# vcl 0.00132f
C64 a_14400_19550# vref 0.00106f
C65 vbp_vco up_b 0.25062f
C66 vbp vbn_vco 0.24473f
C67 vst pfd_dn 0.09192f
C68 vdump vnt 0.95014f
C69 cp_trim1 vbt 0.04398f
C70 vbp vbt 8.66996f
C71 vnt vi 0.03813f
C72 vst vbn_vco 0.16254f
C73 bias_ref pfd_up 0.11322f
C74 vbh vbl 0.49955f
C75 va pfd_up 0.04936f
C76 a_6000_12098# vfilt 0.02959f
C77 vst vbt 0.09192f
C78 up_b vfilt 2.53803f
C79 va t1b 2.07934f
C80 vdump t1a 0.07541f
C81 en_b vref 0.9146f
C82 vdd r2 0.38366f
C83 t1c cp_trim1 0.19875f
C84 vref dn_b 0.33483f
C85 r5 vbn_vco 0.02169f
C86 pll_en nb 0.47133f
C87 up_s en_b 1.14311f
C88 bias_ref vctrl 0.13449f
C89 va vctrl 2.16163f
C90 up_s dn_b 0.1377f
C91 vdd en_b 3.5288f
C92 vdd dn_b 0.36927f
C93 nb r1 0
C94 vbp a_12600_12098# 0.00185f
C95 a_4200_12098# a_6000_12098# 0.00234f
C96 pfd_dn vref 0.24922f
C97 vcp_p vbh 0
C98 vref vbn_vco 0.41616f
C99 pfd_dn up_s 0.21386f
C100 vs t1a 0
C101 vdd pfd_dn 0.58949f
C102 vref vbt 0.0427f
C103 up_s vbn_vco 0.12427f
C104 vdump vi 3.00891f
C105 vdd vbn_vco 1.60315f
C106 vcp_n t1a 0.48869f
C107 up_s vbt 3.9404f
C108 vdd vbt 10.8341f
C109 vctrl a_14400_19550# 0.00289f
C110 a_12000_19550# vfilt 0.09187f
C111 en_b pfd_up 2.21802f
C112 vcp_p vbp 5.04214f
C113 vcp_p cp_trim1 0.113f
C114 dn_b pfd_up 2.40289f
C115 t1c vref 0
C116 t1b en_b 0.11326f
C117 t1b dn_b 0.03197f
C118 vcl t1a 0.20602f
C119 vst vcp_p 0.09192f
C120 vdd t1c 0.00742f
C121 vref vbl 0.02086f
C122 a_10200_12098# vfilt 0.02959f
C123 vctrl a_1200_19730# 0.01597f
C124 vdump vs 0.14608f
C125 vs vi 0.56473f
C126 bias_ref up_b 0.06044f
C127 vctrl en_b 3.75298f
C128 vdump dn_s 0.32243f
C129 va up_b 0.17458f
C130 vctrl dn_b 0.1384f
C131 pfd_dn pfd_up 3.21485f
C132 vdd vbl 1.00568f
C133 pfd_dn t1b 0.03182f
C134 vbn_vco pfd_up 0.12595f
C135 vdump vcp_n 0.08851f
C136 pll_en t1a 0.0832f
C137 t2 t1a 2.73231f
C138 t1a cp_trim0 3.16826f
C139 vbt pfd_up 0.14847f
C140 t1b vbt 0.07242f
C141 nb vco_out 0.59878f
C142 a_8400_12098# a_7200_12098# 0.00585f
C143 vctrl pfd_dn 3.70147f
C144 a_400_12098# vfilt 0.04747f
C145 vref a_10800_19550# 0.00106f
C146 vctrl vbn_vco 0.26197f
C147 vdump vcl 0.17602f
C148 vs dn_s 0
C149 vcp_p vref 0.47805f
C150 vctrl vbt 3.7475f
C151 t1c pfd_up 0
C152 t1c t1b 0.70676f
C153 vbp cp_trim1 0.03063f
C154 vcp_p up_s 5.99509f
C155 vcp_n vs 0.01252f
C156 vdd vcp_p 13.3089f
C157 vcp_n dn_s 1.31867f
C158 vst vbp 0.61018f
C159 bias_ref a_12000_19550# 0
C160 vdump t2 0.03503f
C161 vdump cp_trim0 0.06411f
C162 vdump pll_en 0.38886f
C163 vctrl t1c 0.06547f
C164 pll_en vi 0.42057f
C165 a_7200_12098# a_6000_12098# 0.00585f
C166 en_b up_b 0.2252f
C167 vs vcl 4.10167f
C168 t1a vfilt 3.74692f
C169 dn_b up_b 0.07278f
C170 vcl dn_s 0
C171 vbh vref 0.12756f
C172 vctrl vbl 6.4837f
C173 vcp_n vcl 0.71459f
C174 vdd vbh 4.21052f
C175 vdump vbp_vco 0.39826f
C176 pfd_dn up_b 0.1327f
C177 vcp_p pfd_up 0.1129f
C178 vbp_vco vi 0.85454f
C179 t2 vs 0
C180 pll_en vs 0.43969f
C181 vs cp_trim0 0
C182 vcp_p t1b 0.10449f
C183 vbn_vco up_b 0.12638f
C184 vref cp_trim1 0.1982f
C185 vref vbp 0.53798f
C186 r3 r4 0.27551f
C187 vbt up_b 2.54639f
C188 up_s cp_trim1 0.04398f
C189 up_s vbp 0.72835f
C190 vctrl a_10800_19550# 0.00289f
C191 vcp_n pll_en 0.07745f
C192 vcp_n t2 3.42614f
C193 vcp_n cp_trim0 0.63011f
C194 vst vref 1.5991f
C195 vdump vfilt 3.14f
C196 vctrl a_2000_12098# 0.00842f
C197 vdd cp_trim1 0.05642f
C198 vdd vbp 25.0202f
C199 vcp_p vctrl 0.15148f
C200 pll_en r4 0.00497f
C201 vst up_s 0.02367f
C202 vst vdd 0.83455f
C203 r1 r4 0.25847f
C204 a_13200_19550# vref 0.00106f
C205 t1c up_b 0.00874f
C206 vcl cp_trim0 0.19176f
C207 t2 vcl 0.20531f
C208 vbh pfd_up 0.02874f
C209 vbp_vco vs 0.20596f
C210 pll_en vcl 1.94211f
C211 va vnt 0.49711f
C212 a_11400_12098# vfilt 0.02959f
C213 vdd r5 0.84038f
C214 vs vfilt 8.06781f
C215 dn_s vfilt 2.7126f
C216 vctrl vbh 4.19048f
C217 vbp_vco r4 0.03255f
C218 va t1a 2.22823f
C219 r3 r1 0.20322f
C220 t2 cp_trim0 3.57794f
C221 cp_trim1 pfd_up 0.07714f
C222 vbp pfd_up 0.11915f
C223 pll_en cp_trim0 0.0832f
C224 t2 pll_en 0.0833f
C225 t1b cp_trim1 3.48909f
C226 t1b vbp 1.28638f
C227 vcp_n vfilt 9.83485f
C228 pll_en a_15000_12098# 0
C229 up_s vref 0.04909f
C230 vst pfd_up 0.09209f
C231 vdd vref 0.47638f
C232 vdd up_s 3.31935f
C233 vctrl vbp 0.32757f
C234 vctrl cp_trim1 0.0778f
C235 r3 vbp_vco 0.06843f
C236 vcl vfilt 7.8094f
C237 vcp_p up_b 0.10688f
C238 vst vctrl 0.24578f
C239 vbp_vco pll_en 2.37585f
C240 bias_ref vdump 0.0396f
C241 vdump va 0.07242f
C242 va vi 0.15084f
C243 pll_en a_13800_12098# 0
C244 vbp_vco r1 0.02988f
C245 a_13200_19550# vctrl 0.00289f
C246 vctrl r5 0.00595f
C247 a_13800_12098# a_15000_12098# 0.00585f
C248 cp_trim0 vfilt 3.24502f
C249 t2 vfilt 4.21524f
C250 pll_en vfilt 2.38963f
C251 vref pfd_up 0.30417f
C252 a_15000_12098# vfilt 0.02959f
C253 t1b vref 0.20495f
C254 vbh up_b 0.01882f
C255 up_s pfd_up 0.2114f
C256 en_b t1a 0.11315f
C257 t1b up_s 0.07239f
C258 dn_b t1a 3.47496f
C259 vdd pfd_up 1.07848f
C260 vdd t1b 0.96214f
C261 bias_ref vs 2.82208f
C262 a_12000_19550# a_10800_19550# 0.00585f
C263 va vs 0.24926f
C264 vctrl vref 0.70415f
C265 vctrl up_s 0.42997f
C266 vbp_vco vfilt 0.01522f
C267 bias_ref vcp_n 0.01134f
C268 vbp up_b 0.10591f
C269 vdd vctrl 6.07963f
C270 va vcp_n 0.21547f
C271 cp_trim1 up_b 0.15662f
C272 pfd_dn t1a 0.05422f
C273 a_13800_12098# vfilt 0.02959f
C274 pll_en vco_out 0.64407f
C275 vst up_b 0.0952f
C276 t1a vbt 0.08464f
C277 vdump en_b 0.36848f
C278 en_b vi 0.15561f
C279 bias_ref vcl 0.38063f
C280 va vcl 0.08358f
C281 vdump dn_b 0.69544f
C282 dn_b vi 0
C283 a_14400_19550# vs 0.00168f
C284 a_6600_18230# vfilt 0.10189f
C285 t1b pfd_up 0.07799f
C286 vnt vbl 0.17164f
C287 t1c t1a 0.06526f
C288 vdump pfd_dn 0.18478f
C289 pfd_dn vi 0
C290 vctrl pfd_up 0.14359f
C291 a_4200_12098# vfilt 0.02959f
C292 bias_ref cp_trim0 0.00247f
C293 bias_ref pll_en 0.1038f
C294 va t2 0.1324f
C295 va pll_en 0.1417f
C296 va cp_trim0 0.04427f
C297 vctrl t1b 0.03178f
C298 a_2000_12098# a_400_12098# 0.00585f
C299 vdump vbn_vco 0.24495f
C300 vi vbn_vco 0.12251f
C301 en_b vs 0.38951f
C302 vdump vbt 1.90382f
C303 vs dn_b 0.04035f
C304 vref up_b 0.23265f
C305 dn_b dn_s 0.03125f
C306 a_14400_19550# vcl 0.00132f
C307 vcp_n a_1200_19730# 0
C308 up_s up_b 3.19093f
C309 r4 r2 0.01867f
C310 vcp_n en_b 0.61516f
C311 vdd up_b 0.75974f
C312 vcp_n dn_b 0.11855f
C313 vdump t1c 0.06526f
C314 pfd_dn vs 0.08543f
C315 a_13200_19550# a_12000_19550# 0.00585f
C316 va vbp_vco 0.1443f
C317 pfd_dn dn_s 0.08801f
C318 vs vbn_vco 0.03734f
C319 en_b vcl 0.21271f
C320 vcp_p t1a 0.31156f
C321 vdump vbl 2.06937f
C322 vi vbl 0.04207f
C323 vcl dn_b 0.18203f
C324 vcp_n pfd_dn 0.17646f
C325 vs vbt 0.04884f
C326 r3 r2 0.5427f
C327 r5 nb 0.29555f
C328 bias_ref vfilt 4.89881f
C329 va vfilt 0.58782f
C330 vcp_n vbt 1.14217f
C331 vbn_vco r4 0.03844f
C332 vnt vbh 1.9816f
C333 r1 r2 0.40043f
C334 pfd_up up_b 4.79731f
C335 t1c vs 0
C336 pfd_dn vcl 0.18225f
C337 a_12000_19550# vref 0.00106f
C338 en_b t2 0.11314f
C339 en_b pll_en 3.77167f
C340 en_b cp_trim0 0.11308f
C341 t1b up_b 2.60305f
C342 t2 dn_b 0.03616f
C343 a_12600_12098# a_11400_12098# 0.00585f
C344 dn_b cp_trim0 0.07842f
C345 pll_en dn_b 0.27593f
C346 en_b a_15000_12098# 0.00353f
C347 vcl vbt 1.20127f
C348 vcp_n t1c 0.4099f
C349 vctrl a_6000_12098# 0.00279f
C350 vdump vcp_p 5.69911f
C351 vcp_p vi 0
C352 vctrl up_b 2.46068f
C353 vdd nb 1.32772f
C354 vnt vbp 0.00573f
C355 r3 vbn_vco 0.06991f
C356 vbp_vco r2 0.03298f
C357 a_14400_19550# vfilt 0.09186f
C358 pfd_dn t2 0.0356f
C359 pfd_dn cp_trim0 0.065f
C360 pfd_dn pll_en 0.27106f
C361 bias_ref vco_out 0.04701f
C362 a_7800_18230# vfilt 0.10189f
C363 vst vnt 0
C364 pll_en vbn_vco 0.13101f
C365 t1c vcl 0
C366 vbp_vco en_b 1.52184f
C367 vbp_vco dn_b 0.25013f
C368 t2 vbt 0.11771f
C369 cp_trim1 t1a 0.113f
C370 vbp t1a 1.29955f
C371 pll_en vbt 0.18756f
C372 vbt cp_trim0 0.04427f
C373 r1 vbn_vco 0.10263f
C374 a_7800_18230# a_6600_18230# 0.00585f
C375 en_b a_13800_12098# 0.00374f
C376 a_10800_19550# vs 0.00168f
C377 a_7200_12098# vfilt 0.02959f
C378 a_1200_19730# vfilt 0.16254f
C379 en_b vfilt 2.66904f
C380 vdump vbh 2.02187f
C381 vbh vi 0.09345f
C382 vcp_p vs 0.03675f
C383 dn_b vfilt 3.38839f
C384 vcp_p dn_s 1.08144f
C385 t1c t2 0.07621f
C386 t1c cp_trim0 1.30308f
C387 vbp_vco pfd_dn 0.24971f
C388 vbp_vco vbn_vco 3.59174f
C389 vcp_p vcp_n 5.19512f
C390 bias_ref va 0.045f
C391 vbp_vco vbt 0.25132f
C392 pll_en a_12600_12098# 0.00109f
C393 a_12000_19550# vctrl 0.00289f
C394 pfd_dn vfilt 3.74566f
C395 vnt vref 1.62742f
C396 vdump vbp 0.6088f
C397 vdump cp_trim1 0.07768f
C398 vbp vi 0.15517f
C399 a_10800_19550# vcl 0.00132f
C400 vbn_vco vfilt 0.01516f
C401 vctrl nb 0.094f
C402 vcp_p vcl 0.22344f
C403 vst vdump 0.24375f
C404 vbt vfilt 2.37297f
C405 vst vi 0.15221f
C406 vref t1a 0.23043f
C407 up_s t1a 0.08418f
C408 vdd t1a 0.96471f
C409 bias_ref a_14400_19550# 0
C410 t1c vfilt 0.73568f
C411 bias_ref a_7800_18230# 0.00948f
C412 vcp_p t2 0.14354f
C413 vcp_p pll_en 2.60986f
C414 vcp_p cp_trim0 0.09913f
C415 vbp vs 0.14784f
C416 a_13800_12098# a_12600_12098# 0.00585f
C417 cp_trim1 vs 0
C418 vcp_p a_15000_12098# 0
C419 a_12600_12098# vfilt 0.02959f
C420 vcp_n cp_trim1 1.08654f
C421 vcp_n vbp 8.256f
C422 a_8400_12098# a_10200_12098# 0.00234f
C423 vctrl a_400_12098# 0.00842f
C424 bias_ref en_b 0.05077f
C425 vdump vref 4.09962f
C426 va en_b 0.51188f
C427 vref vi 3.63807f
C428 bias_ref dn_b 0.05016f
C429 va dn_b 0
C430 a_13200_19550# vs 0.00168f
C431 vdump up_s 0.37427f
C432 up_s vi 0
C433 vdd vi 0.08467f
C434 vcp_p vbp_vco 0.25117f
C435 vdd vdump 3.03919f
C436 vbh pll_en 0
C437 cp_trim1 vcl 0.21458f
C438 vbp vcl 0.09496f
C439 t1a pfd_up 0.29054f
C440 t1b t1a 1.68146f
C441 vnt vctrl 2.59472f
C442 vcp_p a_13800_12098# 0
C443 a_10800_19550# vfilt 0.09186f
C444 bias_ref pfd_dn 0.10304f
C445 va pfd_dn 0.05123f
C446 a_2000_12098# vfilt 0.04747f
C447 vcp_p vfilt 8.05097f
C448 r5 r4 0.56361f
C449 va vbn_vco 0.1205f
C450 vctrl t1a 0.03574f
C451 bias_ref vbt 0.04507f
C452 vref vs 0.62553f
C453 va vbt 4.73054f
C454 a_13200_19550# vcl 0.00132f
C455 t2 vbp 2.55606f
C456 vref dn_s 0.00898f
C457 t2 cp_trim1 3.16382f
C458 vbp cp_trim0 0.02918f
C459 pll_en cp_trim1 0.0832f
C460 vbp pll_en 2.60204f
C461 cp_trim1 cp_trim0 0.30197f
C462 up_s vs 0.03976f
C463 vdd vs 2.82577f
C464 vbp a_15000_12098# 0
C465 vcp_n vref 0.22767f
C466 vst pll_en 0.09192f
C467 vdump pfd_up 2.66584f
C468 a_4200_12098# a_2000_12098# 0.00234f
C469 vcp_n up_s 0.19636f
C470 vi pfd_up 0
C471 bias_ref t1c 0.01673f
C472 vdump t1b 0.03159f
C473 vdd vcp_n 5.39367f
C474 r3 r5 0.02161f
C475 vdd r4 0.39172f
C476 r5 pll_en 0.03695f
C477 en_b dn_b 0.21994f
C478 vref vcl 9.3069f
C479 vbp_vco vbp 0.42377f
C480 vdump vctrl 16.7816f
C481 vctrl vi 1.02591f
C482 up_s vcl 0.08986f
C483 r5 r1 0.35917f
C484 vdd vcl 0.36941f
C485 vbp a_13800_12098# 0
C486 vst vbp_vco 0.04271f
C487 vbn_vco r2 0.15347f
C488 vs pfd_up 0.09515f
C489 cp_trim1 vfilt 3.23126f
C490 vbp vfilt 7.06378f
C491 pfd_dn en_b 0.25986f
C492 t1b vs 0
C493 pfd_dn dn_b 9.22973f
C494 vref t2 0.20491f
C495 vref pll_en 0.40076f
C496 vref cp_trim0 0.20263f
C497 vdd r3 0.42477f
C498 en_b vbn_vco 1.00462f
C499 vst vfilt 0.0014f
C500 t1a up_b 0.09881f
C501 dn_b vbn_vco 0.12404f
C502 up_s t2 0.87416f
C503 up_s pll_en 0.1392f
C504 vbp_vco r5 0.0448f
C505 up_s cp_trim0 0.04427f
C506 vcp_n pfd_up 0.09611f
C507 en_b vbt 0.10539f
C508 bias_ref a_10800_19550# 0.01034f
C509 vdd cp_trim0 0.05536f
C510 vcp_n t1b 0.1537f
C511 vdd t2 1.88179f
C512 dn_b vbt 0.0347f
C513 vdd pll_en 3.09023f
C514 vctrl vs 0.59468f
C515 bias_ref vcp_p 0.0396f
C516 va vcp_p 0.037f
C517 vctrl dn_s 0.52018f
C518 a_13200_19550# vfilt 0.09187f
C519 vdd r1 0.37029f
C520 pfd_dn vbn_vco 0.12404f
C521 vctrl vcp_n 0.0975f
C522 vcl pfd_up 0.28309f
C523 t1c dn_b 0.06526f
C524 t1b vcl 0.1954f
C525 pfd_dn vbt 0.08866f
C526 vbp_vco vref 0.20733f
C527 vctrl r4 0.00245f
C528 vbt vbn_vco 0.12404f
C529 vbp_vco up_s 0.85483f
C530 vdd vbp_vco 6.93139f
C531 vdump up_b 0.17918f
C532 vi up_b 0
C533 vctrl vcl 0.22182f
C534 vref vfilt 8.57295f
C535 pfd_dn t1c 0.06526f
C536 vco_out vss 1.23743f
C537 bias_ref vss 13.7149f
C538 pll_en vss 8.89007f
C539 pfd_up vss 4.14085f
C540 vctrl vss 27.90146f
C541 cp_trim1 vss 5.82211f
C542 cp_trim0 vss 5.66925f
C543 pfd_dn vss 4.46581f
C544 vdd vss 0.48079p
C545 nb vss 1.10527f
C546 r4 vss 0.89258f
C547 r5 vss 1.32117f
C548 r3 vss 0.90329f
C549 r1 vss 1.01436f
C550 r2 vss 0.92286f
C551 vi vss 5.01448f
C552 vnt vss 6.52207f
C553 vbn_vco vss 8.40883f
C554 vst vss 4.67951f
C555 vbh vss 5.14399f
C556 vbl vss 7.45711f
C557 vbp_vco vss 6.18156f
C558 a_15000_12098# vss 0.67694f
C559 a_14400_19550# vss 0.68276f
C560 a_13800_12098# vss 0.66937f
C561 a_13200_19550# vss 0.67329f
C562 a_12600_12098# vss 0.66937f
C563 a_12000_19550# vss 0.67329f
C564 a_11400_12098# vss 0.66937f
C565 a_10800_19550# vss 0.67329f
C566 a_10200_12098# vss 0.67529f
C567 a_8400_12098# vss 0.67529f
C568 a_7800_18230# vss 0.66004f
C569 a_7200_12098# vss 0.66937f
C570 a_6600_18230# vss 0.66004f
C571 a_6000_12098# vss 0.68001f
C572 a_4200_12098# vss 0.68519f
C573 vs vss 15.26868f
C574 a_2000_12098# vss 1.08757f
C575 a_1200_19730# vss 1.08608f
C576 a_400_12098# vss 1.10395f
C577 vcl vss 16.42893f
C578 up_b vss 5.61525f
C579 en_b vss 8.92836f
C580 t1c vss 2.95009f
C581 vdump vss 12.52357f
C582 dn_b vss 14.61595f
C583 dn_s vss 3.45362f
C584 vref vss 25.5991f
C585 t1b vss 14.45813f
C586 va vss 5.35602f
C587 t1a vss 14.84638f
C588 t2 vss 11.50812f
C589 vcp_n vss 21.48068f
C590 vbt vss 13.13358f
C591 vbp vss 10.20436f
C592 up_s vss 11.43537f
C593 vcp_p vss 10.00981f
C594 vcp_p.t3 vss 4.92743f
C595 vcp_p.n0 vss 2.0917f
C596 vcp_p.t1 vss 4.92743f
C597 vcp_p.n1 vss 2.11514f
C598 vcp_p.n2 vss 1.89159f
C599 vcp_p.n3 vss 1.71514f
C600 vcp_p.t5 vss 2.37513f
C601 vcp_p.t6 vss 2.25231f
C602 vcp_p.n4 vss 3.31634f
C603 vcp_p.n5 vss 6.96625f
C604 vcp_p.t4 vss 0.62941f
C605 vcp_p.n6 vss 3.47292f
C606 up_s.t0 vss 6.49183f
C607 up_s.t1 vss 6.52455f
C608 up_s.t2 vss 1.22837f
C609 up_s.t3 vss 1.20715f
C610 up_s.n0 vss 1.66656f
C611 up_s.n1 vss 8.60602f
C612 vbp.t1 vss 1.27319f
C613 vbp.t2 vss 0.48811f
C614 vbp.n0 vss 1.63357f
C615 vbp.n1 vss 3.5396f
C616 vbp.n2 vss 1.90619f
C617 vbp.n3 vss 1.83226f
C618 vbp.n4 vss 1.90619f
C619 vbp.n5 vss 1.88099f
C620 vbp.t4 vss 1.01032f
C621 vbp.n6 vss 1.80698f
C622 vbp.n7 vss 1.21646f
C623 vbp.n8 vss 1.93139f
C624 vbp.n9 vss 1.90619f
C625 vbp.n10 vss 1.83226f
C626 vbp.n11 vss 1.90619f
C627 vbp.n12 vss 1.90619f
C628 vbp.n13 vss 1.83226f
C629 vbp.n14 vss 5.58468f
C630 vbp.t0 vss 1.69789f
C631 vbp.n15 vss 8.97786f
C632 vbt.t3 vss 1.42737f
C633 vbt.t8 vss 1.1055f
C634 vbt.t0 vss 1.42737f
C635 vbt.n0 vss 0.82259f
C636 vbt.t1 vss 1.42737f
C637 vbt.n1 vss 0.48101f
C638 vbt.t9 vss 1.07724f
C639 vbt.n2 vss 0.56322f
C640 vbt.t10 vss 1.07724f
C641 vbt.n3 vss 0.56322f
C642 vbt.t2 vss 1.42737f
C643 vbt.n4 vss 0.48101f
C644 vbt.t11 vss 1.07724f
C645 vbt.n5 vss 1.57159f
C646 vbt.t6 vss 2.85973f
C647 vbt.t5 vss 2.62368f
C648 vbt.n6 vss 4.67205f
C649 vbt.t7 vss 2.62368f
C650 vbt.n7 vss 3.22911f
C651 vbt.t4 vss 2.62368f
C652 vbt.n8 vss 9.01642f
C653 vbt.n9 vss 0.48101f
C654 vcp_n.t6 vss 1.77368f
C655 vcp_n.n0 vss 1.08592f
C656 vcp_n.t4 vss 1.77368f
C657 vcp_n.n1 vss 1.10807f
C658 vcp_n.n2 vss 1.00246f
C659 vcp_n.n3 vss 0.85021f
C660 vcp_n.n4 vss 0.85021f
C661 vcp_n.n5 vss 0.78349f
C662 vcp_n.t8 vss 0.60492f
C663 vcp_n.n6 vss 0.65071f
C664 vcp_n.t10 vss 0.60787f
C665 vcp_n.n7 vss 0.52992f
C666 vcp_n.t11 vss 0.58647f
C667 vcp_n.n8 vss 0.70183f
C668 vcp_n.t2 vss 0.43498f
C669 vcp_n.n9 vss 0.77728f
C670 vcp_n.t9 vss 2.16454f
C671 vcp_n.t0 vss 2.03751f
C672 vcp_n.n10 vss 2.64856f
C673 vcp_n.t1 vss 2.03751f
C674 vcp_n.n11 vss 1.78929f
C675 vcp_n.t7 vss 2.03751f
C676 vcp_n.n12 vss 4.03894f
C677 vcp_n.n13 vss 0.40715f
C678 t2.t1 vss 2.12865f
C679 t2.t0 vss 3.69447f
C680 t2.t2 vss 3.00533f
C681 t2.n0 vss 10.1893f
C682 t1a.t0 vss 2.06368f
C683 t1a.t1 vss 8.81493f
C684 va.t0 vss 0.41087f
C685 va.t2 vss 1.07174f
C686 va.n0 vss 2.35763f
C687 va.t1 vss 9.99666f
C688 va.n1 vss 10.5729f
C689 t1b.t1 vss 2.04004f
C690 t1b.t0 vss 7.78492f
C691 vref.t2 vss 0.99893f
C692 vref.n0 vss 1.23158f
C693 vref.n1 vss 0.70211f
C694 vref.n2 vss 0.65052f
C695 vref.n3 vss 0.70211f
C696 vref.n4 vss 0.61886f
C697 vref.n5 vss 0.63322f
C698 vref.n6 vss 0.80722f
C699 vref.t1 vss 0.36422f
C700 vref.n7 vss 2.67387f
C701 vref.n8 vss 2.51973f
C702 vref.n9 vss 1.28028f
C703 vref.n10 vss 2.57836f
C704 vref.t0 vss 1.66248f
C705 vref.n11 vss 6.67159f
C706 vref.n12 vss 0.42254f
C707 dn_s.t0 vss 2.40248f
C708 dn_s.t1 vss 2.44555f
C709 dn_s.t2 vss 0.86827f
C710 dn_s.n0 vss 1.28541f
C711 dn_s.t3 vss 0.84444f
C712 dn_s.n1 vss 0.82742f
C713 dn_b.t0 vss 1.71351f
C714 dn_b.t1 vss 0.72995f
C715 dn_b.n0 vss 10.7019f
C716 vdump.t5 vss 0.94922f
C717 vdump.n0 vss 0.9848f
C718 vdump.t3 vss 0.94922f
C719 vdump.n1 vss 1.01005f
C720 vdump.t12 vss 0.97673f
C721 vdump.n2 vss 1.14373f
C722 vdump.t13 vss 0.97673f
C723 vdump.n3 vss 1.70312f
C724 vdump.t14 vss 5.29223f
C725 vdump.t9 vss 0.95652f
C726 vdump.n4 vss 1.05106f
C727 vdump.t7 vss 0.95652f
C728 vdump.n5 vss 1.02473f
C729 vdump.n6 vss 1.16703f
C730 vdump.t11 vss 0.95652f
C731 vdump.n7 vss 1.02473f
C732 vdump.n8 vss 0.82263f
C733 vdump.t1 vss 0.95652f
C734 vdump.n9 vss 1.02473f
C735 vdump.n10 vss 0.89612f
C736 vdump.t15 vss 1.51643f
C737 vdump.n11 vss 1.05931f
C738 vdump.t16 vss 1.51643f
C739 vdump.n12 vss 2.11746f
C740 vdump.t17 vss 1.14659f
C741 vdump.n13 vss 3.12667f
C742 vdump.n14 vss 9.87154f
C743 vdump.n15 vss 1.21586f
C744 t1c.t0 vss 1.11723f
C745 t1c.t1 vss 1.1198f
C746 en_b.t0 vss 1.09477f
C747 en_b.n0 vss 3.8337f
C748 en_b.t1 vss 2.15505f
C749 en_b.n1 vss 7.5938f
C750 en_b.n2 vss 2.39358f
C751 en_b.n3 vss 1.34905f
C752 en_b.n4 vss 2.01496f
C753 en_b.n5 vss 6.72774f
C754 up_b.t0 vss 1.44044f
C755 up_b.n0 vss 10.7414f
C756 up_b.t1 vss 9.02509f
C757 vcl.t0 vss 3.55312f
C758 vcl.t3 vss 3.67448f
C759 vcl.t4 vss 3.55312f
C760 vcl.n0 vss 1.0786f
C761 vcl.t1 vss 3.55312f
C762 vcl.n1 vss 5.45071f
C763 vcl.t2 vss 1.72393f
C764 vcl.n2 vss 2.07549f
C765 vs.t1 vss 1.3475f
C766 vs.t2 vss 1.31233f
C767 vs.n0 vss 1.48319f
C768 vs.t0 vss 7.22455f
C769 vbp_vco.t2 vss 1.09168f
C770 vbp_vco.t1 vss 1.06791f
C771 vbp_vco.n0 vss 1.05128f
C772 vbp_vco.n1 vss 0.91297f
C773 vbp_vco.t4 vss 0.5824f
C774 vbp_vco.n2 vss 0.97677f
C775 vbp_vco.n3 vss 1.51081f
C776 vbp_vco.n4 vss 1.05012f
C777 vbp_vco.t6 vss 0.5824f
C778 vbp_vco.n5 vss 0.94271f
C779 vbp_vco.n6 vss 0.52501f
C780 vbp_vco.t0 vss 0.56894f
C781 vbp_vco.n7 vss 1.50611f
C782 vbp_vco.n8 vss 0.36555f
C783 vbp_vco.n9 vss 0.36379f
C784 vbp_vco.n10 vss 0.17773f
C785 vbp_vco.n11 vss 0.36379f
C786 vbp_vco.n12 vss 0.1969f
C787 vbp_vco.n13 vss 0.36379f
C788 vbp_vco.n14 vss 0.31484f
C789 vbp_vco.n15 vss 0.3762f
C790 vbp_vco.n16 vss 1.08918f
C791 vbl.t4 vss 0.75969f
C792 vbl.t5 vss 0.83822f
C793 vbl.t6 vss 0.75969f
C794 vbl.n0 vss 0.56698f
C795 vbl.t7 vss 0.75969f
C796 vbl.n1 vss 1.19352f
C797 vbl.t1 vss 0.41254f
C798 vbl.n2 vss 0.68962f
C799 vbl.n3 vss 1.01442f
C800 vbl.n4 vss 0.59378f
C801 vbl.t3 vss 0.41254f
C802 vbl.n5 vss 0.65353f
C803 vbl.n6 vss 0.99485f
C804 vbl.n7 vss 0.92919f
C805 vbh.t5 vss 0.73668f
C806 vbh.t4 vss 0.81199f
C807 vbh.t1 vss 0.74663f
C808 vbh.n0 vss 0.89125f
C809 vbh.n1 vss 0.60244f
C810 vbh.n2 vss 1.06398f
C811 vbh.t3 vss 0.74663f
C812 vbh.n3 vss 0.89816f
C813 vbh.n4 vss 1.18591f
C814 vbh.n5 vss 0.99648f
C815 vst.t1 vss 1.02823f
C816 vst.t3 vss 1.04831f
C817 vst.n0 vss 1.03646f
C818 vst.t0 vss 0.39466f
C819 vst.n1 vss 1.34179f
C820 vst.t2 vss 2.6973f
C821 vst.n2 vss 0.73198f
C822 vbn_vco.t3 vss 1.02695f
C823 vbn_vco.t4 vss 1.04317f
C824 vbn_vco.n0 vss 1.41042f
C825 vbn_vco.t1 vss 0.33799f
C826 vbn_vco.n1 vss 0.58161f
C827 vbn_vco.n2 vss 0.34678f
C828 vbn_vco.t2 vss 0.38363f
C829 vbn_vco.n3 vss 0.19204f
C830 vbn_vco.n4 vss 0.19197f
C831 vbn_vco.n5 vss 0.14876f
C832 vbn_vco.n6 vss 0.19197f
C833 vbn_vco.n7 vss 0.14994f
C834 vbn_vco.n8 vss 0.19197f
C835 vbn_vco.n9 vss 0.23979f
C836 vbn_vco.n10 vss 0.20143f
C837 vbn_vco.n11 vss 1.00305f
C838 vbn_vco.n12 vss 1.0925f
C839 vnt.t0 vss 1.01926f
C840 vnt.t7 vss 0.68774f
C841 vnt.t1 vss 1.01926f
C842 vnt.n0 vss 0.28538f
C843 vnt.t6 vss 0.66958f
C844 vnt.n1 vss 0.7169f
C845 vnt.t5 vss 0.71338f
C846 vnt.n2 vss 0.60532f
C847 vnt.t3 vss 0.71338f
C848 vnt.n3 vss 0.56847f
C849 vnt.t4 vss 0.71338f
C850 vnt.n4 vss 0.90737f
C851 vnt.t2 vss 0.74973f
C852 vnt.n5 vss 0.48797f
C853 vi.t0 vss 1.08013f
C854 vi.t2 vss 1.50214f
C855 vi.t3 vss 1.01665f
C856 vi.n0 vss 1.3154f
C857 vi.t4 vss 1.01665f
C858 vi.n1 vss 0.46599f
C859 vi.t1 vss 1.1022f
C860 vi.n2 vss 0.82546f
C861 a_17300_1144.t1 vss 0.35042f
C862 a_17300_1144.t3 vss 0.24306f
C863 a_17300_1144.t2 vss 0.2434f
C864 a_17300_1144.n0 vss 0.33515f
C865 a_17300_1144.n1 vss 0.46601f
C866 a_17300_1144.t0 vss 0.35241f
C867 a_17984_1144.t2 vss 0.3455f
C868 a_17984_1144.t1 vss 0.24084f
C869 a_17984_1144.t0 vss 0.24118f
C870 a_17984_1144.n0 vss 0.32533f
C871 a_17984_1144.n1 vss 0.45235f
C872 a_17984_1144.t3 vss 0.34358f
C873 a_18668_1144.t1 vss 0.33938f
C874 a_18668_1144.t3 vss 0.24002f
C875 a_18668_1144.t2 vss 0.24035f
C876 a_18668_1144.n0 vss 0.32166f
C877 a_18668_1144.n1 vss 0.44725f
C878 a_18668_1144.t0 vss 0.34128f
C879 a_19352_1144.t1 vss 0.33213f
C880 a_19352_1144.t3 vss 0.23987f
C881 a_19352_1144.t2 vss 0.2402f
C882 a_19352_1144.n0 vss 0.32101f
C883 a_19352_1144.n1 vss 0.44635f
C884 a_19352_1144.t0 vss 0.33404f
C885 a_20036_1144.t2 vss 0.33112f
C886 a_20036_1144.t1 vss 0.23755f
C887 a_20036_1144.t0 vss 0.23789f
C888 a_20036_1144.n0 vss 0.31077f
C889 a_20036_1144.n1 vss 0.43211f
C890 a_20036_1144.t3 vss 0.32929f
C891 r2.t2 vss 0.12807f
C892 r2.n0 vss 0.2535f
C893 r2.n1 vss 0.32188f
C894 r2.n2 vss 0.21233f
C895 r2.n3 vss 0.17202f
C896 r2.n4 vss 0.19153f
C897 r2.t0 vss 0.07212f
C898 r2.t1 vss 0.07229f
C899 r2.n5 vss 0.10184f
C900 r2.t3 vss 0.12821f
C901 r1.t0 vss 0.12172f
C902 r1.n0 vss 0.2657f
C903 r1.n1 vss 0.34086f
C904 r1.n2 vss 0.22225f
C905 r1.n3 vss 0.17279f
C906 r1.n4 vss 0.20821f
C907 r1.t2 vss 0.06801f
C908 r1.t3 vss 0.06815f
C909 r1.n5 vss 0.10038f
C910 r1.t1 vss 0.12185f
C911 r3.t0 vss 0.12696f
C912 r3.n0 vss 0.24993f
C913 r3.n1 vss 0.33017f
C914 r3.n2 vss 0.21022f
C915 r3.n3 vss 0.17776f
C916 r3.n4 vss 0.19721f
C917 r3.t2 vss 0.07139f
C918 r3.t1 vss 0.07155f
C919 r3.n5 vss 0.10711f
C920 r3.t3 vss 0.1271f
C921 r5.t0 vss 0.12027f
C922 r5.n0 vss 0.22445f
C923 r5.n1 vss 0.28385f
C924 r5.n2 vss 0.18879f
C925 r5.n3 vss 0.15964f
C926 r5.n4 vss 0.18063f
C927 r5.n5 vss 0.16806f
C928 r5.n6 vss 0.17007f
C929 r5.n7 vss 0.17365f
C930 r5.n8 vss 0.1373f
C931 r5.t2 vss 0.06799f
C932 r5.t3 vss 0.06815f
C933 r5.n9 vss 0.09619f
C934 r5.t1 vss 0.12041f
C935 r4.t0 vss 0.12662f
C936 r4.n0 vss 0.25196f
C937 r4.n1 vss 0.32536f
C938 r4.n2 vss 0.21104f
C939 r4.n3 vss 0.17098f
C940 r4.n4 vss 0.19579f
C941 r4.t3 vss 0.07126f
C942 r4.t2 vss 0.07143f
C943 r4.n5 vss 0.10122f
C944 r4.t1 vss 0.12676f
C945 nb.t2 vss 0.09804f
C946 nb.n0 vss 0.18766f
C947 nb.t3 vss 0.08171f
C948 nb.t0 vss 0.08185f
C949 nb.n1 vss 0.1374f
C950 nb.t5 vss 0.0815f
C951 nb.t4 vss 0.08164f
C952 nb.n2 vss 0.14213f
C953 nb.n3 vss 0.30018f
C954 nb.n4 vss 0.19156f
C955 nb.n5 vss 0.19341f
C956 nb.n6 vss 0.16687f
C957 nb.n7 vss 0.19766f
C958 nb.n8 vss 0.2337f
C959 nb.n9 vss 0.23662f
C960 nb.t1 vss 0.09785f
C961 a_17304_0.t0 vss 0.12109f
C962 a_17304_0.t3 vss 0.12186f
C963 a_17304_0.t2 vss 0.08486f
C964 a_17304_0.t1 vss 0.08514f
C965 a_17304_0.n0 vss 0.07739f
C966 a_17304_0.n1 vss 0.29339f
C967 a_17988_0.t0 vss 0.08636f
C968 a_17988_0.n0 vss 0.08193f
C969 a_17988_0.t2 vss 0.12674f
C970 a_17988_0.t3 vss 0.12757f
C971 a_17988_0.n1 vss 0.31059f
C972 a_17988_0.t1 vss 0.08609f
C973 a_18672_0.t0 vss 0.08614f
C974 a_18672_0.n0 vss 0.0811f
C975 a_18672_0.t2 vss 0.12521f
C976 a_18672_0.t3 vss 0.12602f
C977 a_18672_0.n1 vss 0.30744f
C978 a_18672_0.t1 vss 0.08587f
C979 a_19356_0.t0 vss 0.12139f
C980 a_19356_0.t3 vss 0.12056f
C981 a_19356_0.t2 vss 0.08574f
C982 a_19356_0.t1 vss 0.08601f
C983 a_19356_0.n0 vss 0.08064f
C984 a_19356_0.n1 vss 0.30572f
C985 a_20040_0.t0 vss 0.1106f
C986 a_20040_0.t1 vss 0.11125f
C987 a_20040_0.t3 vss 0.0822f
C988 a_20040_0.t2 vss 0.08247f
C989 a_20040_0.n0 vss 0.06754f
C990 a_20040_0.n1 vss 0.25603f
C991 a_20724_n100.t1 vss 0.07461f
C992 a_20724_n100.n0 vss 0.05254f
C993 a_20724_n100.t2 vss 0.12194f
C994 a_20724_n100.n1 vss 0.17794f
C995 a_20724_n100.t3 vss 0.1247f
C996 a_20724_n100.t0 vss 0.07442f
C997 vss.t136 vss 0.29709f
C998 vss.t133 vss 0.43699f
C999 vss.t131 vss 0.43699f
C1000 vss.t110 vss 0.29709f
C1001 vss.t55 vss 0.43449f
C1002 vss.t112 vss 0.4211f
C1003 vss.t53 vss 0.4211f
C1004 vss.t70 vss 0.4211f
C1005 vss.t108 vss 0.4211f
C1006 vss.t49 vss 0.4211f
C1007 vss.t129 vss 0.32905f
C1008 vss.t62 vss 0.32905f
C1009 vss.t3 vss 0.30237f
C1010 vss.t24 vss 0.14055f
C1011 vss.t122 vss 0.1328f
C1012 vss.t19 vss 0.1328f
C1013 vss.t9 vss 0.10655f
C1014 vss.t31 vss 0.1328f
C1015 vss.t64 vss 0.95536f
C1016 vss.t36 vss 1.06614f
C1017 vss.t73 vss 1.06614f
C1018 vss.t13 vss 1.06614f
C1019 vss.t68 vss 1.06614f
C1020 vss.t38 vss 0.95536f
C1021 vss.t126 vss 2.09934f
C1022 vss.t104 vss 0.16927f
C1023 vss.t141 vss 0.19744f
C1024 vss.t41 vss 1.4801f
C1025 vss.t93 vss 1.20511f
C1026 vss.t1 vss 1.18025f
C1027 vss.t106 vss 1.18025f
C1028 vss.t7 vss 1.18025f
C1029 vss.t81 vss 76.2321f
C1030 vss.t5 vss 0.05974f
C1031 vss.t114 vss 0.05962f
C1032 vss.t47 vss 0.06021f
C1033 vss.t45 vss 0.06003f
C1034 vss.t100 vss 0.06421f
C1035 vss.t143 vss 0.06394f
C1036 vss.t77 vss 0.06421f
C1037 vss.t79 vss 0.06394f
C1038 vss.t95 vss 0.06421f
C1039 vss.t97 vss 0.06394f
C1040 vss.t57 vss 0.06421f
C1041 vss.t59 vss 0.06394f
C1042 vss.t87 vss 0.06421f
C1043 vss.t89 vss 0.06394f
C1044 vss.t119 vss 65.9585f
C1045 vdd.t59 vss 3.05435f
C1046 vdd.n0 vss 2.55827f
C1047 vdd.t93 vss 3.18746f
C1048 vdd.n1 vss 0.09773f
C1049 vdd.t7 vss 3.18746f
C1050 vdd.n2 vss 0.09933f
C1051 vdd.n3 vss 0.28358f
C1052 vdd.t95 vss 3.05435f
C1053 vdd.n4 vss 0.08256f
C1054 vdd.t72 vss 1.31751f
C1055 vdd.n5 vss 0.21715f
C1056 vdd.t68 vss 1.28697f
C1057 vdd.n6 vss 0.21874f
C1058 vdd.n7 vss 0.28358f
C1059 vdd.t21 vss 1.28697f
C1060 vdd.n8 vss 0.20197f
C1061 vdd.t32 vss 1.28697f
C1062 vdd.n9 vss 0.21715f
C1063 vdd.t70 vss 1.28697f
C1064 vdd.n10 vss 0.21874f
C1065 vdd.n11 vss 0.28358f
C1066 vdd.t74 vss 1.28697f
C1067 vdd.n12 vss 0.20197f
C1068 vdd.t39 vss 0.89612f
C1069 vdd.n13 vss 0.21715f
C1070 vdd.t66 vss 1.28697f
C1071 vdd.n14 vss 0.21874f
C1072 vdd.n15 vss 0.28358f
C1073 vdd.t37 vss 1.28697f
C1074 vdd.n16 vss 0.20197f
C1075 vdd.t87 vss 1.28697f
C1076 vdd.n17 vss 0.21715f
C1077 vdd.t53 vss 1.28697f
C1078 vdd.n18 vss 0.21874f
C1079 vdd.n19 vss 0.28358f
C1080 vdd.t77 vss 1.28697f
C1081 vdd.n20 vss 0.20197f
C1082 vdd.t64 vss 1.28697f
C1083 vdd.n21 vss 0.21715f
C1084 vdd.t13 vss 1.28697f
C1085 vdd.n22 vss 0.21874f
C1086 vdd.n23 vss 2.77792f
C1087 vdd.n24 vss 2.77792f
C1088 vdd.n25 vss 2.77792f
C1089 vdd.n26 vss 2.77792f
C1090 vdd.n27 vss 2.77792f
C1091 vdd.t6 vss 3.1197f
C1092 vdd.t12 vss 3.61299f
C1093 vdd.t20 vss 3.1197f
C1094 vdd.t31 vss 3.57672f
C1095 vdd.t36 vss 3.1197f
C1096 vdd.t38 vss 3.57672f
C1097 vdd.t52 vss 3.1197f
C1098 vdd.t58 vss 3.62006f
C1099 vdd.t63 vss 3.57672f
C1100 vdd.t65 vss 3.1197f
C1101 vdd.t67 vss 3.1197f
C1102 vdd.t69 vss 3.1197f
C1103 vdd.t71 vss 3.57672f
C1104 vdd.t73 vss 3.1197f
C1105 vdd.t76 vss 3.1197f
C1106 vdd.t86 vss 3.57672f
C1107 vdd.t92 vss 3.57672f
C1108 vdd.t94 vss 3.1197f
C1109 vdd.n28 vss 3.29792f
C1110 vdd.n29 vss 1.06651f
C1111 vdd.n30 vss 0.18499f
C1112 vdd.t1 vss 0.61549f
C1113 vdd.n31 vss 0.07386f
C1114 vdd.t23 vss 0.74895f
C1115 vdd.n32 vss 0.08904f
C1116 vdd.t3 vss 0.74895f
C1117 vdd.n33 vss 0.09063f
C1118 vdd.n34 vss 0.1175f
C1119 vdd.t114 vss 0.61549f
C1120 vdd.n35 vss 0.07386f
C1121 vdd.t111 vss 0.32873f
C1122 vdd.n36 vss 0.09384f
C1123 vdd.t97 vss 0.54463f
C1124 vdd.n37 vss 0.08368f
C1125 vdd.t41 vss 0.18151f
C1126 vdd.n38 vss 0.0966f
C1127 vdd.t43 vss 0.1737f
C1128 vdd.n39 vss 0.09819f
C1129 vdd.n40 vss 0.10734f
C1130 vdd.t45 vss 0.20119f
C1131 vdd.n41 vss 0.07867f
C1132 vdd.t99 vss 2.05547f
C1133 vdd.n42 vss 0.16103f
C1134 vdd.n43 vss 0.15629f
C1135 vdd.t121 vss 0.32f
C1136 vdd.n44 vss 0.09105f
C1137 vdd.t91 vss 0.37237f
C1138 vdd.n45 vss 0.06489f
C1139 vdd.t89 vss 0.37237f
C1140 vdd.n46 vss 0.06648f
C1141 vdd.n47 vss 0.10864f
C1142 vdd.t119 vss 0.32f
C1143 vdd.n48 vss 0.05857f
C1144 vdd.t51 vss 0.17448f
C1145 vdd.n49 vss 0.09949f
C1146 vdd.n50 vss 0.62743f
C1147 vdd.n51 vss 0.67851f
C1148 vdd.n52 vss 0.72959f
C1149 vdd.n53 vss 0.55388f
C1150 vdd.n54 vss 1.06161f
C1151 vdd.n55 vss 0.57635f
C1152 vdd.t0 vss 0.80194f
C1153 vdd.t2 vss 0.80194f
C1154 vdd.t5 vss 0.71511f
C1155 vdd.t17 vss 0.71511f
C1156 vdd.t18 vss 0.71511f
C1157 vdd.t19 vss 0.57209f
C1158 vdd.t22 vss 0.91942f
C1159 vdd.t33 vss 0.71511f
C1160 vdd.t40 vss 0.568f
C1161 vdd.t42 vss 0.53837f
C1162 vdd.t44 vss 1.03486f
C1163 vdd.t50 vss 0.58738f
C1164 vdd.t88 vss 0.57209f
C1165 vdd.t90 vss 0.61295f
C1166 vdd.t96 vss 0.568f
C1167 vdd.t98 vss 1.53135f
C1168 vdd.t101 vss 0.69059f
C1169 vdd.t102 vss 0.64871f
C1170 vdd.t103 vss 0.64871f
C1171 vdd.t104 vss 0.64871f
C1172 vdd.t110 vss 0.65586f
C1173 vdd.t112 vss 0.61295f
C1174 vdd.t113 vss 0.71409f
C1175 vdd.t118 vss 0.56085f
C1176 vdd.t120 vss 0.61295f
C1177 vdd.n56 vss 0.82137f
C1178 vdd.n57 vss 0.27773f
C1179 vdd.n58 vss 1.47307f
C1180 vdd.n59 vss 0.51916f
C1181 vdd.n60 vss 0.04098f
C1182 vdd.n61 vss 0.51916f
C1183 vdd.n62 vss 0.04098f
C1184 vdd.n63 vss 0.49493f
C1185 vdd.n64 vss 0.03708f
C1186 vdd.t4 vss 0.73807f
C1187 vdd.t8 vss 0.20484f
C1188 vdd.t10 vss 0.17621f
C1189 vdd.t14 vss 1.31716f
C1190 vdd.t16 vss 0.39647f
C1191 vdd.t24 vss 0.57708f
C1192 vdd.t26 vss 0.17621f
C1193 vdd.t28 vss 0.52863f
C1194 vdd.t29 vss 0.65638f
C1195 vdd.t34 vss 0.65638f
C1196 vdd.t48 vss 0.65638f
C1197 vdd.t46 vss 0.23568f
C1198 vdd.t54 vss 0.57708f
C1199 vdd.t56 vss 0.17621f
C1200 vdd.t60 vss 0.6806f
C1201 vdd.t62 vss 0.22467f
C1202 vdd.t75 vss 0.22467f
C1203 vdd.t78 vss 0.22467f
C1204 vdd.t79 vss 0.5969f
C1205 vdd.t81 vss 0.46034f
C1206 vdd.t83 vss 0.17621f
C1207 vdd.t85 vss 0.22467f
C1208 vdd.t100 vss 0.52863f
C1209 vdd.t105 vss 0.57708f
C1210 vdd.t107 vss 0.17621f
C1211 vdd.t109 vss 0.14097f
C1212 vdd.t115 vss 0.22467f
C1213 vdd.t116 vss 0.65638f
C1214 vdd.t108 vss 0.26345f
C1215 vdd.n65 vss 0.10642f
C1216 vdd.t106 vss 0.26378f
C1217 vdd.n66 vss 0.09553f
C1218 vdd.t11 vss 0.26345f
C1219 vdd.n67 vss 0.09491f
C1220 vdd.t9 vss 0.26378f
C1221 vdd.n68 vss 0.07524f
C1222 vdd.t27 vss 0.26345f
C1223 vdd.n69 vss 0.09553f
C1224 vdd.t25 vss 0.26378f
C1225 vdd.n70 vss 0.09553f
C1226 vdd.t84 vss 0.26345f
C1227 vdd.n71 vss 0.09553f
C1228 vdd.t82 vss 0.26378f
C1229 vdd.n72 vss 0.09553f
C1230 vdd.t57 vss 0.26345f
C1231 vdd.n73 vss 0.07489f
C1232 vdd.t55 vss 0.26378f
C1233 vdd.n74 vss 0.09526f
C1234 vdd.t61 vss 0.10848f
C1235 vdd.n75 vss 0.1351f
C1236 vdd.t30 vss 0.10863f
C1237 vdd.n76 vss 0.1351f
C1238 vdd.t49 vss 0.12462f
C1239 vdd.n77 vss 0.13253f
C1240 vdd.t47 vss 0.12482f
C1241 vdd.n78 vss 0.12066f
C1242 vdd.t80 vss 0.15045f
C1243 vdd.n79 vss 0.12805f
C1244 vdd.t117 vss 0.15058f
C1245 vdd.n80 vss 0.12805f
C1246 vdd.t35 vss 0.15045f
C1247 vdd.n81 vss 0.26019f
C1248 vdd.t15 vss 0.15889f
C1249 vdd.n82 vss 1.42548f
C1250 pfd_dn.n0 vss 11.9824f
C1251 pfd_dn.n1 vss 11.3249f
C1252 cp_trim0.n0 vss 9.24656f
C1253 cp_trim1.n0 vss 8.97157f
C1254 vctrl.t2 vss 1.02418f
C1255 vctrl.t1 vss 0.62024f
C1256 vctrl.n0 vss 2.04272f
C1257 vctrl.n1 vss 0.36149f
C1258 vctrl.n2 vss 0.20245f
C1259 vctrl.n3 vss 0.20618f
C1260 vctrl.t0 vss 0.39563f
C1261 vctrl.n4 vss 0.57598f
C1262 vctrl.n5 vss 0.38962f
C1263 vctrl.n6 vss 0.52533f
C1264 vctrl.n7 vss 0.89137f
C1265 vctrl.n8 vss 0.69159f
C1266 vctrl.n9 vss 0.12765f
C1267 vctrl.n10 vss 0.50124f
C1268 pfd_up.n0 vss 5.19197f
C1269 pfd_up.n1 vss 11.4876f
C1270 pll_en.n0 vss 1.6578f
C1271 pll_en.n1 vss 2.42797f
C1272 pll_en.n2 vss 2.63971f
C1273 pll_en.n3 vss 2.49901f
C1274 pll_en.n4 vss 9.43351f
C1275 pll_en.n5 vss 2.0428f
C1276 pll_en.n6 vss 2.46764f
C1277 pll_en.n7 vss 0.23981f
C1278 pll_en.n8 vss 0.22268f
C1279 pll_en.n9 vss 0.22559f
C1280 bias_ref.t0 vss 0.37443f
C1281 bias_ref.t1 vss 0.2151f
C1282 bias_ref.n0 vss 7.64518f
C1283 vco_out.t2 vss 0.10924f
C1284 vco_out.t1 vss 0.10937f
C1285 vco_out.n0 vss 0.26138f
C1286 vco_out.n1 vss 0.58945f
C1287 vco_out.t3 vss 0.10924f
C1288 vco_out.t5 vss 0.10937f
C1289 vco_out.n2 vss 0.20424f
C1290 vco_out.t4 vss 0.10908f
C1291 vco_out.t0 vss 0.1092f
C1292 vco_out.n3 vss 0.1997f
C1293 vco_out.n4 vss 0.26873f
.ends
