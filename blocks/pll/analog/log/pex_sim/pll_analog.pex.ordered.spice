* NGSPICE file created from pll_analog.ext - technology: gf180mcuD

.subckt pll_analog vco_out pfd_up pfd_dn pll_en cp_trim0 cp_trim1 vctrl bias_ref vdd vss
X0 nb.t2 r5.t9 vdd.t72 vdd.t71 pfet_03v3 ad=0.52p pd=2.52u as=1.3p ps=5.3u w=2u l=0.28u
X1 a_17258_0.t1 r3.t4 r4.t2 vss.t38 nfet_03v3 ad=0.915p pd=4.22u as=0.39p ps=2.02u w=1.5u l=0.28u
X2 a_14400_19930# a_13800_12478# vss.t41 ppolyf_u r_width=1u r_length=36.6u
X3 vdump.t7 vdump.t6 vbt.t3 vdd.t26 pfet_03v3 ad=3.25p pd=11.3u as=3.25p ps=11.3u w=5u l=1u
X4 t1a.t0 vbp.t12 vdd.t28 vdd.t27 pfet_03v3 ad=2.6p pd=9.3u as=2.6p ps=9.3u w=4u l=2u
X5 vss.t119 vbn_vco.t13 a_15650_0.t2 vss.t118 nfet_03v3 ad=1.22p pd=5.22u as=0.52p ps=2.52u w=2u l=0.5u
X6 vcp_n.t4 cp_trim1.t1 t2.t1 vss.t78 nfet_03v3 ad=1.22p pd=5.22u as=1.22p ps=5.22u w=2u l=0.28u
X7 vfilt vss.t29 cap_mim_2f0_m4m5_noshield c_width=100u c_length=100u
X8 a_18062_0.t2 vbn_vco.t8 vss.t86 vss.t85 nfet_03v3 ad=0.52p pd=2.52u as=1.22p ps=5.22u w=2u l=0.5u
X9 a_18058_1524.t3 vbp_vco.t10 vdd.t98 vdd.t97 pfet_03v3 ad=1.3p pd=5.52u as=3.25p ps=11.3u w=5u l=0.5u
X10 up_b.t0 pfd_up.t2 vss.t83 vss.t82 nfet_03v3 ad=0.61p pd=3.22u as=0.61p ps=3.22u w=1u l=0.28u
X11 a_17258_0.t0 vbn_vco.t10 vss.t25 vss.t24 nfet_03v3 ad=0.52p pd=2.52u as=1.22p ps=5.22u w=2u l=0.5u
X12 vdd.t84 pll_en.t2 nb.t4 vdd.t83 pfet_03v3 ad=1.3p pd=5.3u as=0.52p ps=2.52u w=2u l=0.28u
X13 vnt.t5 vref.t5 vss.t134 vss.t133 nfet_03v3 ad=1.22p pd=5.22u as=1.22p ps=5.22u w=2u l=2u
X14 vdump.t17 pfd_up.t0 up_s.t3 vdd.t63 pfet_03v3 ad=2.6p pd=9.3u as=2.6p ps=9.3u w=4u l=0.5u
X15 a_10800_19930# a_11400_12478# vss.t105 ppolyf_u r_width=1u r_length=36.6u
X16 vdump.t13 vbh.t6 vdd.t90 vdd.t89 pfet_03v3 ad=2.6p pd=9.3u as=2.6p ps=9.3u w=4u l=2u
X17 vnt.t4 vref.t9 vss.t121 vss.t120 nfet_03v3 ad=1.22p pd=5.22u as=1.22p ps=5.22u w=2u l=2u
X18 vcp_n.t7 en_b.t7 vss.t5 vss.t4 nfet_03v3 ad=0.61p pd=3.22u as=0.61p ps=3.22u w=1u l=0.28u
X19 a_18866_0.t3 vbn_vco.t6 vss.t142 vss.t141 nfet_03v3 ad=0.52p pd=2.52u as=1.22p ps=5.22u w=2u l=0.5u
X20 vi.t2 vref.t10 vss.t125 vss.t124 nfet_03v3 ad=1.22p pd=5.22u as=1.22p ps=5.22u w=2u l=2u
X21 vbh.t1 vbh.t0 vdd.t10 vdd.t9 pfet_03v3 ad=2.6p pd=9.3u as=2.6p ps=9.3u w=4u l=2u
X22 vi.t3 vctrl.t5 vs.t1 vss.t137 nfet_03v3 ad=3.05p pd=11.22u as=3.05p ps=11.22u w=5u l=1u
X23 up_s.t1 vcp_p.t8 vdd.t23 vdd.t22 pfet_03v3 ad=16.25p pd=51.3u as=16.25p ps=51.3u w=25u l=2u
X24 r3.t1 r2.t5 a_15650_0.t1 vss.t37 nfet_03v3 ad=0.39p pd=2.02u as=0.915p ps=4.22u w=1.5u l=0.28u
X25 vcp_p.t2 vcp_p.t1 vdd.t88 vdd.t87 pfet_03v3 ad=16.25p pd=51.3u as=16.25p ps=51.3u w=25u l=2u
X26 vbt.t7 vbp.t15 vdd.t59 vdd.t58 pfet_03v3 ad=2.6p pd=9.3u as=2.6p ps=9.3u w=4u l=2u
X27 a_6600_18610# a_7200_12478# vss.t9 ppolyf_u r_width=1u r_length=30u
X28 a_18062_0.t0 r5.t6 r1.t1 vss.t63 nfet_03v3 ad=0.915p pd=4.22u as=0.39p ps=2.02u w=1.5u l=0.28u
X29 vdd.t14 vbp_vco.t11 a_17254_1524.t0 vdd.t13 pfet_03v3 ad=3.25p pd=11.3u as=1.3p ps=5.52u w=5u l=0.5u
X30 vdd.t119 vbp_vco.t7 a_18862_1524.t2 vdd.t118 pfet_03v3 ad=3.25p pd=11.3u as=1.3p ps=5.52u w=5u l=0.5u
X31 vbt.t4 vbp.t7 vdd.t12 vdd.t11 pfet_03v3 ad=2.6p pd=9.3u as=2.6p ps=9.3u w=4u l=2u
X32 r2.t0 r1.t7 a_16450_1524.t0 vdd.t42 pfet_03v3 ad=0.78p pd=3.52u as=1.95p ps=7.3u w=3u l=0.28u
X33 vst.t2 vref.t4 vss.t81 vss.t80 nfet_03v3 ad=3.05p pd=11.22u as=3.05p ps=11.22u w=5u l=1u
X34 va.t0 vref.t7 vss.t52 vss.t51 nfet_03v3 ad=1.22p pd=5.22u as=1.22p ps=5.22u w=2u l=2u
X35 up_s.t0 vcp_p.t7 vdd.t19 vdd.t18 pfet_03v3 ad=16.25p pd=51.3u as=16.25p ps=51.3u w=25u l=2u
X36 vctrl.t2 a_400_12478# vss.t126 ppolyf_u r_width=2u r_length=37.5u
X37 a_13200_19930# a_12600_12478# vss.t54 ppolyf_u r_width=1u r_length=36.6u
X38 vbh.t3 vbh.t2 vdd.t65 vdd.t64 pfet_03v3 ad=2.6p pd=9.3u as=2.6p ps=9.3u w=4u l=2u
X39 vcp_n.t2 vbp.t14 vdd.t49 vdd.t48 pfet_03v3 ad=2.6p pd=9.3u as=2.6p ps=9.3u w=4u l=2u
X40 vs.t0 a_4200_12478# vss.t84 ppolyf_u r_width=1u r_length=17.5u
X41 r5.t1 r4.t7 a_18862_1524.t0 vdd.t110 pfet_03v3 ad=0.78p pd=3.52u as=1.95p ps=7.3u w=3u l=0.28u
X42 vcp_n.t1 vbp.t6 vdd.t36 vdd.t35 pfet_03v3 ad=2.6p pd=9.3u as=2.6p ps=9.3u w=4u l=2u
X43 a_17254_1524.t3 r3.t6 r4.t0 vdd.t0 pfet_03v3 ad=1.95p pd=7.3u as=0.78p ps=3.52u w=3u l=0.28u
X44 a_15646_1524.t1 r2.t6 r3.t2 vdd.t68 pfet_03v3 ad=1.95p pd=7.3u as=0.78p ps=3.52u w=3u l=0.28u
X45 a_18862_1524.t1 r4.t6 r5.t0 vdd.t101 pfet_03v3 ad=1.95p pd=7.3u as=0.78p ps=3.52u w=3u l=0.28u
X46 vcp_p.t4 vcp_p.t3 vdd.t34 vdd.t33 pfet_03v3 ad=16.25p pd=51.3u as=16.25p ps=51.3u w=25u l=2u
X47 vbp.t3 vbp.t2 vdd.t112 vdd.t111 pfet_03v3 ad=2.6p pd=9.3u as=2.6p ps=9.3u w=4u l=2u
X48 bias_ref.t1 a_10200_12478# vss.t43 ppolyf_u r_width=1u r_length=36.6u
X49 vdd.t53 nb.t10 vco_out.t4 vdd.t52 pfet_03v3 ad=1.95p pd=7.3u as=0.78p ps=3.52u w=3u l=0.28u
X50 vbn_vco.t1 vbn_vco.t0 vss.t7 vss.t6 nfet_03v3 ad=2.44p pd=9.22u as=2.44p ps=9.22u w=4u l=0.5u
X51 t2.t2 vbp.t13 vdd.t94 vdd.t93 pfet_03v3 ad=2.6p pd=9.3u as=2.6p ps=9.3u w=4u l=2u
X52 a_1200_20110# a_400_12478# vss.t73 ppolyf_u r_width=2u r_length=37.5u
X53 bias_ref.t0 a_8400_12478# vss.t42 ppolyf_u r_width=1u r_length=30u
X54 r2.t2 r1.t5 a_16454_0.t2 vss.t68 nfet_03v3 ad=0.39p pd=2.02u as=0.915p ps=4.22u w=1.5u l=0.28u
X55 vbl.t6 vctrl.t11 vbt.t8 vdd.t113 pfet_03v3 ad=3.25p pd=11.3u as=3.25p ps=11.3u w=5u l=1u
X56 vbl.t5 vctrl.t8 vbt.t11 vdd.t116 pfet_03v3 ad=3.25p pd=11.3u as=3.25p ps=11.3u w=5u l=1u
X57 a_18866_0.t1 r4.t4 r5.t3 vss.t103 nfet_03v3 ad=0.915p pd=4.22u as=0.39p ps=2.02u w=1.5u l=0.28u
X58 a_16450_1524.t3 vbp_vco.t14 vdd.t109 vdd.t108 pfet_03v3 ad=1.3p pd=5.52u as=3.25p ps=11.3u w=5u l=0.5u
X59 t1b.t0 vbp.t10 vdd.t55 vdd.t54 pfet_03v3 ad=2.6p pd=9.3u as=2.6p ps=9.3u w=4u l=2u
X60 vcp_p.t6 vcp_n.t12 vss.t77 vss.t76 nfet_03v3 ad=6.1p pd=21.22u as=6.1p ps=21.22u w=10u l=2u
X61 vbt.t5 vbp.t5 vdd.t47 vdd.t46 pfet_03v3 ad=2.6p pd=9.3u as=2.6p ps=9.3u w=4u l=2u
X62 vbn_vco.t4 en_b.t2 vss.t113 vss.t112 nfet_03v3 ad=0.61p pd=3.22u as=0.61p ps=3.22u w=1u l=0.28u
X63 vbt.t6 vbp.t17 vdd.t57 vdd.t56 pfet_03v3 ad=2.6p pd=9.3u as=2.6p ps=9.3u w=4u l=2u
X64 a_18862_1524.t3 vbp_vco.t8 vdd.t121 vdd.t120 pfet_03v3 ad=1.3p pd=5.52u as=3.25p ps=11.3u w=5u l=0.5u
X65 va.t1 vbp.t11 vdd.t92 vdd.t91 pfet_03v3 ad=2.6p pd=9.3u as=2.6p ps=9.3u w=4u l=2u
X66 a_14400_19930# a_15000_12478# vss.t23 ppolyf_u r_width=1u r_length=36.6u
X67 a_16454_0.t3 vbn_vco.t12 vss.t117 vss.t116 nfet_03v3 ad=0.52p pd=2.52u as=1.22p ps=5.22u w=2u l=0.5u
X68 vss.t62 nb.t6 vco_out.t1 vss.t61 nfet_03v3 ad=1.83p pd=7.22u as=0.78p ps=3.52u w=3u l=0.28u
X69 vref.t0 a_6000_12478# vss.t28 ppolyf_u r_width=1u r_length=30u
X70 vss.t102 vbn_vco.t5 a_18866_0.t0 vss.t101 nfet_03v3 ad=1.22p pd=5.22u as=0.52p ps=2.52u w=2u l=0.5u
X71 vdump.t1 vdump.t0 vbt.t2 vdd.t17 pfet_03v3 ad=3.25p pd=11.3u as=3.25p ps=11.3u w=5u l=1u
X72 up_b.t1 pfd_up.t1 vdd.t62 vdd.t61 pfet_03v3 ad=1.3p pd=5.3u as=1.3p ps=5.3u w=2u l=0.28u
X73 t2.t0 vbp.t9 vdd.t38 vdd.t37 pfet_03v3 ad=2.6p pd=9.3u as=2.6p ps=9.3u w=4u l=2u
X74 nb.t1 r5.t5 a_19968_0.t1 vss.t11 nfet_03v3 ad=0.52p pd=2.52u as=1.22p ps=5.22u w=2u l=0.28u
X75 vbn_vco.t2 vbp_vco.t17 vdd.t30 vdd.t29 pfet_03v3 ad=3.25p pd=11.3u as=3.25p ps=11.3u w=5u l=0.5u
X76 vbl.t3 vbl.t2 vss.t49 vss.t48 nfet_03v3 ad=1.22p pd=5.22u as=1.22p ps=5.22u w=2u l=2u
X77 a_15650_0.t3 vbn_vco.t14 vss.t144 vss.t143 nfet_03v3 ad=0.52p pd=2.52u as=1.22p ps=5.22u w=2u l=0.5u
X78 vcp_n.t3 cp_trim1.t0 t1c.t0 vss.t79 nfet_03v3 ad=1.22p pd=5.22u as=1.22p ps=5.22u w=2u l=0.28u
X79 vst.t3 vref.t3 vss.t108 vss.t107 nfet_03v3 ad=3.05p pd=11.22u as=3.05p ps=11.22u w=5u l=1u
X80 vbp_vco.t6 pll_en.t4 vi.t1 vss.t94 nfet_03v3 ad=3.05p pd=11.22u as=3.05p ps=11.22u w=5u l=0.28u
X81 vcp_n.t0 vbp.t16 vdd.t25 vdd.t24 pfet_03v3 ad=2.6p pd=9.3u as=2.6p ps=9.3u w=4u l=2u
X82 vcp_n.t11 vcp_n.t10 vss.t90 vss.t89 nfet_03v3 ad=6.1p pd=21.22u as=6.1p ps=21.22u w=10u l=2u
X83 a_12000_19930# a_11400_12478# vss.t104 ppolyf_u r_width=1u r_length=36.6u
X84 vdd.t103 vbp_vco.t15 a_15646_1524.t2 vdd.t102 pfet_03v3 ad=3.25p pd=11.3u as=1.3p ps=5.52u w=5u l=0.5u
X85 vst.t0 en_b.t5 vss.t19 vss.t18 nfet_03v3 ad=0.61p pd=3.22u as=0.61p ps=3.22u w=1u l=0.28u
X86 vnt.t3 vref.t6 vss.t115 vss.t114 nfet_03v3 ad=1.22p pd=5.22u as=1.22p ps=5.22u w=2u l=2u
X87 a_1200_20110# a_2000_12478# vss.t99 ppolyf_u r_width=2u r_length=37.5u
X88 vcl.t4 vref.t14 vss.t123 vss.t122 nfet_03v3 ad=6.1p pd=21.22u as=6.1p ps=21.22u w=10u l=2u
X89 vdump.t9 vdump.t8 vnt.t2 vss.t106 nfet_03v3 ad=3.05p pd=11.22u as=3.05p ps=11.22u w=5u l=1u
X90 vbp_vco.t5 pll_en.t5 vi.t0 vss.t93 nfet_03v3 ad=3.05p pd=11.22u as=3.05p ps=11.22u w=5u l=0.28u
X91 vcl.t2 vref.t13 vss.t60 vss.t59 nfet_03v3 ad=6.1p pd=21.22u as=6.1p ps=21.22u w=10u l=2u
X92 r4.t3 r3.t5 a_17258_0.t2 vss.t39 nfet_03v3 ad=0.39p pd=2.02u as=0.915p ps=4.22u w=1.5u l=0.28u
X93 vdd.t40 nb.t8 vco_out.t2 vdd.t39 pfet_03v3 ad=1.95p pd=7.3u as=0.78p ps=3.52u w=3u l=0.28u
X94 dn_b.t0 pfd_dn.t1 vss.t33 vss.t32 nfet_03v3 ad=0.61p pd=3.22u as=0.61p ps=3.22u w=1u l=0.28u
X95 vbl.t7 vctrl.t10 vbt.t9 vdd.t114 pfet_03v3 ad=3.25p pd=11.3u as=3.25p ps=11.3u w=5u l=1u
X96 vctrl.t1 up_b.t2 up_s.t2 vdd.t60 pfet_03v3 ad=2.6p pd=9.3u as=2.6p ps=9.3u w=4u l=0.5u
X97 vco_out.t0 nb.t9 vdd.t8 vdd.t7 pfet_03v3 ad=0.78p pd=3.52u as=1.95p ps=7.3u w=3u l=0.28u
X98 vcp_n.t9 vcp_n.t8 vss.t13 vss.t12 nfet_03v3 ad=6.1p pd=21.22u as=6.1p ps=21.22u w=10u l=2u
X99 r4.t1 r3.t7 a_17254_1524.t2 vdd.t1 pfet_03v3 ad=0.78p pd=3.52u as=1.95p ps=7.3u w=3u l=0.28u
X100 r3.t3 r2.t7 a_15646_1524.t0 vdd.t69 pfet_03v3 ad=0.78p pd=3.52u as=1.95p ps=7.3u w=3u l=0.28u
X101 vcp_n.t5 vbp.t8 vdd.t67 vdd.t66 pfet_03v3 ad=2.6p pd=9.3u as=2.6p ps=9.3u w=4u l=2u
X102 vcp_n.t6 cp_trim0.t1 t1a.t1 vss.t109 nfet_03v3 ad=1.22p pd=5.22u as=1.22p ps=5.22u w=2u l=0.28u
X103 vdump.t16 vbl.t8 vss.t35 vss.t34 nfet_03v3 ad=1.22p pd=5.22u as=1.22p ps=5.22u w=2u l=2u
X104 vco_out.t3 nb.t11 vdd.t45 vdd.t44 pfet_03v3 ad=0.78p pd=3.52u as=1.95p ps=7.3u w=3u l=0.28u
X105 vdump.t5 vdump.t4 vbt.t0 vdd.t117 pfet_03v3 ad=3.25p pd=11.3u as=3.25p ps=11.3u w=5u l=1u
X106 vcl.t1 vref.t12 vss.t58 vss.t57 nfet_03v3 ad=6.1p pd=21.22u as=6.1p ps=21.22u w=10u l=2u
X107 vdump.t11 vdump.t10 vnt.t1 vss.t100 nfet_03v3 ad=3.05p pd=11.22u as=3.05p ps=11.22u w=5u l=1u
X108 t1c.t1 cp_trim0.t0 t1b.t1 vss.t110 nfet_03v3 ad=1.22p pd=5.22u as=1.22p ps=5.22u w=2u l=0.28u
X109 vi.t4 vctrl.t4 vs.t2 vss.t138 nfet_03v3 ad=3.05p pd=11.22u as=3.05p ps=11.22u w=5u l=1u
X110 a_7800_18610# a_7200_12478# vss.t145 ppolyf_u r_width=1u r_length=30u
X111 vbh.t4 vctrl.t7 vnt.t6 vss.t135 nfet_03v3 ad=3.05p pd=11.22u as=3.05p ps=11.22u w=5u l=1u
X112 a_15650_0.t0 r2.t4 r3.t0 vss.t36 nfet_03v3 ad=0.915p pd=4.22u as=0.39p ps=2.02u w=1.5u l=0.28u
X113 a_18058_1524.t1 r5.t10 r1.t2 vdd.t70 pfet_03v3 ad=1.95p pd=7.3u as=0.78p ps=3.52u w=3u l=0.28u
X114 vss.t128 vbn_vco.t7 a_18062_0.t3 vss.t127 nfet_03v3 ad=1.22p pd=5.22u as=0.52p ps=2.52u w=2u l=0.5u
X115 r1.t0 r5.t7 a_18062_0.t1 vss.t64 nfet_03v3 ad=0.39p pd=2.02u as=0.915p ps=4.22u w=1.5u l=0.28u
X116 vnt.t0 vref.t8 vss.t1 vss.t0 nfet_03v3 ad=1.22p pd=5.22u as=1.22p ps=5.22u w=2u l=2u
X117 en_b.t1 pll_en.t7 vdd.t78 vdd.t77 pfet_03v3 ad=1.3p pd=5.3u as=1.3p ps=5.3u w=2u l=0.28u
X118 a_13200_19930# a_13800_12478# vss.t45 ppolyf_u r_width=1u r_length=36.6u
X119 vcl.t0 a_4200_12478# vss.t40 ppolyf_u r_width=1u r_length=17.5u
X120 a_15646_1524.t3 vbp_vco.t16 vdd.t105 vdd.t104 pfet_03v3 ad=1.3p pd=5.52u as=3.25p ps=11.3u w=5u l=0.5u
X121 a_17254_1524.t1 vbp_vco.t12 vdd.t16 vdd.t15 pfet_03v3 ad=1.3p pd=5.52u as=3.25p ps=11.3u w=5u l=0.5u
X122 vctrl.t3 vss.t139 cap_mim_2f0_m4m5_noshield c_width=32u c_length=32u
X123 vss.t88 vbn_vco.t9 a_17258_0.t3 vss.t87 nfet_03v3 ad=1.22p pd=5.22u as=0.52p ps=2.52u w=2u l=0.5u
X124 a_19968_0.t2 pll_en.t1 vss.t98 vss.t97 nfet_03v3 ad=0.52p pd=2.52u as=1.22p ps=5.22u w=2u l=0.28u
X125 vref.t1 en_b.t3 vss.t3 vss.t2 nfet_03v3 ad=0.61p pd=3.22u as=0.61p ps=3.22u w=1u l=0.28u
X126 vdd.t86 r5.t8 nb.t5 vdd.t85 pfet_03v3 ad=1.3p pd=5.3u as=0.52p ps=2.52u w=2u l=0.28u
X127 vbp.t0 vst.t4 vss.t75 vss.t74 nfet_03v3 ad=0.305p pd=2.22u as=0.305p ps=2.22u w=0.5u l=2u
X128 vbp.t4 va.t3 vref.t2 vss.t130 nfet_03v3 ad=2.44p pd=9.22u as=2.44p ps=9.22u w=4u l=1u
X129 vfilt a_2000_12478# vss.t22 ppolyf_u r_width=2u r_length=37.5u
X130 vss.t27 vbn_vco.t11 a_16454_0.t0 vss.t26 nfet_03v3 ad=1.22p pd=5.22u as=0.52p ps=2.52u w=2u l=0.5u
X131 vbp.t1 pll_en.t8 vdd.t76 vdd.t75 pfet_03v3 ad=0.65p pd=3.3u as=0.65p ps=3.3u w=1u l=0.28u
X132 a_10800_19930# a_10200_12478# vss.t44 ppolyf_u r_width=1u r_length=36.6u
X133 vbl.t4 vctrl.t9 vbt.t10 vdd.t115 pfet_03v3 ad=3.25p pd=11.3u as=3.25p ps=11.3u w=5u l=1u
X134 vst.t1 en_b.t6 vdd.t51 vdd.t50 pfet_03v3 ad=0.325p pd=2.3u as=0.325p ps=2.3u w=0.5u l=10u
X135 va.t2 en_b.t4 vss.t47 vss.t46 nfet_03v3 ad=0.61p pd=3.22u as=0.61p ps=3.22u w=1u l=0.28u
X136 vctrl.t0 pfd_dn.t2 dn_s.t1 vss.t31 nfet_03v3 ad=1.22p pd=5.22u as=1.22p ps=5.22u w=2u l=0.5u
X137 a_16454_0.t1 r1.t4 r2.t3 vss.t67 nfet_03v3 ad=0.915p pd=4.22u as=0.39p ps=2.02u w=1.5u l=0.28u
X138 vdd.t96 vbp_vco.t9 a_18058_1524.t2 vdd.t95 pfet_03v3 ad=3.25p pd=11.3u as=1.3p ps=5.52u w=5u l=0.5u
X139 vdd.t107 vbp_vco.t13 a_16450_1524.t2 vdd.t106 pfet_03v3 ad=3.25p pd=11.3u as=1.3p ps=5.52u w=5u l=0.5u
X140 vss.t21 a_15000_12478# vss.t20 ppolyf_u r_width=1u r_length=36.6u
X141 vbh.t5 vctrl.t6 vnt.t7 vss.t136 nfet_03v3 ad=3.05p pd=11.22u as=3.05p ps=11.22u w=5u l=1u
X142 a_6600_18610# a_6000_12478# vss.t53 ppolyf_u r_width=1u r_length=30u
X143 vdump.t14 dn_b.t2 dn_s.t3 vss.t50 nfet_03v3 ad=1.22p pd=5.22u as=1.22p ps=5.22u w=2u l=0.5u
X144 vcp_p.t5 vcp_n.t15 vss.t72 vss.t71 nfet_03v3 ad=6.1p pd=21.22u as=6.1p ps=21.22u w=10u l=2u
X145 vdump.t15 vbl.t9 vss.t66 vss.t65 nfet_03v3 ad=1.22p pd=5.22u as=1.22p ps=5.22u w=2u l=2u
X146 vbn_vco.t3 vbp_vco.t18 vdd.t32 vdd.t31 pfet_03v3 ad=3.25p pd=11.3u as=3.25p ps=11.3u w=5u l=0.5u
X147 r5.t2 r4.t5 a_18866_0.t2 vss.t111 nfet_03v3 ad=0.39p pd=2.02u as=0.915p ps=4.22u w=1.5u l=0.28u
X148 vbl.t1 vbl.t0 vss.t17 vss.t16 nfet_03v3 ad=1.22p pd=5.22u as=1.22p ps=5.22u w=2u l=2u
X149 vco_out.t5 nb.t7 vss.t132 vss.t131 nfet_03v3 ad=0.78p pd=3.52u as=1.83p ps=7.22u w=3u l=0.28u
X150 vbp_vco.t4 pll_en.t6 vdd.t82 vdd.t81 pfet_03v3 ad=0.65p pd=3.3u as=0.65p ps=3.3u w=1u l=0.28u
X151 dn_b.t1 pfd_dn.t0 vdd.t21 vdd.t20 pfet_03v3 ad=1.3p pd=5.3u as=1.3p ps=5.3u w=2u l=0.28u
X152 a_12000_19930# a_12600_12478# vss.t8 ppolyf_u r_width=1u r_length=36.6u
X153 vdump.t3 vdump.t2 vbt.t1 vdd.t2 pfet_03v3 ad=3.25p pd=11.3u as=3.25p ps=11.3u w=5u l=1u
X154 a_19968_0.t0 r5.t4 nb.t0 vss.t10 nfet_03v3 ad=1.22p pd=5.22u as=0.52p ps=2.52u w=2u l=0.28u
X155 vss.t96 pll_en.t0 a_19968_0.t3 vss.t95 nfet_03v3 ad=1.22p pd=5.22u as=0.52p ps=2.52u w=2u l=0.28u
X156 nb.t3 pll_en.t3 vdd.t80 vdd.t79 pfet_03v3 ad=0.52p pd=2.52u as=1.3p ps=5.3u w=2u l=0.28u
X157 en_b.t0 pll_en.t10 vss.t92 vss.t91 nfet_03v3 ad=0.61p pd=3.22u as=0.61p ps=3.22u w=1u l=0.28u
X158 a_16450_1524.t1 r1.t6 r2.t1 vdd.t41 pfet_03v3 ad=1.95p pd=7.3u as=0.78p ps=3.52u w=3u l=0.28u
X159 dn_s.t2 vcp_n.t14 vss.t56 vss.t55 nfet_03v3 ad=6.1p pd=21.22u as=6.1p ps=21.22u w=10u l=2u
X160 vdump.t12 vbh.t7 vdd.t6 vdd.t5 pfet_03v3 ad=2.6p pd=9.3u as=2.6p ps=9.3u w=4u l=2u
X161 r1.t3 r5.t11 a_18058_1524.t0 vdd.t43 pfet_03v3 ad=0.78p pd=3.52u as=1.95p ps=7.3u w=3u l=0.28u
X162 vcl.t3 vref.t11 vss.t70 vss.t69 nfet_03v3 ad=6.1p pd=21.22u as=6.1p ps=21.22u w=10u l=2u
X163 a_7800_18610# a_8400_12478# vss.t129 ppolyf_u r_width=1u r_length=30u
X164 dn_s.t0 vcp_n.t13 vss.t15 vss.t14 nfet_03v3 ad=6.1p pd=21.22u as=6.1p ps=21.22u w=10u l=2u
X165 vbp_vco.t1 vbp_vco.t0 vdd.t4 vdd.t3 pfet_03v3 ad=3.25p pd=11.3u as=3.25p ps=11.3u w=5u l=0.5u
X166 vcp_p.t0 pll_en.t9 vdd.t74 vdd.t73 pfet_03v3 ad=0.65p pd=3.3u as=0.65p ps=3.3u w=1u l=0.28u
X167 vbp_vco.t3 vbp_vco.t2 vdd.t100 vdd.t99 pfet_03v3 ad=3.25p pd=11.3u as=3.25p ps=11.3u w=5u l=0.5u
R0 vco_out vco_out.n1 8.6225
R1 vco_out.n1 vco_out.n4 5.7305
R2 vco_out.n4 vco_out.n3 6.77734
R3 vco_out.n3 vco_out.t5 0.5465
R4 vco_out.n3 vco_out.t1 0.5465
R5 vco_out.n4 vco_out.n2 6.61734
R6 vco_out.n2 vco_out.t3 0.607167
R7 vco_out.n2 vco_out.t4 0.607167
R8 vco_out.n1 vco_out.n0 11.1173
R9 vco_out.n0 vco_out.t0 0.607167
R10 vco_out.n0 vco_out.t2 0.607167
R11 bias_ref bias_ref.n0 56.2752
R12 bias_ref.n0 bias_ref.t1 21.0588
R13 bias_ref.n0 bias_ref.t0 23.8937
R14 pll_en pll_en.n0 10.1405
R15 pll_en.n0 pll_en.n9 6.1085
R16 pll_en.n9 pll_en.n8 5.37555
R17 pll_en.n8 pll_en.t0 45.5434
R18 pll_en.n8 pll_en.t1 45.7328
R19 pll_en.n9 pll_en.n7 6.03729
R20 pll_en.n7 pll_en.t2 45.5434
R21 pll_en.n7 pll_en.t3 45.7328
R22 pll_en.n4 pll_en.n3 4.5005
R23 pll_en.n0 pll_en.n6 11.8085
R24 pll_en.n6 pll_en.n4 4.1675
R25 pll_en.n6 pll_en.n5 5.1665
R26 pll_en.n5 pll_en.t4 96.3364
R27 pll_en.n5 pll_en.t5 95.7289
R28 pll_en.n2 pll_en.n1 1.121
R29 pll_en.n3 pll_en.n2 8.411
R30 pll_en.n3 pll_en.t6 44.7698
R31 pll_en.n2 pll_en.t7 57.513
R32 pll_en.n1 pll_en.t8 44.7023
R33 pll_en.n1 pll_en.t9 45.3278
R34 pll_en.n4 pll_en.t10 79.1968
R35 pfd_up.n1 pfd_up.n0 5.5535
R36 pfd_up pfd_up.n1 6.953
R37 pfd_up.n1 pfd_up.t2 87.3193
R38 pfd_up.n0 pfd_up.t0 55.1802
R39 pfd_up.n0 pfd_up.t1 64.4475
R40 vctrl vctrl.n10 18.4033
R41 vctrl.n10 vctrl.n6 3.9875
R42 vctrl.n6 vctrl.n0 11.903
R43 vctrl.n8 vctrl.n7 20.075
R44 vctrl.n9 vctrl.n8 0.77
R45 vctrl.n10 vctrl.n9 4.622
R46 vctrl.n9 vctrl.t4 40.0182
R47 vctrl.n8 vctrl.t5 40.0182
R48 vctrl.n7 vctrl.t6 40.0182
R49 vctrl.n7 vctrl.t7 42.3267
R50 vctrl.n2 vctrl.n1 1.283
R51 vctrl.n3 vctrl.n2 2.363
R52 vctrl.n5 vctrl.n3 1.4135
R53 vctrl.n4 vctrl.n5 11.0637
R54 vctrl.n6 vctrl.n4 9.27725
R55 vctrl.n5 vctrl.t3 9.23931
R56 vctrl.n4 vctrl.t1 12.186
R57 vctrl.n3 vctrl.t8 40.1274
R58 vctrl.n2 vctrl.t9 40.1274
R59 vctrl.n1 vctrl.t10 40.1274
R60 vctrl.n1 vctrl.t11 42.4899
R61 vctrl.n0 vctrl.t2 41.6334
R62 vctrl.n0 vctrl.t0 41.9313
R63 cp_trim1 cp_trim1.n0 21.9155
R64 cp_trim1.n0 cp_trim1.t0 58.7818
R65 cp_trim1.n0 cp_trim1.t1 59.9968
R66 cp_trim0 cp_trim0.n0 22.523
R67 cp_trim0.n0 cp_trim0.t0 58.4218
R68 cp_trim0.n0 cp_trim0.t1 59.6368
R69 pfd_dn pfd_dn.n0 7.133
R70 pfd_dn.n0 pfd_dn.n1 38.2212
R71 pfd_dn.n1 pfd_dn.t1 45.071
R72 pfd_dn.n1 pfd_dn.t2 47.265
R73 pfd_dn.n0 pfd_dn.t0 69.555
R74 vdd vdd.n83 21.8503
R75 vdd.n30 vdd.n29 3.6455
R76 vdd.n31 vdd.n30 0.43475
R77 vdd.n32 vdd.n31 1.013
R78 vdd.n33 vdd.n32 1.013
R79 vdd.n34 vdd.n33 1.07375
R80 vdd.n35 vdd.n34 0.43475
R81 vdd.n36 vdd.n35 1.013
R82 vdd.n37 vdd.n36 0.626
R83 vdd.n38 vdd.n37 0.626
R84 vdd.n39 vdd.n38 0.626
R85 vdd.n40 vdd.n39 0.68675
R86 vdd.n41 vdd.n40 0.43475
R87 vdd.n42 vdd.n41 0.626
R88 vdd.n57 vdd.n42 1.18625
R89 vdd.n43 vdd.n57 1.688
R90 vdd.n44 vdd.n43 1.78475
R91 vdd.n45 vdd.n44 0.6755
R92 vdd.n46 vdd.n45 0.6755
R93 vdd.n47 vdd.n46 0.73625
R94 vdd.n48 vdd.n47 0.43475
R95 vdd.n49 vdd.n48 0.6755
R96 vdd.n56 vdd.n49 0.68675
R97 vdd.n83 vdd.n56 7.7675
R98 vdd.n57 vdd.n82 24.2533
R99 vdd.n82 vdd.n65 0.3095
R100 vdd.n65 vdd.n66 0.3545
R101 vdd.n66 vdd.n67 0.2495
R102 vdd.n67 vdd.n58 0.254
R103 vdd.n58 vdd.n68 0.101
R104 vdd.n68 vdd.n69 0.2495
R105 vdd.n69 vdd.n70 0.3545
R106 vdd.n70 vdd.n71 0.2495
R107 vdd.n71 vdd.n60 0.248
R108 vdd.n60 vdd.n72 0.107
R109 vdd.n72 vdd.n73 0.2495
R110 vdd.n73 vdd.n74 0.3545
R111 vdd.n74 vdd.n75 0.3395
R112 vdd.n75 vdd.n62 0.152
R113 vdd.n62 vdd.n76 0.137
R114 vdd.n76 vdd.n77 0.3395
R115 vdd.n77 vdd.n78 0.2885
R116 vdd.n78 vdd.n79 0.3395
R117 vdd.n79 vdd.n64 0.098
R118 vdd.n64 vdd.n80 0.191
R119 vdd.n80 vdd.n81 0.3395
R120 vdd.n81 vdd.t40 4.86639
R121 vdd.n81 vdd.t8 4.57839
R122 vdd.n80 vdd.t53 4.57839
R123 vdd.n79 vdd.t45 4.57839
R124 vdd.n78 vdd.t86 5.64331
R125 vdd.n77 vdd.t72 5.64331
R126 vdd.n76 vdd.t84 5.64331
R127 vdd.n75 vdd.t80 5.64331
R128 vdd.n74 vdd.t119 2.01891
R129 vdd.n73 vdd.t121 2.01891
R130 vdd.n72 vdd.t96 2.01891
R131 vdd.n71 vdd.t98 2.01891
R132 vdd.n70 vdd.t14 2.01891
R133 vdd.n69 vdd.t16 2.01891
R134 vdd.n68 vdd.t107 2.01891
R135 vdd.n67 vdd.t109 2.01891
R136 vdd.n66 vdd.t103 2.01891
R137 vdd.n65 vdd.t105 2.01891
R138 vdd.n58 vdd.t106 12.6005
R139 vdd.n60 vdd.n59 12.6005
R140 vdd.n62 vdd.n61 12.6005
R141 vdd.n64 vdd.n63 12.6005
R142 vdd.n82 vdd.t69 203.654
R143 vdd.t69 vdd.t104 7.37315
R144 vdd.t104 vdd.t68 46.2471
R145 vdd.t68 vdd.t102 22.1185
R146 vdd.t102 vdd.t42 193.701
R147 vdd.t108 vdd.t42 7.37315
R148 vdd.t41 vdd.t108 46.2471
R149 vdd.t106 vdd.t41 22.1185
R150 vdd.t106 vdd.t1 193.701
R151 vdd.t1 vdd.t15 7.37315
R152 vdd.t15 vdd.t0 46.2471
R153 vdd.t0 vdd.t13 22.1185
R154 vdd.t43 vdd.t13 193.701
R155 vdd.t97 vdd.t43 7.37315
R156 vdd.t70 vdd.t97 46.2471
R157 vdd.n59 vdd.t70 19.4375
R158 vdd.n59 vdd.t95 2.68147
R159 vdd.t95 vdd.t110 193.701
R160 vdd.t110 vdd.t120 7.37315
R161 vdd.t120 vdd.t101 46.2471
R162 vdd.t101 vdd.t118 22.1185
R163 vdd.t79 vdd.t118 233.915
R164 vdd.n61 vdd.t79 30.1614
R165 vdd.n61 vdd.t83 23.4589
R166 vdd.t83 vdd.t71 226.542
R167 vdd.t71 vdd.t85 53.6198
R168 vdd.t44 vdd.t85 226.542
R169 vdd.n63 vdd.t44 6.03267
R170 vdd.n63 vdd.t52 47.5876
R171 vdd.t52 vdd.t7 226.542
R172 vdd.t7 vdd.t39 53.6198
R173 vdd.n29 vdd.t113 438.584
R174 vdd.t113 vdd.t117 505.781
R175 vdd.t117 vdd.t2 505.781
R176 vdd.t114 vdd.t2 505.781
R177 vdd.n50 vdd.t114 411.851
R178 vdd.n50 vdd.t115 411.851
R179 vdd.t115 vdd.t17 505.781
R180 vdd.t17 vdd.t26 505.781
R181 vdd.t116 vdd.t26 505.781
R182 vdd.n51 vdd.t116 411.851
R183 vdd.n51 vdd.t9 484.104
R184 vdd.t9 vdd.t5 650.289
R185 vdd.t89 vdd.t5 650.289
R186 vdd.n52 vdd.t89 484.104
R187 vdd.n52 vdd.t64 484.104
R188 vdd.t64 vdd.t61 526.013
R189 vdd.t61 vdd.t20 401.735
R190 vdd.t73 vdd.t20 401.735
R191 vdd.t75 vdd.t73 401.735
R192 vdd.n53 vdd.t75 359.827
R193 vdd.n53 vdd.t77 359.827
R194 vdd.t77 vdd.t50 1104.05
R195 vdd.n54 vdd.t50 1062.14
R196 vdd.n54 vdd.t60 375.724
R197 vdd.t60 vdd.t63 433.526
R198 vdd.t63 vdd.t3 433.526
R199 vdd.t31 vdd.t3 433.526
R200 vdd.t29 vdd.t31 433.526
R201 vdd.n55 vdd.t29 375.724
R202 vdd.n55 vdd.t99 375.724
R203 vdd.t99 vdd.t81 417.63
R204 vdd.n56 vdd.t81 382.916
R205 vdd.n47 vdd.n55 23.09
R206 vdd.n43 vdd.n54 23.09
R207 vdd.n40 vdd.n53 23.09
R208 vdd.n34 vdd.n52 23.09
R209 vdd.n30 vdd.n51 23.09
R210 vdd.n29 vdd.n50 23.09
R211 vdd.n49 vdd.t82 18.6345
R212 vdd.n48 vdd.t100 11.2274
R213 vdd.n46 vdd.t30 11.2274
R214 vdd.n45 vdd.t32 11.2274
R215 vdd.n44 vdd.t4 11.2274
R216 vdd.n42 vdd.t51 21.6308
R217 vdd.n41 vdd.t78 13.5844
R218 vdd.n39 vdd.t76 18.6345
R219 vdd.n38 vdd.t74 18.6345
R220 vdd.n37 vdd.t21 13.5844
R221 vdd.n36 vdd.t62 13.5844
R222 vdd.n35 vdd.t65 11.646
R223 vdd.n33 vdd.t90 11.646
R224 vdd.n32 vdd.t6 11.646
R225 vdd.n31 vdd.t10 11.646
R226 vdd.n1 vdd.n0 1.013
R227 vdd.n2 vdd.n1 1.013
R228 vdd.n3 vdd.n2 1.07375
R229 vdd.n4 vdd.n3 0.43475
R230 vdd.n5 vdd.n4 1.013
R231 vdd.n6 vdd.n5 1.013
R232 vdd.n7 vdd.n6 1.07375
R233 vdd.n8 vdd.n7 0.43475
R234 vdd.n9 vdd.n8 1.013
R235 vdd.n10 vdd.n9 1.013
R236 vdd.n11 vdd.n10 1.07375
R237 vdd.n12 vdd.n11 0.43475
R238 vdd.n13 vdd.n12 1.013
R239 vdd.n14 vdd.n13 1.013
R240 vdd.n15 vdd.n14 1.07375
R241 vdd.n16 vdd.n15 0.43475
R242 vdd.n17 vdd.n16 1.013
R243 vdd.n18 vdd.n17 1.013
R244 vdd.n19 vdd.n18 1.07375
R245 vdd.n20 vdd.n19 0.43475
R246 vdd.n21 vdd.n20 1.013
R247 vdd.n22 vdd.n21 1.013
R248 vdd.n28 vdd.n22 1.07375
R249 vdd.n83 vdd.n28 37.2583
R250 vdd.n0 vdd.t87 152.468
R251 vdd.t87 vdd.t22 167.162
R252 vdd.t18 vdd.t22 167.162
R253 vdd.n23 vdd.t18 124.444
R254 vdd.n23 vdd.t33 124.444
R255 vdd.t33 vdd.t56 167.162
R256 vdd.t24 vdd.t56 167.162
R257 vdd.n24 vdd.t24 124.444
R258 vdd.n24 vdd.t58 124.444
R259 vdd.t58 vdd.t48 167.162
R260 vdd.t93 vdd.t48 167.162
R261 vdd.n25 vdd.t93 124.444
R262 vdd.n25 vdd.t27 124.444
R263 vdd.t27 vdd.t111 167.162
R264 vdd.t91 vdd.t111 167.162
R265 vdd.n26 vdd.t91 124.444
R266 vdd.n26 vdd.t54 124.444
R267 vdd.t54 vdd.t37 167.162
R268 vdd.t66 vdd.t37 167.162
R269 vdd.n27 vdd.t66 124.444
R270 vdd.n27 vdd.t11 124.444
R271 vdd.t11 vdd.t35 167.162
R272 vdd.t46 vdd.t35 167.162
R273 vdd.n28 vdd.t46 152.032
R274 vdd.n19 vdd.n27 27.59
R275 vdd.n15 vdd.n26 27.59
R276 vdd.n11 vdd.n25 27.59
R277 vdd.n7 vdd.n24 27.59
R278 vdd.n3 vdd.n23 27.59
R279 vdd.n22 vdd.t47 16.146
R280 vdd.n21 vdd.t36 16.146
R281 vdd.n20 vdd.t12 16.146
R282 vdd.n18 vdd.t67 16.146
R283 vdd.n17 vdd.t38 16.146
R284 vdd.n16 vdd.t55 16.146
R285 vdd.n14 vdd.t92 16.146
R286 vdd.n13 vdd.t112 16.146
R287 vdd.n12 vdd.t28 16.146
R288 vdd.n10 vdd.t94 16.146
R289 vdd.n9 vdd.t49 16.146
R290 vdd.n8 vdd.t59 16.146
R291 vdd.n6 vdd.t25 16.146
R292 vdd.n5 vdd.t57 16.146
R293 vdd.n4 vdd.t34 12.6482
R294 vdd.n2 vdd.t19 12.6482
R295 vdd.n1 vdd.t23 12.6482
R296 vdd.n0 vdd.t88 12.6482
R297 vss.n107 vss.n106 4.5005
R298 vss vss.n107 17.8632
R299 vss.n107 vss.n0 16.25
R300 vss.n2 vss.n1 0.43025
R301 vss.n3 vss.n2 0.995
R302 vss.n4 vss.n3 0.995
R303 vss.n5 vss.n4 1.06025
R304 vss.n6 vss.n5 0.43025
R305 vss.n7 vss.n6 0.995
R306 vss.n105 vss.n7 0.14225
R307 vss.n8 vss.n105 0.85325
R308 vss.n9 vss.n8 1.06025
R309 vss.n10 vss.n9 0.43025
R310 vss.n11 vss.n10 0.995
R311 vss.n12 vss.n11 0.995
R312 vss.n13 vss.n12 1.06025
R313 vss.n14 vss.n13 0.43025
R314 vss.n15 vss.n14 1.7645
R315 vss.n25 vss.n15 0.69575
R316 vss.n16 vss.n25 0.07475
R317 vss.n17 vss.n16 0.83525
R318 vss.n18 vss.n17 0.43025
R319 vss.n19 vss.n18 0.995
R320 vss.n20 vss.n19 0.608
R321 vss.n21 vss.n20 0.608
R322 vss.n22 vss.n21 0.608
R323 vss.n23 vss.n22 0.72275
R324 vss.n24 vss.n23 0.43025
R325 vss.n106 vss.n24 3.15275
R326 vss.n105 vss.t139 13.992
R327 vss.n27 vss.n26 10.4005
R328 vss.n29 vss.n28 10.4005
R329 vss.n31 vss.n30 10.4005
R330 vss.n33 vss.n32 10.4005
R331 vss.n91 vss.n90 10.4005
R332 vss.n25 vss.n27 26.3862
R333 vss.n27 vss.n104 0.344
R334 vss.n104 vss.n103 0.3485
R335 vss.n103 vss.n102 0.2555
R336 vss.n102 vss.n29 0.254
R337 vss.n29 vss.n101 0.095
R338 vss.n101 vss.n100 0.2555
R339 vss.n100 vss.n99 0.3485
R340 vss.n99 vss.n98 0.2555
R341 vss.n98 vss.n31 0.248
R342 vss.n31 vss.n97 0.101
R343 vss.n97 vss.n96 0.2555
R344 vss.n96 vss.n95 0.3485
R345 vss.n95 vss.n94 0.3455
R346 vss.n94 vss.n33 0.152
R347 vss.n33 vss.n93 0.131
R348 vss.n93 vss.n92 0.9725
R349 vss.n92 vss.n91 0.098
R350 vss.n104 vss.t144 3.85787
R351 vss.n103 vss.t119 3.85787
R352 vss.n102 vss.t117 3.85787
R353 vss.n101 vss.t27 3.85787
R354 vss.n100 vss.t25 3.85787
R355 vss.n99 vss.t88 3.85787
R356 vss.n98 vss.t86 3.85787
R357 vss.n97 vss.t128 3.85787
R358 vss.n96 vss.t142 3.85787
R359 vss.n95 vss.t102 3.85787
R360 vss.n94 vss.t98 5.08945
R361 vss.n93 vss.t96 5.08945
R362 vss.n92 vss.t132 3.94787
R363 vss.n91 vss.t62 4.13237
R364 vss.n26 vss.n37 349.685
R365 vss.n26 vss.t37 582.12
R366 vss.t37 vss.t143 22.6271
R367 vss.t143 vss.t36 141.93
R368 vss.t36 vss.t118 67.8803
R369 vss.t118 vss.t68 594.462
R370 vss.t116 vss.t68 22.6271
R371 vss.t67 vss.t116 141.93
R372 vss.t26 vss.t67 67.8803
R373 vss.n28 vss.t26 4.11442
R374 vss.n28 vss.t39 590.348
R375 vss.t39 vss.t24 22.6271
R376 vss.t24 vss.t38 141.93
R377 vss.t38 vss.t87 67.8803
R378 vss.t87 vss.t64 594.462
R379 vss.t85 vss.t64 22.6271
R380 vss.t63 vss.t85 141.93
R381 vss.n30 vss.t63 63.7663
R382 vss.n30 vss.t127 4.11442
R383 vss.t127 vss.t111 594.462
R384 vss.t111 vss.t141 22.6271
R385 vss.t141 vss.t103 141.93
R386 vss.t103 vss.t101 67.8803
R387 vss.t97 vss.t101 717.88
R388 vss.n32 vss.t97 96.6777
R389 vss.n32 vss.t95 67.8803
R390 vss.t95 vss.t11 695.254
R391 vss.t11 vss.t10 164.558
R392 vss.t131 vss.t10 695.254
R393 vss.n90 vss.t131 22.6271
R394 vss.n90 vss.t61 141.93
R395 vss.n37 vss.t107 410.82
R396 vss.n34 vss.t107 489.154
R397 vss.n34 vss.t74 576.192
R398 vss.t74 vss.t18 619.712
R399 vss.t18 vss.t46 470.005
R400 vss.t2 vss.t46 470.005
R401 vss.t6 vss.t2 489.154
R402 vss.n35 vss.t6 445.635
R403 vss.n35 vss.t112 426.486
R404 vss.t112 vss.t137 532.673
R405 vss.t137 vss.t138 595.341
R406 vss.t93 vss.t138 532.673
R407 vss.t94 vss.t93 470.005
R408 vss.n36 vss.t94 426.486
R409 vss.n36 vss.n89 760.712
R410 vss.n89 vss.t61 7952.74
R411 vss.n50 vss.n42 21.9812
R412 vss.n54 vss.n43 21.9812
R413 vss.n55 vss.n44 21.9812
R414 vss.n61 vss.n45 21.9812
R415 vss.n67 vss.t126 3.46717
R416 vss.n68 vss.t73 3.46717
R417 vss.n69 vss.t99 3.46717
R418 vss.n70 vss.t22 3.46717
R419 vss.n71 vss.t84 10.4005
R420 vss.n72 vss.t40 10.4005
R421 vss.n73 vss.t28 10.4005
R422 vss.n74 vss.t53 10.4005
R423 vss.n75 vss.t9 10.4005
R424 vss.n76 vss.t145 10.4005
R425 vss.n77 vss.t129 10.4005
R426 vss.n78 vss.t42 10.4005
R427 vss.n79 vss.t43 10.4005
R428 vss.n80 vss.t44 10.4005
R429 vss.n81 vss.t105 10.4005
R430 vss.n82 vss.t104 10.4005
R431 vss.n83 vss.t8 10.4005
R432 vss.n84 vss.t54 10.4005
R433 vss.n85 vss.t45 10.4005
R434 vss.n86 vss.t41 10.4005
R435 vss.n87 vss.t23 8.68176
R436 vss.n47 vss.t126 112.921
R437 vss.t126 vss.t12 29.3254
R438 vss.t12 vss.t73 115.49
R439 vss.t73 vss.t71 44.531
R440 vss.t71 vss.t99 100.284
R441 vss.t99 vss.t55 59.7365
R442 vss.t55 vss.t22 85.079
R443 vss.t22 vss.n42 34.756
R444 vss.n42 vss.t14 119.835
R445 vss.t84 vss.t14 80.7346
R446 vss.t84 vss.t76 79.2864
R447 vss.t40 vss.t76 29.3254
R448 vss.t40 vss.t89 130.696
R449 vss.t28 vss.t89 86.5272
R450 vss.t28 vss.t31 46.3411
R451 vss.t31 vss.t53 62.2707
R452 vss.t53 vss.n43 30.4116
R453 vss.n43 vss.t9 78.2003
R454 vss.t9 vss.t50 14.482
R455 vss.t50 vss.t145 94.1299
R456 vss.t145 vss.t109 7.60326
R457 vss.t109 vss.t78 97.7503
R458 vss.t129 vss.t78 3.25883
R459 vss.t129 vss.t110 94.492
R460 vss.t42 vss.t110 14.1199
R461 vss.t42 vss.t79 83.6309
R462 vss.n44 vss.t79 88.6994
R463 vss.n44 vss.t43 44.893
R464 vss.t43 vss.t82 43.8069
R465 vss.t82 vss.t44 64.805
R466 vss.t44 vss.t32 32.9458
R467 vss.t32 vss.t105 75.6661
R468 vss.t105 vss.t4 22.0847
R469 vss.t4 vss.t104 86.5272
R470 vss.t104 vss.t91 11.2236
R471 vss.t91 vss.t8 97.3883
R472 vss.t8 vss.t122 31.4977
R473 vss.t122 vss.t54 77.1142
R474 vss.t54 vss.n45 42.7208
R475 vss.n45 vss.t45 65.8911
R476 vss.t45 vss.t59 53.9439
R477 vss.t59 vss.t41 54.668
R478 vss.t41 vss.t57 105.353
R479 vss.t23 vss.t57 3.25883
R480 vss.n87 vss.t20 9.27483
R481 vss.t20 vss.t69 48.1513
R482 vss.t69 vss.n46 119.835
R483 vss.n46 vss.n89 2677.22
R484 vss.n67 vss.n68 0.947868
R485 vss.n68 vss.n69 0.947868
R486 vss.n69 vss.n70 0.947868
R487 vss.n70 vss.n71 1.53997
R488 vss.n71 vss.n72 0.711026
R489 vss.n72 vss.n73 1.42155
R490 vss.n73 vss.n74 0.711026
R491 vss.n74 vss.n75 0.711026
R492 vss.n75 vss.n76 0.711026
R493 vss.n76 vss.n77 0.711026
R494 vss.n77 vss.n78 0.711026
R495 vss.n78 vss.n79 1.42155
R496 vss.n79 vss.n80 0.711026
R497 vss.n80 vss.n81 0.711026
R498 vss.n81 vss.n82 0.711026
R499 vss.n82 vss.n83 0.711026
R500 vss.n83 vss.n84 0.711026
R501 vss.n84 vss.n85 0.711026
R502 vss.n85 vss.n86 0.711026
R503 vss.n86 vss.n87 1.59954
R504 vss.n88 vss.n67 36.2627
R505 vss.n0 vss.n88 12.308
R506 vss.n88 vss.t21 19.9788
R507 vss.n66 vss.n46 21.9812
R508 vss.n48 vss.n47 0.995
R509 vss.n49 vss.n48 0.995
R510 vss.n50 vss.n49 1.06025
R511 vss.n51 vss.n50 0.43025
R512 vss.n52 vss.n51 0.995
R513 vss.n53 vss.n52 0.995
R514 vss.n54 vss.n53 1.71725
R515 vss.n55 vss.n54 3.5825
R516 vss.n56 vss.n55 0.43025
R517 vss.n57 vss.n56 0.608
R518 vss.n58 vss.n57 0.608
R519 vss.n59 vss.n58 0.608
R520 vss.n60 vss.n59 0.608
R521 vss.n61 vss.n60 1.06025
R522 vss.n62 vss.n61 0.43025
R523 vss.n63 vss.n62 0.995
R524 vss.n64 vss.n63 0.995
R525 vss.n66 vss.n64 1.06025
R526 vss.n65 vss.n66 5.324
R527 vss.n0 vss.n65 10.1863
R528 vss.n65 vss.t29 13.9313
R529 vss.n64 vss.t70 11.1876
R530 vss.n63 vss.t58 11.1876
R531 vss.n62 vss.t60 11.1876
R532 vss.n60 vss.t123 11.1876
R533 vss.n59 vss.t92 20.4058
R534 vss.n58 vss.t5 20.4058
R535 vss.n57 vss.t33 20.4058
R536 vss.n56 vss.t83 20.4058
R537 vss.n53 vss.t90 11.1876
R538 vss.n52 vss.t77 11.1876
R539 vss.n51 vss.t15 11.1876
R540 vss.n49 vss.t56 11.1876
R541 vss.n48 vss.t72 11.1876
R542 vss.n47 vss.t13 11.1876
R543 vss.n1 vss.t135 209.335
R544 vss.t135 vss.t106 225.047
R545 vss.t106 vss.t100 225.047
R546 vss.t136 vss.t100 225.047
R547 vss.n38 vss.t136 184.906
R548 vss.n38 vss.t16 217.808
R549 vss.t16 vss.t65 290.849
R550 vss.t34 vss.t65 290.849
R551 vss.n39 vss.t34 217.808
R552 vss.n39 vss.t48 217.808
R553 vss.t48 vss.t124 290.849
R554 vss.t120 vss.t124 290.849
R555 vss.n40 vss.t120 217.808
R556 vss.n40 vss.t0 217.808
R557 vss.t0 vss.t51 290.849
R558 vss.t114 vss.t51 290.849
R559 vss.n41 vss.t114 217.808
R560 vss.n41 vss.t133 217.808
R561 vss.t133 vss.t130 257.947
R562 vss.t130 vss.t80 225.047
R563 vss.n37 vss.t80 69.7515
R564 vss.n13 vss.n41 20.8562
R565 vss.n9 vss.n40 20.8562
R566 vss.n5 vss.n39 20.8562
R567 vss.n1 vss.n38 20.8562
R568 vss.n106 vss.n36 21.1308
R569 vss.n23 vss.n35 20.8562
R570 vss.n17 vss.n34 20.8562
R571 vss.n24 vss.t113 19.2808
R572 vss.n22 vss.t7 11.6644
R573 vss.n21 vss.t3 19.2808
R574 vss.n20 vss.t47 19.2808
R575 vss.n19 vss.t19 19.2808
R576 vss.n18 vss.t75 21.857
R577 vss.n16 vss.t108 11.2319
R578 vss.n15 vss.t81 11.2319
R579 vss.n14 vss.t134 13.7073
R580 vss.n12 vss.t115 13.7073
R581 vss.n11 vss.t52 13.7073
R582 vss.n10 vss.t1 13.7073
R583 vss.n8 vss.t121 13.7073
R584 vss.n7 vss.t125 13.7073
R585 vss.n6 vss.t49 13.7073
R586 vss.n4 vss.t35 13.7073
R587 vss.n3 vss.t66 13.7073
R588 vss.n2 vss.t17 13.7073
R589 a_19968_0.t2 a_19968_0.n0 0.8195
R590 a_19968_0.n0 a_19968_0.t3 0.8195
R591 a_19968_0.n0 a_19968_0.n1 7.64805
R592 a_19968_0.n1 a_19968_0.t1 8.17905
R593 a_19968_0.n1 a_19968_0.t0 8.60205
R594 a_18866_0.n0 a_18866_0.t3 0.8195
R595 a_18866_0.t0 a_18866_0.n0 0.8195
R596 a_18866_0.n0 a_18866_0.n1 7.36905
R597 a_18866_0.n1 a_18866_0.t2 9.85078
R598 a_18866_0.n1 a_18866_0.t1 9.75178
R599 a_18062_0.t0 a_18062_0.n1 9.75178
R600 a_18062_0.n1 a_18062_0.n0 7.36905
R601 a_18062_0.n0 a_18062_0.t2 0.8195
R602 a_18062_0.n0 a_18062_0.t3 0.8195
R603 a_18062_0.n1 a_18062_0.t1 9.85078
R604 a_17258_0.t0 a_17258_0.n0 0.8195
R605 a_17258_0.n0 a_17258_0.t3 0.8195
R606 a_17258_0.n0 a_17258_0.n1 7.36905
R607 a_17258_0.n1 a_17258_0.t2 9.85078
R608 a_17258_0.n1 a_17258_0.t1 9.75178
R609 a_16454_0.n0 a_16454_0.t3 0.8195
R610 a_16454_0.t0 a_16454_0.n0 0.8195
R611 a_16454_0.n0 a_16454_0.n1 7.36905
R612 a_16454_0.n1 a_16454_0.t2 9.85078
R613 a_16454_0.n1 a_16454_0.t1 9.75178
R614 a_15650_0.t0 a_15650_0.n1 9.75178
R615 a_15650_0.n1 a_15650_0.n0 7.36905
R616 a_15650_0.n0 a_15650_0.t3 0.8195
R617 a_15650_0.n0 a_15650_0.t2 0.8195
R618 a_15650_0.n1 a_15650_0.t1 9.85078
R619 nb.n0 nb.t3 0.9105
R620 nb.n0 nb.t4 0.9105
R621 nb.n4 nb.n0 12.9109
R622 nb.n4 nb.n3 4.5005
R623 nb nb.n4 0.9275
R624 nb.n8 nb.n7 4.5005
R625 nb nb.n8 0.9095
R626 nb.n8 nb.n9 10.8733
R627 nb.n9 nb.t8 58.5791
R628 nb.n9 nb.t9 58.7685
R629 nb.n7 nb.n6 5.67555
R630 nb.n6 nb.t6 58.5791
R631 nb.n6 nb.t7 58.7685
R632 nb.n7 nb.n5 5.13729
R633 nb.n5 nb.t10 58.5791
R634 nb.n5 nb.t11 58.7685
R635 nb.n3 nb.n2 8.09955
R636 nb.n2 nb.t1 0.8195
R637 nb.n2 nb.t0 0.8195
R638 nb.n3 nb.n1 7.19289
R639 nb.n1 nb.t2 0.9105
R640 nb.n1 nb.t5 0.9105
R641 r4.n0 r4.t1 0.607167
R642 r4.n0 r4.t0 0.607167
R643 r4.n1 r4.n0 6.31734
R644 r4.n1 r4.n5 9.24066
R645 r4.n5 r4.t3 1.0925
R646 r4.n5 r4.t2 1.0925
R647 r4 r4.n1 6.0035
R648 r4 r4.n4 5.9915
R649 r4.n4 r4.n3 6.12555
R650 r4.n3 r4.t4 39.0255
R651 r4.n3 r4.t5 39.215
R652 r4.n4 r4.n2 5.13729
R653 r4.n2 r4.t6 58.5791
R654 r4.n2 r4.t7 58.7685
R655 r5.n0 r5.t1 0.607167
R656 r5.n0 r5.t0 0.607167
R657 r5.n1 r5.n0 6.61734
R658 r5.n8 r5.n1 4.5005
R659 r5.n1 r5.n9 8.94066
R660 r5.n9 r5.t2 1.0925
R661 r5.n9 r5.t3 1.0925
R662 r5 r5.n8 1.3205
R663 r5 r5.n7 6.4025
R664 r5.n7 r5.n6 5.67555
R665 r5.n6 r5.t4 45.5434
R666 r5.n6 r5.t5 45.7328
R667 r5.n7 r5.n5 5.73729
R668 r5.n5 r5.t8 45.5434
R669 r5.n5 r5.t9 45.7328
R670 r5.n8 r5.n4 5.0645
R671 r5.n4 r5.n3 5.82555
R672 r5.n3 r5.t6 39.0255
R673 r5.n3 r5.t7 39.215
R674 r5.n4 r5.n2 5.43729
R675 r5.n2 r5.t11 58.7685
R676 r5.n2 r5.t10 58.5791
R677 r3.n0 r3.t3 0.607167
R678 r3.n0 r3.t2 0.607167
R679 r3.n1 r3.n0 6.61734
R680 r3.n1 r3.n5 8.94066
R681 r3.n5 r3.t1 1.0925
R682 r3.n5 r3.t0 1.0925
R683 r3 r3.n1 6.0035
R684 r3 r3.n4 5.9915
R685 r3.n4 r3.n3 5.82555
R686 r3.n3 r3.t4 39.0255
R687 r3.n3 r3.t5 39.215
R688 r3.n4 r3.n2 5.43729
R689 r3.n2 r3.t6 58.5791
R690 r3.n2 r3.t7 58.7685
R691 r1.n0 r1.t3 0.607167
R692 r1.n0 r1.t2 0.607167
R693 r1.n1 r1.n0 6.91734
R694 r1.n1 r1.n5 8.64066
R695 r1.n5 r1.t0 1.0925
R696 r1.n5 r1.t1 1.0925
R697 r1 r1.n1 5.3825
R698 r1 r1.n4 5.3885
R699 r1.n4 r1.n3 5.52555
R700 r1.n3 r1.t4 39.0255
R701 r1.n3 r1.t5 39.215
R702 r1.n4 r1.n2 5.73729
R703 r1.n2 r1.t7 58.7685
R704 r1.n2 r1.t6 58.5791
R705 r2.t0 r2.n0 0.607167
R706 r2.n0 r2.t1 0.607167
R707 r2.n1 r2.n0 6.91734
R708 r2.n1 r2.n5 8.64066
R709 r2.n5 r2.t2 1.0925
R710 r2.n5 r2.t3 1.0925
R711 r2 r2.n1 4.7795
R712 r2 r2.n4 4.7855
R713 r2.n4 r2.n3 5.52555
R714 r2.n3 r2.t4 39.0255
R715 r2.n3 r2.t5 39.215
R716 r2.n4 r2.n2 5.73729
R717 r2.n2 r2.t7 58.7685
R718 r2.n2 r2.t6 58.5791
R719 a_18862_1524.t1 a_18862_1524.n1 7.12409
R720 a_18862_1524.n1 a_18862_1524.t0 7.22309
R721 a_18862_1524.n1 a_18862_1524.n0 6.20245
R722 a_18862_1524.n0 a_18862_1524.t3 0.3645
R723 a_18862_1524.n0 a_18862_1524.t2 0.3645
R724 a_18058_1524.t1 a_18058_1524.n1 7.12409
R725 a_18058_1524.n1 a_18058_1524.t0 7.22309
R726 a_18058_1524.n1 a_18058_1524.n0 6.20245
R727 a_18058_1524.n0 a_18058_1524.t3 0.3645
R728 a_18058_1524.n0 a_18058_1524.t2 0.3645
R729 a_17254_1524.t2 a_17254_1524.n1 7.22309
R730 a_17254_1524.n1 a_17254_1524.t3 7.12409
R731 a_17254_1524.n1 a_17254_1524.n0 6.20245
R732 a_17254_1524.n0 a_17254_1524.t1 0.3645
R733 a_17254_1524.n0 a_17254_1524.t0 0.3645
R734 a_16450_1524.t1 a_16450_1524.n1 7.12409
R735 a_16450_1524.n1 a_16450_1524.t0 7.22309
R736 a_16450_1524.n1 a_16450_1524.n0 6.20245
R737 a_16450_1524.n0 a_16450_1524.t3 0.3645
R738 a_16450_1524.n0 a_16450_1524.t2 0.3645
R739 a_15646_1524.t1 a_15646_1524.n1 7.12409
R740 a_15646_1524.n1 a_15646_1524.t0 7.22309
R741 a_15646_1524.n1 a_15646_1524.n0 6.20245
R742 a_15646_1524.n0 a_15646_1524.t3 0.3645
R743 a_15646_1524.n0 a_15646_1524.t2 0.3645
R744 vi.n2 vi.t0 12.1319
R745 vi vi.n0 6.18575
R746 vi.n0 vi.n1 0.77
R747 vi.n1 vi.n2 0.365
R748 vi.n2 vi.t1 12.7394
R749 vi.n1 vi.t4 12.1319
R750 vi.n0 vi.t3 12.1319
R751 vi vi.t2 22.5341
R752 vnt.n5 vnt.t1 11.4119
R753 vnt.n5 vnt.n0 0.77
R754 vnt.n1 vnt.n5 0.77
R755 vnt vnt.n1 5.01125
R756 vnt vnt.n2 2.35175
R757 vnt.n2 vnt.n3 1.49
R758 vnt.n3 vnt.n4 1.9895
R759 vnt.n4 vnt.t5 15.3768
R760 vnt.n4 vnt.t3 13.8873
R761 vnt.n3 vnt.t0 13.8873
R762 vnt.n2 vnt.t4 13.8873
R763 vnt.n1 vnt.t7 11.4119
R764 vnt.n0 vnt.t2 11.4119
R765 vnt.n0 vnt.t6 12.1814
R766 vbn_vco.t2 vbn_vco.n0 13.8307
R767 vbn_vco.n12 vbn_vco.n0 14.0675
R768 vbn_vco vbn_vco.n11 19.6711
R769 vbn_vco vbn_vco.n2 0.953375
R770 vbn_vco.n2 vbn_vco.n12 0.77225
R771 vbn_vco.n11 vbn_vco.n5 1.1405
R772 vbn_vco.n5 vbn_vco.n7 1.1765
R773 vbn_vco.n7 vbn_vco.n9 1.1765
R774 vbn_vco.n9 vbn_vco.n10 10.8946
R775 vbn_vco.n10 vbn_vco.t5 29.6085
R776 vbn_vco.n10 vbn_vco.t6 29.8501
R777 vbn_vco.n9 vbn_vco.n8 9.71861
R778 vbn_vco.n8 vbn_vco.t7 29.6085
R779 vbn_vco.n8 vbn_vco.t8 29.8501
R780 vbn_vco.n7 vbn_vco.n6 9.71861
R781 vbn_vco.n6 vbn_vco.t9 29.6085
R782 vbn_vco.n6 vbn_vco.t10 29.8501
R783 vbn_vco.n5 vbn_vco.n4 9.71861
R784 vbn_vco.n4 vbn_vco.t11 29.6085
R785 vbn_vco.n4 vbn_vco.t12 29.8501
R786 vbn_vco.n11 vbn_vco.n3 9.74561
R787 vbn_vco.n3 vbn_vco.t13 29.6085
R788 vbn_vco.n3 vbn_vco.t14 29.8501
R789 vbn_vco.n12 vbn_vco.t4 21.0515
R790 vbn_vco.n2 vbn_vco.n1 11.2168
R791 vbn_vco.n1 vbn_vco.t1 1.88813
R792 vbn_vco.n1 vbn_vco.t0 44.5424
R793 vbn_vco.n0 vbn_vco.t3 14.3392
R794 vst.t2 vst.n0 13.2614
R795 vst vst.n0 0.66425
R796 vst vst.n2 0.1175
R797 vst.n2 vst.n1 0.878
R798 vst.n2 vst.t1 37.851
R799 vst.n1 vst.t0 20.9795
R800 vst.n1 vst.t4 17.4463
R801 vst.n0 vst.t3 12.4919
R802 vbh.t5 vbh.n5 11.5919
R803 vbh vbh.n5 2.03338
R804 vbh vbh.n4 17.8689
R805 vbh.n4 vbh.n1 0.0275
R806 vbh.n1 vbh.n2 1.013
R807 vbh.n2 vbh.n3 12.0492
R808 vbh.n3 vbh.t3 1.83599
R809 vbh.n3 vbh.t2 12.2744
R810 vbh.n2 vbh.t6 22.759
R811 vbh.n1 vbh.t7 22.759
R812 vbh.n4 vbh.n0 11.8648
R813 vbh.n0 vbh.t1 1.83599
R814 vbh.n0 vbh.t0 12.2744
R815 vbh.n5 vbh.t4 13.9004
R816 vbl.t4 vbl.n7 11.5874
R817 vbl.n7 vbl.n0 1.283
R818 vbl.n1 vbl.n7 2.363
R819 vbl.n6 vbl.n1 15.0755
R820 vbl vbl.n3 0.919625
R821 vbl vbl.n4 0.075875
R822 vbl.n4 vbl.n6 1.32125
R823 vbl.n6 vbl.n5 11.1312
R824 vbl.n5 vbl.t3 3.47655
R825 vbl.n5 vbl.t2 8.58548
R826 vbl.n4 vbl.t8 19.4863
R827 vbl.n3 vbl.t9 19.4863
R828 vbl.n3 vbl.n2 12.2945
R829 vbl.n2 vbl.t1 3.47655
R830 vbl.n2 vbl.t0 8.58548
R831 vbl.n1 vbl.t5 11.5874
R832 vbl.n0 vbl.t7 11.5874
R833 vbl.n0 vbl.t6 13.9499
R834 vbp_vco.t6 vbp_vco.n0 13.4594
R835 vbp_vco vbp_vco.n16 18.0286
R836 vbp_vco vbp_vco.n1 1.51812
R837 vbp_vco.n1 vbp_vco.n0 1.21775
R838 vbp_vco.n16 vbp_vco.n10 0.9125
R839 vbp_vco.n10 vbp_vco.n12 1.1765
R840 vbp_vco.n12 vbp_vco.n14 1.1765
R841 vbp_vco.n14 vbp_vco.n15 10.8963
R842 vbp_vco.n15 vbp_vco.t7 51.6545
R843 vbp_vco.n15 vbp_vco.t8 51.8961
R844 vbp_vco.n14 vbp_vco.n13 9.72034
R845 vbp_vco.n13 vbp_vco.t9 51.6545
R846 vbp_vco.n13 vbp_vco.t10 51.8961
R847 vbp_vco.n12 vbp_vco.n11 9.72034
R848 vbp_vco.n11 vbp_vco.t11 51.6545
R849 vbp_vco.n11 vbp_vco.t12 51.8961
R850 vbp_vco.n10 vbp_vco.n9 9.72034
R851 vbp_vco.n9 vbp_vco.t13 51.6545
R852 vbp_vco.n9 vbp_vco.t14 51.8961
R853 vbp_vco.n16 vbp_vco.n8 9.95434
R854 vbp_vco.n8 vbp_vco.t15 51.6545
R855 vbp_vco.n8 vbp_vco.t16 51.8961
R856 vbp_vco.n1 vbp_vco.n7 13.7075
R857 vbp_vco.n4 vbp_vco.n3 0.6755
R858 vbp_vco.n6 vbp_vco.n4 1.00175
R859 vbp_vco.n7 vbp_vco.n6 0.00725
R860 vbp_vco.n7 vbp_vco.t4 21.5933
R861 vbp_vco.n6 vbp_vco.n5 11.9233
R862 vbp_vco.n5 vbp_vco.t3 1.6447
R863 vbp_vco.n5 vbp_vco.t2 51.9932
R864 vbp_vco.n4 vbp_vco.t17 63.6952
R865 vbp_vco.n3 vbp_vco.t18 63.6952
R866 vbp_vco.n3 vbp_vco.n2 12.767
R867 vbp_vco.n2 vbp_vco.t1 1.6447
R868 vbp_vco.n2 vbp_vco.t0 51.9932
R869 vbp_vco.n0 vbp_vco.t5 12.8519
R870 vs.n0 vs.t1 13.2614
R871 vs vs.n0 1.76337
R872 vs vs.t0 75.0306
R873 vs.n0 vs.t2 12.4919
R874 vcl.t1 vcl.n2 14.0676
R875 vcl.n2 vcl.n0 0.995
R876 vcl.n1 vcl.n2 0.995
R877 vcl vcl.n1 35.5482
R878 vcl vcl.t0 35.965
R879 vcl.n1 vcl.t3 14.0676
R880 vcl.n0 vcl.t2 14.0676
R881 vcl.n0 vcl.t4 15.5571
R882 up_b.t1 up_b 20.9925
R883 up_b up_b.n0 0.100625
R884 up_b.n0 up_b.t0 71.5708
R885 up_b.n0 up_b.t2 54.6402
R886 en_b.t1 en_b.n0 18.5456
R887 en_b.n5 en_b.n0 10.4585
R888 en_b.n3 en_b.n2 0.608
R889 en_b en_b.n3 1.193
R890 en_b en_b.n4 0.5675
R891 en_b.n4 en_b.n5 10.508
R892 en_b.n4 en_b.t2 44.8461
R893 en_b.n3 en_b.t3 44.8461
R894 en_b.n2 en_b.t4 44.8461
R895 en_b.n2 en_b.t5 45.4536
R896 en_b.n5 en_b.n1 32.315
R897 en_b.n1 en_b.t0 22.9257
R898 en_b.n1 en_b.t7 47.1298
R899 en_b.n0 en_b.t6 14.7589
R900 t1c t1c.t0 17.1746
R901 t1c t1c.t1 17.1746
R902 vdump.t11 vdump.n0 1.68292
R903 vdump.n0 vdump.t10 30.1453
R904 vdump.n15 vdump.n0 10.2695
R905 vdump.n2 vdump.n15 3.254
R906 vdump.n3 vdump.n2 0.995
R907 vdump vdump.n3 6.67962
R908 vdump vdump.n14 20.1841
R909 vdump.n8 vdump.n6 2.858
R910 vdump.n10 vdump.n8 0.788
R911 vdump.n11 vdump.n10 3.308
R912 vdump.n12 vdump.n11 1.013
R913 vdump.n13 vdump.n12 9.788
R914 vdump.n14 vdump.n13 9.32225
R915 vdump.n13 vdump.t17 12.366
R916 vdump.n12 vdump.t13 12.366
R917 vdump.n11 vdump.t12 12.366
R918 vdump.n10 vdump.n9 10.3032
R919 vdump.n9 vdump.t7 1.6447
R920 vdump.n9 vdump.t6 30.2254
R921 vdump.n8 vdump.n7 10.3032
R922 vdump.n7 vdump.t1 1.6447
R923 vdump.n7 vdump.t0 30.2254
R924 vdump.n6 vdump.n5 10.3032
R925 vdump.n5 vdump.t3 1.6447
R926 vdump.n5 vdump.t2 30.2254
R927 vdump.n6 vdump.n4 11.0908
R928 vdump.n4 vdump.t5 1.6447
R929 vdump.n4 vdump.t4 30.2254
R930 vdump.n14 vdump.t14 52.8618
R931 vdump.n3 vdump.t16 14.4273
R932 vdump.n2 vdump.t15 14.4273
R933 vdump.n15 vdump.n1 11.039
R934 vdump.n1 vdump.t9 1.68292
R935 vdump.n1 vdump.t8 30.1453
R936 dn_b.t1 dn_b 20.8598
R937 dn_b dn_b.n0 44.7654
R938 dn_b.n0 dn_b.t0 21.4858
R939 dn_b.n0 dn_b.t2 46.1242
R940 dn_s.t0 dn_s.n1 11.7276
R941 dn_s dn_s.n1 1.0085
R942 dn_s dn_s.n0 1.346
R943 dn_s.n0 dn_s.t3 16.5243
R944 dn_s.n0 dn_s.t1 15.3723
R945 dn_s.n1 dn_s.t2 13.2171
R946 vref.n12 vref.t2 12.7444
R947 vref.n1 vref.n0 1.49
R948 vref.n2 vref.n1 0.995
R949 vref.n3 vref.n2 0.995
R950 vref.n4 vref.n3 1.49
R951 vref.n12 vref.n4 0.19625
R952 vref.n5 vref.n12 1.34375
R953 vref vref.n5 0.4505
R954 vref vref.n6 0.32
R955 vref.n6 vref.n7 3.14375
R956 vref.n7 vref.n11 25.0588
R957 vref.n11 vref.t0 45.2912
R958 vref.n9 vref.n8 0.995
R959 vref.n10 vref.n9 0.995
R960 vref.n11 vref.n10 17.7507
R961 vref.n10 vref.t11 35.5713
R962 vref.n9 vref.t12 35.5713
R963 vref.n8 vref.t13 35.5713
R964 vref.n8 vref.t14 37.0608
R965 vref.n7 vref.t1 20.3608
R966 vref.n6 vref.t3 40.5582
R967 vref.n5 vref.t4 40.5582
R968 vref.n4 vref.t5 19.6663
R969 vref.n3 vref.t6 19.6663
R970 vref.n2 vref.t7 19.6663
R971 vref.n1 vref.t8 19.6663
R972 vref.n0 vref.t9 19.6663
R973 vref.n0 vref.t10 20.6608
R974 t1b t1b.t1 24.9832
R975 t1b t1b.t0 55.3781
R976 va.t1 va.n1 78.0862
R977 va va.n0 3.77487
R978 va va.n1 0.300875
R979 va.n1 va.t2 19.6407
R980 va.n0 va.t3 36.4132
R981 va.n0 va.t0 17.4896
R982 t1a t1a.t1 24.7807
R983 t1a t1a.t0 59.2481
R984 t2 t2.t1 25.0169
R985 t2 t2.n0 36.9939
R986 t2.n0 t2.t0 17.226
R987 t2.n0 t2.t2 23.2785
R988 vcp_n.t11 vcp_n.n0 1.64987
R989 vcp_n.n0 vcp_n.t10 23.1665
R990 vcp_n.n13 vcp_n.n0 9.71825
R991 vcp_n.n3 vcp_n.n2 0.995
R992 vcp_n.n4 vcp_n.n3 1.49
R993 vcp_n.n5 vcp_n.n4 0.995
R994 vcp_n.n13 vcp_n.n5 0.82625
R995 vcp_n.n6 vcp_n.n13 2.417
R996 vcp_n.n7 vcp_n.n6 0.608
R997 vcp_n.n8 vcp_n.n7 1.2155
R998 vcp_n.n9 vcp_n.n8 2.318
R999 vcp_n vcp_n.n9 1.20537
R1000 vcp_n vcp_n.n12 40.4656
R1001 vcp_n.n11 vcp_n.n10 8.078
R1002 vcp_n.n12 vcp_n.n11 2.5205
R1003 vcp_n.n12 vcp_n.t1 17.046
R1004 vcp_n.n11 vcp_n.t5 17.046
R1005 vcp_n.n10 vcp_n.t2 17.046
R1006 vcp_n.n10 vcp_n.t0 19.566
R1007 vcp_n.n9 vcp_n.t7 20.5858
R1008 vcp_n.n8 vcp_n.t3 15.0123
R1009 vcp_n.n7 vcp_n.t4 15.0123
R1010 vcp_n.n6 vcp_n.t6 15.0123
R1011 vcp_n.n5 vcp_n.t12 32.6913
R1012 vcp_n.n4 vcp_n.t13 32.6913
R1013 vcp_n.n3 vcp_n.t14 32.6913
R1014 vcp_n.n2 vcp_n.t15 32.6913
R1015 vcp_n.n2 vcp_n.n1 10.8815
R1016 vcp_n.n1 vcp_n.t9 1.64987
R1017 vcp_n.n1 vcp_n.t8 23.1665
R1018 vbt.n9 vbt.t3 11.4074
R1019 vbt.n1 vbt.n0 0.788
R1020 vbt.n2 vbt.n1 0.788
R1021 vbt.n3 vbt.n2 1.283
R1022 vbt.n4 vbt.n3 0.788
R1023 vbt.n9 vbt.n4 0.788
R1024 vbt.n5 vbt.n9 0.788
R1025 vbt vbt.n5 7.35463
R1026 vbt vbt.n8 55.3741
R1027 vbt.n7 vbt.n6 10.598
R1028 vbt.n8 vbt.n7 2.0255
R1029 vbt.n8 vbt.t5 16.686
R1030 vbt.n7 vbt.t4 16.686
R1031 vbt.n6 vbt.t7 16.686
R1032 vbt.n6 vbt.t6 19.206
R1033 vbt.n5 vbt.t11 11.4074
R1034 vbt.n4 vbt.t2 11.4074
R1035 vbt.n3 vbt.t10 11.4074
R1036 vbt.n2 vbt.t9 11.4074
R1037 vbt.n1 vbt.t1 11.4074
R1038 vbt.n0 vbt.t0 11.4074
R1039 vbt.n0 vbt.t8 12.1949
R1040 vbp.t4 vbp.n0 14.8729
R1041 vbp vbp.n0 1.37187
R1042 vbp vbp.n15 14.5074
R1043 vbp.n15 vbp.t1 35.1743
R1044 vbp.n2 vbp.n1 1.508
R1045 vbp.n3 vbp.n2 1.013
R1046 vbp.n4 vbp.n3 1.013
R1047 vbp.n5 vbp.n4 1.508
R1048 vbp.n7 vbp.n5 0.84425
R1049 vbp.n8 vbp.n7 1.18175
R1050 vbp.n9 vbp.n8 1.508
R1051 vbp.n10 vbp.n9 1.013
R1052 vbp.n11 vbp.n10 1.013
R1053 vbp.n12 vbp.n11 1.508
R1054 vbp.n13 vbp.n12 1.013
R1055 vbp.n14 vbp.n13 1.013
R1056 vbp.n15 vbp.n14 33.3838
R1057 vbp.n14 vbp.t5 27.079
R1058 vbp.n13 vbp.t6 27.079
R1059 vbp.n12 vbp.t7 27.079
R1060 vbp.n11 vbp.t8 27.079
R1061 vbp.n10 vbp.t9 27.079
R1062 vbp.n9 vbp.t10 27.079
R1063 vbp.n8 vbp.t11 27.079
R1064 vbp.n7 vbp.n6 15.0305
R1065 vbp.n6 vbp.t3 1.83599
R1066 vbp.n6 vbp.t2 12.2744
R1067 vbp.n5 vbp.t12 27.079
R1068 vbp.n4 vbp.t13 27.079
R1069 vbp.n3 vbp.t14 27.079
R1070 vbp.n2 vbp.t15 27.079
R1071 vbp.n1 vbp.t16 27.079
R1072 vbp.n1 vbp.t17 28.0915
R1073 vbp.n0 vbp.t0 22.037
R1074 up_s.t0 up_s.n1 13.0082
R1075 up_s up_s.n1 60.9541
R1076 up_s up_s.n0 3.12463
R1077 up_s.n0 up_s.t3 13.806
R1078 up_s.n0 up_s.t2 14.481
R1079 up_s.n1 up_s.t1 14.0207
R1080 vcp_p.t4 vcp_p.n0 3.11042
R1081 vcp_p.n0 vcp_p.t3 50.5496
R1082 vcp_p.n6 vcp_p.n0 9.71825
R1083 vcp_p.n3 vcp_p.n2 1.013
R1084 vcp_p.n6 vcp_p.n3 1.33925
R1085 vcp_p.n5 vcp_p.n6 34.2793
R1086 vcp_p vcp_p.n5 25.4514
R1087 vcp_p vcp_p.t0 25.5971
R1088 vcp_p.n5 vcp_p.n4 23.7852
R1089 vcp_p.n4 vcp_p.t6 11.5476
R1090 vcp_p.n4 vcp_p.t5 15.0261
R1091 vcp_p.n3 vcp_p.t7 60.139
R1092 vcp_p.n2 vcp_p.t8 60.139
R1093 vcp_p.n2 vcp_p.n1 10.8995
R1094 vcp_p.n1 vcp_p.t2 3.11042
R1095 vcp_p.n1 vcp_p.t1 50.5496
C0 vdump vbt 1.90382f
C1 cp_trim1 en_b 0.11308f
C2 vbp_vco vs 0.20572f
C3 nb pll_en 0.42712f
C4 vdump bias_ref 0.0396f
C5 r1 pll_en 0
C6 cp_trim0 vref 0.20263f
C7 a_10800_19930# a_12000_19930# 0.00585f
C8 vdump vnt 0.95014f
C9 vcp_n cp_trim1 1.08654f
C10 up_b t2 0.19121f
C11 vdd vcl 0.36941f
C12 a_6600_18610# vfilt 0.10189f
C13 vcp_p up_b 0.10688f
C14 vdd pfd_dn 0.58949f
C15 vdd up_s 3.28204f
C16 vdump t1a 0.07541f
C17 vbn_vco pll_en 0.13101f
C18 vfilt pll_en 2.38963f
C19 vbn_vco dn_b 0.12404f
C20 dn_b vfilt 3.38839f
C21 vbp_vco vbp 0.45927f
C22 t1c cp_trim0 1.30308f
C23 vs vbn_vco 0.03734f
C24 va vdd 1.29063f
C25 vs vfilt 8.06781f
C26 r5 vctrl 0.01161f
C27 pfd_dn vi 0
C28 vi up_s 0
C29 vcp_p vst 0.09192f
C30 vbt vbl 2.37982f
C31 a_6600_18610# vref 0.00948f
C32 vcl a_12000_19930# 0.00132f
C33 pfd_up t2 0.07723f
C34 pll_en vref 0.40076f
C35 va vi 0.15084f
C36 vbl vnt 0.17164f
C37 vbp_vco r1 0.03358f
C38 vcp_p pfd_up 0.1129f
C39 dn_b vref 0.33483f
C40 vbn_vco vbp 0.25691f
C41 vdd up_b 0.74743f
C42 vbp vfilt 7.06378f
C43 vs vref 0.62553f
C44 vctrl a_10800_19930# 0.00289f
C45 r3 r4 0.40373f
C46 bias_ref vco_out 0.04861f
C47 cp_trim0 cp_trim1 0.30197f
C48 vfilt dn_s 2.7126f
C49 vbp_vco vbn_vco 3.78834f
C50 a_15000_12478# en_b 0.00353f
C51 vbh vref 0.12756f
C52 vbp_vco vfilt 0.01522f
C53 vi up_b 0
C54 t2 en_b 0.11314f
C55 r5 r3 0.02755f
C56 t1b vcl 0.1954f
C57 vdd vst 0.78116f
C58 t1c dn_b 0.06526f
C59 bias_ref vbt 0.04507f
C60 vbn_vco r1 0.0944f
C61 vcp_p en_b 0.21476f
C62 t1b up_s 0.07239f
C63 t1b pfd_dn 0.03182f
C64 vcp_n t2 3.42614f
C65 vbp vref 0.53798f
C66 vcp_n vcp_p 5.19512f
C67 vs t1c 0
C68 vdd pfd_up 1.07208f
C69 dn_s vref 0.00898f
C70 va t1b 2.07934f
C71 vbt t1a 0.08464f
C72 vctrl vcl 0.22182f
C73 vbp_vco vref 0.19707f
C74 vi vst 0.15221f
C75 a_14400_19930# a_13200_19930# 0.00585f
C76 vbn_vco vfilt 0.01516f
C77 vctrl pfd_dn 3.70147f
C78 vctrl up_s 0.42997f
C79 pfd_up vi 0
C80 cp_trim1 pll_en 0.0832f
C81 dn_b cp_trim1 0.07838f
C82 va vctrl 2.16163f
C83 a_11400_12478# vfilt 0.02959f
C84 t1b up_b 2.60305f
C85 vs cp_trim1 0
C86 vdd en_b 3.56403f
C87 vcp_n a_1200_20110# 0
C88 vdump vcl 0.17602f
C89 r5 vco_out 0.07578f
C90 vdd vcp_n 5.39367f
C91 vdump pfd_dn 0.18478f
C92 vdump up_s 0.37427f
C93 a_6000_12478# a_4200_12478# 0.00234f
C94 vbn_vco vref 0.43553f
C95 vfilt vref 8.57295f
C96 vdump va 0.07242f
C97 vctrl up_b 2.46068f
C98 a_7200_12478# vfilt 0.02959f
C99 vi en_b 0.15561f
C100 cp_trim0 t2 3.57794f
C101 cp_trim0 vcp_p 0.09913f
C102 vbp cp_trim1 0.03063f
C103 t1b pfd_up 0.07799f
C104 t1c vfilt 0.73568f
C105 a_13800_12478# en_b 0.00374f
C106 vdump up_b 0.17918f
C107 vctrl vst 0.25157f
C108 bias_ref a_10800_19930# 0.01034f
C109 a_13200_19930# a_12000_19930# 0.00585f
C110 vctrl pfd_up 0.14359f
C111 vctrl a_4200_12478# 0.00482f
C112 a_15000_12478# pll_en 0
C113 vdd cp_trim0 0.05536f
C114 r5 r4 0.55691f
C115 t1b en_b 0.11326f
C116 t1c vref 0
C117 vdump vst 0.24344f
C118 t2 pll_en 0.0833f
C119 t1b vcp_n 0.1537f
C120 dn_b t2 0.03616f
C121 vcp_p pll_en 2.60986f
C122 cp_trim1 vfilt 3.23126f
C123 vcp_p dn_b 0.13657f
C124 a_14400_19930# vs 0.00168f
C125 vdump pfd_up 2.66584f
C126 vs t2 0
C127 vbt vcl 1.20127f
C128 vs vcp_p 0.03675f
C129 vbt up_s 3.9404f
C130 a_10200_12478# a_8400_12478# 0.00234f
C131 vbt pfd_dn 0.08866f
C132 bias_ref vcl 0.38063f
C133 vctrl en_b 3.75298f
C134 a_2000_12478# vfilt 0.04747f
C135 bias_ref pfd_dn 0.10304f
C136 bias_ref up_s 0.04496f
C137 vctrl vcp_n 0.0975f
C138 vcp_p vbh 0
C139 va vbt 4.73054f
C140 vbp a_15000_12478# 0
C141 cp_trim1 vref 0.1982f
C142 va bias_ref 0.045f
C143 vcl t1a 0.20602f
C144 a_12600_12478# pll_en 0.00109f
C145 va vnt 0.49711f
C146 pfd_dn t1a 0.05422f
C147 t1a up_s 0.08418f
C148 vbp t2 2.55606f
C149 vcp_p vbp 5.04214f
C150 a_13200_19930# vctrl 0.00289f
C151 vdump en_b 0.36848f
C152 vdd pll_en 3.2639f
C153 vdd dn_b 0.36927f
C154 vdump vcp_n 0.08851f
C155 vcp_p dn_s 1.08144f
C156 va t1a 2.22823f
C157 vs vdd 2.82571f
C158 vbt up_b 2.54639f
C159 vbp_vco vcp_p 0.25117f
C160 bias_ref up_b 0.06044f
C161 t1c cp_trim1 0.19875f
C162 t1b cp_trim0 0.05636f
C163 vi pll_en 0.42057f
C164 vdd vbh 4.21052f
C165 a_7800_18610# a_6600_18610# 0.00585f
C166 vi dn_b 0
C167 vbp a_12600_12478# 0.00185f
C168 vs vi 0.56473f
C169 t1a up_b 0.09881f
C170 a_15000_12478# vfilt 0.02959f
C171 vbp_vco r2 0.023f
C172 vdd vbp 24.9542f
C173 vbt vst 0.09192f
C174 cp_trim0 vctrl 0.06417f
C175 vs a_12000_19930# 0.00168f
C176 a_14400_19930# vfilt 0.09186f
C177 a_13800_12478# pll_en 0
C178 vfilt t2 4.21524f
C179 vbn_vco vcp_p 0.12404f
C180 vcp_p vfilt 8.05097f
C181 vst vnt 0
C182 vi vbh 0.09345f
C183 r2 r1 0.27959f
C184 vbt pfd_up 0.14847f
C185 bias_ref pfd_up 0.11322f
C186 vbp_vco vdd 7.57974f
C187 vi vbp 0.15517f
C188 a_10800_19930# vcl 0.00132f
C189 vdd nb 1.65294f
C190 vdd r1 0.43601f
C191 vdump cp_trim0 0.06411f
C192 vbn_vco r2 0.15869f
C193 a_14400_19930# vref 0.00106f
C194 t1b pll_en 0.08342f
C195 pfd_up t1a 0.29054f
C196 t2 vref 0.20491f
C197 t1b dn_b 0.03197f
C198 vcp_p vref 0.47805f
C199 vbp_vco vi 0.85454f
C200 a_12600_12478# vfilt 0.02959f
C201 a_13800_12478# vbp 0
C202 vs t1b 0
C203 vbt en_b 0.10539f
C204 vfilt a_1200_20110# 0.16254f
C205 vdd vbn_vco 1.53921f
C206 vbt vcp_n 1.14217f
C207 bias_ref en_b 0.05077f
C208 vdd vfilt 30.4242f
C209 a_11400_12478# a_12600_12478# 0.00585f
C210 vctrl pll_en 5.25148f
C211 bias_ref vcp_n 0.01134f
C212 vctrl dn_b 0.1384f
C213 vs vctrl 0.59468f
C214 t1c t2 0.07621f
C215 t1a en_b 0.11315f
C216 t1c vcp_p 0.06526f
C217 pfd_dn vcl 0.18225f
C218 vcl up_s 0.08986f
C219 vbn_vco vi 0.12542f
C220 t1b vbp 1.28638f
C221 pfd_dn up_s 0.21386f
C222 vcp_n t1a 0.48869f
C223 bias_ref a_13200_19930# 0
C224 vctrl vbh 4.19048f
C225 vdd vref 0.55517f
C226 vdump pll_en 0.38886f
C227 vfilt a_12000_19930# 0.09187f
C228 a_7800_18610# vfilt 0.10189f
C229 va vcl 0.08358f
C230 vdump dn_b 0.69544f
C231 va up_s 4.2646f
C232 va pfd_dn 0.05123f
C233 a_6000_12478# vfilt 0.02959f
C234 vs vdump 0.14608f
C235 vctrl vbp 0.32757f
C236 a_13800_12478# vfilt 0.02959f
C237 vctrl dn_s 0.52018f
C238 cp_trim1 t2 3.16382f
C239 vi vref 3.63807f
C240 vcp_p cp_trim1 0.113f
C241 vdump vbh 2.02187f
C242 vbp_vco vctrl 0.38382f
C243 vcl up_b 0.22657f
C244 vdd t1c 0.00742f
C245 a_12000_19930# vref 0.00106f
C246 vbt cp_trim0 0.04427f
C247 pfd_dn up_b 0.1327f
C248 up_b up_s 3.19093f
C249 bias_ref cp_trim0 0.00247f
C250 vfilt a_400_12478# 0.04747f
C251 vdump vbp 0.6088f
C252 vctrl nb 0.08691f
C253 t1b vfilt 3.61933f
C254 vdump dn_s 0.32243f
C255 va up_b 0.17458f
C256 a_7200_12478# a_6000_12478# 0.00585f
C257 a_10200_12478# vfilt 0.02959f
C258 cp_trim0 t1a 3.16826f
C259 vbp_vco vdump 0.39826f
C260 vst up_s 0.03142f
C261 a_11400_12478# a_10200_12478# 0.00585f
C262 vbn_vco vctrl 0.2545f
C263 pfd_dn vst 0.09192f
C264 vctrl vfilt 12.3242f
C265 vdd cp_trim1 0.05642f
C266 vco_out pll_en 0.61997f
C267 pfd_up vcl 0.28309f
C268 t1b vref 0.20495f
C269 pfd_dn pfd_up 3.21485f
C270 pfd_up up_s 0.2114f
C271 vbp_vco r3 0.05365f
C272 va vst 0.16545f
C273 vbl vbh 0.49955f
C274 r3 r1 0.33642f
C275 vbt pll_en 0.18756f
C276 va pfd_up 0.04936f
C277 vdump vbn_vco 0.24786f
C278 vbt dn_b 0.0347f
C279 vdump vfilt 3.14f
C280 bias_ref pll_en 0.1054f
C281 vctrl vref 0.70415f
C282 bias_ref dn_b 0.05016f
C283 vs vbt 0.04884f
C284 vs bias_ref 2.82208f
C285 vcl en_b 0.21271f
C286 t1c t1b 0.70676f
C287 vst up_b 0.09952f
C288 vcp_p a_15000_12478# 0
C289 pfd_dn en_b 0.25986f
C290 up_s en_b 1.14311f
C291 vbn_vco r3 0.11887f
C292 t1a pll_en 0.0832f
C293 vcp_n vcl 0.71459f
C294 vbt vbh 0.25043f
C295 dn_b t1a 3.47496f
C296 pfd_dn vcp_n 0.17646f
C297 vcp_n up_s 0.19636f
C298 vcp_p t2 0.14354f
C299 pfd_up up_b 4.79731f
C300 vnt vbh 1.9816f
C301 vs t1a 0
C302 vdump vref 4.09962f
C303 va en_b 0.51188f
C304 t1c vctrl 0.06547f
C305 vbt vbp 8.66996f
C306 va vcp_n 0.21547f
C307 a_13200_19930# vcl 0.00132f
C308 bias_ref vbp 0.0396f
C309 vbp vnt 0.00573f
C310 vco_out nb 0.72902f
C311 r4 pll_en 0.02678f
C312 t1b cp_trim1 3.48909f
C313 pfd_up vst 0.09293f
C314 vbp_vco vbt 0.25132f
C315 t1a vbp 1.29955f
C316 vcp_p a_12600_12478# 0
C317 up_b en_b 0.2252f
C318 vdump t1c 0.06526f
C319 a_2000_12478# a_400_12478# 0.00585f
C320 vcp_n up_b 0.09708f
C321 vdd t2 1.88179f
C322 vdd vcp_p 13.3089f
C323 r5 pll_en 0.29422f
C324 vctrl cp_trim1 0.0778f
C325 vbl vref 0.02086f
C326 cp_trim0 vcl 0.19176f
C327 vbn_vco vbt 0.12404f
C328 vst en_b 1.46056f
C329 cp_trim0 up_s 0.04427f
C330 vbt vfilt 2.37297f
C331 cp_trim0 pfd_dn 0.065f
C332 a_2000_12478# vctrl 0.00842f
C333 bias_ref vfilt 4.89881f
C334 vcp_p vi 0
C335 vdd r2 0.44333f
C336 pfd_up en_b 2.21802f
C337 vdump cp_trim1 0.07768f
C338 a_13800_12478# a_15000_12478# 0.00585f
C339 va cp_trim0 0.04427f
C340 vs a_10800_19930# 0.00168f
C341 vcp_n pfd_up 0.09611f
C342 vbp_vco r4 0.0922f
C343 t1a vfilt 3.74692f
C344 a_13800_12478# vcp_p 0
C345 r4 r1 0.20607f
C346 nb r4 0.02224f
C347 vbt vref 0.0427f
C348 bias_ref vref 2.89684f
C349 vbp_vco r5 0.03427f
C350 vnt vref 1.62742f
C351 cp_trim0 up_b 0.08985f
C352 vbn_vco r4 0.0468f
C353 vdd vi 0.08773f
C354 r5 nb 0.54437f
C355 r5 r1 0.26323f
C356 vcp_n en_b 0.61516f
C357 vcl pll_en 1.94211f
C358 t1b t2 1.6636f
C359 vcl dn_b 0.18203f
C360 t1a vref 0.23043f
C361 pfd_dn pll_en 0.27106f
C362 up_s pll_en 0.1392f
C363 t1b vcp_p 0.10449f
C364 dn_b up_s 0.1377f
C365 pfd_dn dn_b 9.22973f
C366 a_13800_12478# a_12600_12478# 0.00585f
C367 vs vcl 4.10167f
C368 vs up_s 0.03976f
C369 vs pfd_dn 0.08543f
C370 bias_ref t1c 0.01673f
C371 va pll_en 0.1417f
C372 va dn_b 0
C373 r5 vbn_vco 0.05703f
C374 a_14400_19930# vctrl 0.00289f
C375 vctrl t2 0.03527f
C376 vctrl vcp_p 0.15148f
C377 vs va 0.24926f
C378 pfd_dn vbh 0
C379 cp_trim0 pfd_up 0.07656f
C380 t1c t1a 0.06526f
C381 vcl vbp 0.09496f
C382 pfd_dn vbp 0.10454f
C383 vbp up_s 0.72835f
C384 up_b pll_en 0.27031f
C385 a_10800_19930# vfilt 0.09186f
C386 vdd t1b 0.96214f
C387 vcl dn_s 0
C388 dn_b up_b 0.07278f
C389 vbt cp_trim1 0.04398f
C390 vdump t2 0.03503f
C391 pfd_dn dn_s 0.08801f
C392 vdump vcp_p 5.69911f
C393 bias_ref cp_trim1 0.00516f
C394 va vbp 3.21956f
C395 vs up_b 0.0502f
C396 vbp_vco up_s 0.8601f
C397 vbp_vco pfd_dn 0.24971f
C398 cp_trim0 en_b 0.11308f
C399 vctrl a_1200_20110# 0.01597f
C400 vdd vctrl 6.04476f
C401 vbh up_b 0.01882f
C402 cp_trim0 vcp_n 0.63011f
C403 t1a cp_trim1 0.113f
C404 vst pll_en 0.09192f
C405 vbp_vco va 0.13018f
C406 vst dn_b 0.09192f
C407 a_10800_19930# vref 0.00106f
C408 vbp up_b 0.10591f
C409 pfd_up pll_en 0.27016f
C410 pfd_up dn_b 2.40289f
C411 vcl vfilt 7.8094f
C412 vbn_vco up_s 0.12449f
C413 vbn_vco pfd_dn 0.12404f
C414 vctrl vi 1.02594f
C415 pfd_dn vfilt 3.74566f
C416 vfilt up_s 1.09241f
C417 vs pfd_up 0.09515f
C418 vdump vdd 3.03584f
C419 r2 r3 0.42772f
C420 vctrl a_12000_19930# 0.00289f
C421 vbp_vco up_b 0.25557f
C422 va vbn_vco 0.12341f
C423 va vfilt 0.58782f
C424 vctrl a_6000_12478# 0.00279f
C425 pfd_up vbh 0.02874f
C426 vst vbp 0.61018f
C427 vdd r3 0.51027f
C428 pll_en en_b 3.77167f
C429 vdump vi 3.00891f
C430 vcl vref 9.3069f
C431 dn_b en_b 0.21994f
C432 pfd_up vbp 0.11915f
C433 pfd_dn vref 0.24922f
C434 vcp_n pll_en 0.07745f
C435 up_s vref 0.04909f
C436 vcp_n dn_b 0.11855f
C437 vs en_b 0.38951f
C438 vbp_vco vst 0.12112f
C439 vs vcp_n 0.01252f
C440 vbn_vco up_b 0.12414f
C441 vfilt up_b 2.53803f
C442 vbt t2 0.11771f
C443 va vref 0.78258f
C444 vctrl a_400_12478# 0.00842f
C445 vbt vcp_p 0.19693f
C446 vbp_vco pfd_up 0.29599f
C447 a_14400_19930# bias_ref 0
C448 t1b vctrl 0.03178f
C449 bias_ref vcp_p 0.0396f
C450 vdd vbl 1.00568f
C451 t1c vcl 0
C452 vs a_13200_19930# 0.00168f
C453 t1c pfd_dn 0.06526f
C454 vbp en_b 5.51926f
C455 t1a t2 2.73231f
C456 vbn_vco vst 0.32761f
C457 vcp_p t1a 0.31156f
C458 vcp_n vbp 8.256f
C459 vst vfilt 0.00284f
C460 vdd vco_out 0.63527f
C461 up_b vref 0.23265f
C462 vdump t1b 0.03159f
C463 vbl vi 0.04207f
C464 vcp_n dn_s 1.31867f
C465 vbn_vco pfd_up 0.12595f
C466 vbp_vco en_b 1.44323f
C467 pfd_up vfilt 2.62965f
C468 a_4200_12478# vfilt 0.02959f
C469 vdd vbt 10.8341f
C470 cp_trim0 pll_en 0.0832f
C471 bias_ref vdd 1.09436f
C472 vcl cp_trim1 0.21458f
C473 vdump vctrl 16.7816f
C474 cp_trim0 dn_b 0.07842f
C475 pfd_dn cp_trim1 0.07807f
C476 cp_trim1 up_s 0.04398f
C477 vst vref 1.5991f
C478 t1c up_b 0.00874f
C479 vs cp_trim0 0
C480 pfd_up vref 0.30417f
C481 vdd t1a 0.96471f
C482 vbn_vco en_b 1.00182f
C483 va cp_trim1 0.04398f
C484 vfilt en_b 2.66877f
C485 vcp_n vfilt 9.83485f
C486 vi vnt 0.03813f
C487 r2 r4 0.01267f
C488 bias_ref a_12000_19930# 0
C489 bias_ref a_7800_18610# 0.00948f
C490 a_8400_12478# vfilt 0.02959f
C491 cp_trim0 vbp 0.02918f
C492 vdd r4 0.53651f
C493 cp_trim1 up_b 0.15662f
C494 a_13200_19930# vfilt 0.09187f
C495 t1c pfd_up 0
C496 en_b vref 0.9146f
C497 vbl vctrl 6.4837f
C498 dn_b pll_en 0.27593f
C499 vcp_n vref 0.22767f
C500 vs pll_en 0.43969f
C501 vbt t1b 0.07242f
C502 vdd r5 1.02038f
C503 vs dn_b 0.04035f
C504 vco_out vctrl 0.11638f
C505 a_8400_12478# a_7200_12478# 0.00585f
C506 a_13200_19930# vref 0.00106f
C507 vbh pll_en 0
C508 vdump vbl 2.06937f
C509 dn_b vbh 0.00104f
C510 pfd_up cp_trim1 0.07714f
C511 a_14400_19930# vcl 0.00132f
C512 t1c vcp_n 0.4099f
C513 vcl t2 0.20531f
C514 vbt vctrl 3.7475f
C515 t1b t1a 1.68146f
C516 cp_trim0 vfilt 3.24502f
C517 t2 up_s 0.87416f
C518 vcp_p vcl 0.22344f
C519 pfd_dn t2 0.0356f
C520 vbp pll_en 2.60204f
C521 bias_ref vctrl 0.13449f
C522 dn_b vbp 0.0996f
C523 vcp_p up_s 5.99509f
C524 pfd_dn vcp_p 2.16442f
C525 vctrl vnt 2.59472f
C526 vs vbp 0.14784f
C527 dn_b dn_s 0.03125f
C528 a_2000_12478# a_4200_12478# 0.00234f
C529 va t2 0.1324f
C530 va vcp_p 0.037f
C531 vbp_vco pll_en 2.36512f
C532 vctrl t1a 0.03574f
C533 vs dn_s 0
C534 vbp_vco dn_b 0.25013f
C535 vco_out vss 1.20719f
C536 bias_ref vss 13.81271f
C537 pll_en vss 9.23861f
C538 pfd_up vss 4.1408f
C539 vctrl vss 27.99254f
C540 cp_trim1 vss 5.82211f
C541 cp_trim0 vss 5.66925f
C542 pfd_dn vss 4.46581f
C543 vdd vss 0.49604p
C544 nb vss 1.66676f
C545 r4 vss 1.35644f
C546 r5 vss 2.06869f
C547 r3 vss 1.56027f
C548 r1 vss 1.17086f
C549 r2 vss 0.98944f
C550 vi vss 5.01625f
C551 vnt vss 6.52386f
C552 vbn_vco vss 9.34635f
C553 vst vss 4.53344f
C554 vbh vss 5.14399f
C555 vbl vss 7.45711f
C556 vbp_vco vss 6.54205f
C557 a_15000_12478# vss 0.67694f
C558 a_14400_19930# vss 0.68276f
C559 a_13800_12478# vss 0.66937f
C560 a_13200_19930# vss 0.67329f
C561 a_12600_12478# vss 0.66937f
C562 a_12000_19930# vss 0.67329f
C563 a_11400_12478# vss 0.66937f
C564 a_10800_19930# vss 0.67329f
C565 a_10200_12478# vss 0.67529f
C566 a_8400_12478# vss 0.67529f
C567 a_7800_18610# vss 0.66004f
C568 a_7200_12478# vss 0.66937f
C569 a_6600_18610# vss 0.66004f
C570 a_6000_12478# vss 0.68001f
C571 a_4200_12478# vss 0.68519f
C572 vs vss 15.26858f
C573 a_2000_12478# vss 1.08757f
C574 a_1200_20110# vss 1.08608f
C575 a_400_12478# vss 1.10395f
C576 vcl vss 16.42893f
C577 up_b vss 5.61464f
C578 en_b vss 8.90695f
C579 t1c vss 2.95009f
C580 vdump vss 12.52351f
C581 dn_b vss 14.61595f
C582 dn_s vss 3.45362f
C583 vref vss 25.61498f
C584 t1b vss 14.45813f
C585 va vss 5.3679f
C586 t1a vss 14.84638f
C587 t2 vss 11.50812f
C588 vcp_n vss 21.48068f
C589 vbt vss 13.13358f
C590 vbp vss 10.19642f
C591 up_s vss 11.429f
C592 vcp_p vss 10.00981f
C593 vcp_p.t4 vss 4.92743f
C594 vcp_p.n0 vss 2.0917f
C595 vcp_p.t2 vss 4.92743f
C596 vcp_p.n1 vss 2.11514f
C597 vcp_p.n2 vss 1.89159f
C598 vcp_p.n3 vss 1.71514f
C599 vcp_p.t5 vss 2.37513f
C600 vcp_p.t6 vss 2.25231f
C601 vcp_p.n4 vss 3.31634f
C602 vcp_p.n5 vss 6.96625f
C603 vcp_p.t0 vss 0.62825f
C604 vcp_p.n6 vss 3.47292f
C605 up_s.t0 vss 6.48831f
C606 up_s.t1 vss 6.521f
C607 up_s.t2 vss 1.22746f
C608 up_s.t3 vss 1.20626f
C609 up_s.n0 vss 1.66511f
C610 up_s.n1 vss 8.59855f
C611 vbp.t4 vss 1.27285f
C612 vbp.t0 vss 0.49802f
C613 vbp.n0 vss 1.63317f
C614 vbp.n1 vss 3.53874f
C615 vbp.n2 vss 1.90572f
C616 vbp.n3 vss 1.83181f
C617 vbp.n4 vss 1.90572f
C618 vbp.n5 vss 1.88053f
C619 vbp.t3 vss 1.01007f
C620 vbp.n6 vss 1.80654f
C621 vbp.n7 vss 1.21616f
C622 vbp.n8 vss 1.93092f
C623 vbp.n9 vss 1.90572f
C624 vbp.n10 vss 1.83181f
C625 vbp.n11 vss 1.90572f
C626 vbp.n12 vss 1.90572f
C627 vbp.n13 vss 1.83181f
C628 vbp.n14 vss 5.58331f
C629 vbp.t1 vss 1.69642f
C630 vbp.n15 vss 8.97566f
C631 vbt.t3 vss 1.42737f
C632 vbt.t8 vss 1.10551f
C633 vbt.t0 vss 1.42737f
C634 vbt.n0 vss 0.82259f
C635 vbt.t1 vss 1.42737f
C636 vbt.n1 vss 0.48101f
C637 vbt.t9 vss 1.07724f
C638 vbt.n2 vss 0.56322f
C639 vbt.t10 vss 1.07724f
C640 vbt.n3 vss 0.56322f
C641 vbt.t2 vss 1.42737f
C642 vbt.n4 vss 0.48101f
C643 vbt.t11 vss 1.07724f
C644 vbt.n5 vss 1.57159f
C645 vbt.t6 vss 2.85946f
C646 vbt.t7 vss 2.62343f
C647 vbt.n6 vss 4.67205f
C648 vbt.t4 vss 2.62343f
C649 vbt.n7 vss 3.22911f
C650 vbt.t5 vss 2.62343f
C651 vbt.n8 vss 9.01642f
C652 vbt.n9 vss 0.48101f
C653 vcp_n.t11 vss 1.77368f
C654 vcp_n.n0 vss 1.08592f
C655 vcp_n.t9 vss 1.77368f
C656 vcp_n.n1 vss 1.10807f
C657 vcp_n.n2 vss 1.00246f
C658 vcp_n.n3 vss 0.85021f
C659 vcp_n.n4 vss 0.85021f
C660 vcp_n.n5 vss 0.78349f
C661 vcp_n.t6 vss 0.60492f
C662 vcp_n.n6 vss 0.65071f
C663 vcp_n.t4 vss 0.60787f
C664 vcp_n.n7 vss 0.52992f
C665 vcp_n.t3 vss 0.58647f
C666 vcp_n.n8 vss 0.70183f
C667 vcp_n.t7 vss 0.43487f
C668 vcp_n.n9 vss 0.77728f
C669 vcp_n.t0 vss 2.16429f
C670 vcp_n.t2 vss 2.03725f
C671 vcp_n.n10 vss 2.64856f
C672 vcp_n.t5 vss 2.03725f
C673 vcp_n.n11 vss 1.78929f
C674 vcp_n.t1 vss 2.03725f
C675 vcp_n.n12 vss 4.03894f
C676 vcp_n.n13 vss 0.40715f
C677 t2.t1 vss 2.12865f
C678 t2.t2 vss 3.69422f
C679 t2.t0 vss 3.00508f
C680 t2.n0 vss 10.1893f
C681 t1a.t1 vss 2.06368f
C682 t1a.t0 vss 8.81467f
C683 va.t1 vss 9.99366f
C684 va.t0 vss 1.07247f
C685 va.n0 vss 2.35691f
C686 va.t2 vss 0.41071f
C687 va.n1 vss 10.5697f
C688 t1b.t1 vss 2.04004f
C689 t1b.t0 vss 7.78466f
C690 vref.t2 vss 1.00008f
C691 vref.n0 vss 1.23429f
C692 vref.n1 vss 0.70365f
C693 vref.n2 vss 0.65195f
C694 vref.n3 vss 0.70365f
C695 vref.n4 vss 0.62022f
C696 vref.n5 vss 0.63461f
C697 vref.n6 vss 0.809f
C698 vref.t1 vss 0.36466f
C699 vref.n7 vss 2.67976f
C700 vref.n8 vss 2.52528f
C701 vref.n9 vss 1.2831f
C702 vref.n10 vss 2.58403f
C703 vref.t0 vss 1.66614f
C704 vref.n11 vss 6.68627f
C705 vref.n12 vss 0.42347f
C706 dn_s.t0 vss 2.40248f
C707 dn_s.t2 vss 2.44555f
C708 dn_s.t1 vss 0.86827f
C709 dn_s.n0 vss 1.28541f
C710 dn_s.t3 vss 0.84443f
C711 dn_s.n1 vss 0.82742f
C712 dn_b.t1 vss 1.71351f
C713 dn_b.t0 vss 0.72995f
C714 dn_b.n0 vss 10.7019f
C715 vdump.t11 vss 0.94921f
C716 vdump.n0 vss 0.98478f
C717 vdump.t9 vss 0.94921f
C718 vdump.n1 vss 1.01003f
C719 vdump.t15 vss 0.97672f
C720 vdump.n2 vss 1.14372f
C721 vdump.t16 vss 0.97672f
C722 vdump.n3 vss 1.70309f
C723 vdump.t14 vss 5.29216f
C724 vdump.t5 vss 0.95651f
C725 vdump.n4 vss 1.05104f
C726 vdump.t3 vss 0.95651f
C727 vdump.n5 vss 1.02472f
C728 vdump.n6 vss 1.16701f
C729 vdump.t1 vss 0.95651f
C730 vdump.n7 vss 1.02472f
C731 vdump.n8 vss 0.82262f
C732 vdump.t7 vss 0.95651f
C733 vdump.n9 vss 1.02472f
C734 vdump.n10 vss 0.8961f
C735 vdump.t12 vss 1.51642f
C736 vdump.n11 vss 1.0593f
C737 vdump.t13 vss 1.51642f
C738 vdump.n12 vss 2.11743f
C739 vdump.t17 vss 1.14652f
C740 vdump.n13 vss 3.12663f
C741 vdump.n14 vss 9.8714f
C742 vdump.n15 vss 1.21584f
C743 t1c.t0 vss 1.1198f
C744 t1c.t1 vss 1.11723f
C745 en_b.t1 vss 1.09316f
C746 en_b.n0 vss 3.83152f
C747 en_b.t0 vss 2.14227f
C748 en_b.n1 vss 7.58949f
C749 en_b.n2 vss 2.39222f
C750 en_b.n3 vss 1.34829f
C751 en_b.n4 vss 2.01382f
C752 en_b.n5 vss 6.72392f
C753 up_b.t1 vss 1.44008f
C754 up_b.n0 vss 10.7388f
C755 up_b.t0 vss 9.02289f
C756 vcl.t1 vss 3.55571f
C757 vcl.t4 vss 3.67712f
C758 vcl.t2 vss 3.55571f
C759 vcl.n0 vss 2.07549f
C760 vcl.t3 vss 3.55571f
C761 vcl.n1 vss 5.45071f
C762 vcl.t0 vss 1.72393f
C763 vcl.n2 vss 1.0786f
C764 vs.t1 vss 1.34749f
C765 vs.t2 vss 1.31232f
C766 vs.n0 vss 1.48317f
C767 vs.t0 vss 7.22445f
C768 vbp_vco.t6 vss 1.09276f
C769 vbp_vco.t5 vss 1.06896f
C770 vbp_vco.n0 vss 1.05394f
C771 vbp_vco.n1 vss 0.98597f
C772 vbp_vco.t1 vss 0.58387f
C773 vbp_vco.n2 vss 0.97924f
C774 vbp_vco.n3 vss 1.51463f
C775 vbp_vco.n4 vss 1.05277f
C776 vbp_vco.t3 vss 0.58387f
C777 vbp_vco.n5 vss 0.9451f
C778 vbp_vco.n6 vss 0.52634f
C779 vbp_vco.t4 vss 0.56895f
C780 vbp_vco.n7 vss 1.50992f
C781 vbp_vco.n8 vss 0.42491f
C782 vbp_vco.n9 vss 0.42308f
C783 vbp_vco.n10 vss 0.20765f
C784 vbp_vco.n11 vss 0.42308f
C785 vbp_vco.n12 vss 0.22709f
C786 vbp_vco.n13 vss 0.42308f
C787 vbp_vco.n14 vss 0.35834f
C788 vbp_vco.n15 vss 0.43896f
C789 vbp_vco.n16 vss 1.15018f
C790 vbl.t4 vss 0.7597f
C791 vbl.t6 vss 0.83823f
C792 vbl.t7 vss 0.7597f
C793 vbl.n0 vss 0.92919f
C794 vbl.t5 vss 0.7597f
C795 vbl.n1 vss 1.19352f
C796 vbl.t1 vss 0.41254f
C797 vbl.n2 vss 0.68962f
C798 vbl.n3 vss 1.01442f
C799 vbl.n4 vss 0.59378f
C800 vbl.t3 vss 0.41254f
C801 vbl.n5 vss 0.65353f
C802 vbl.n6 vss 0.99485f
C803 vbl.n7 vss 0.56698f
C804 vbh.t5 vss 0.73668f
C805 vbh.t4 vss 0.812f
C806 vbh.t1 vss 0.74663f
C807 vbh.n0 vss 0.89125f
C808 vbh.n1 vss 0.60244f
C809 vbh.n2 vss 1.06398f
C810 vbh.t3 vss 0.74663f
C811 vbh.n3 vss 0.89816f
C812 vbh.n4 vss 1.18591f
C813 vbh.n5 vss 0.99648f
C814 vst.t2 vss 1.07272f
C815 vst.t3 vss 1.05198f
C816 vst.n0 vss 0.75609f
C817 vst.n1 vss 1.09001f
C818 vst.t0 vss 0.40295f
C819 vst.n2 vss 1.4078f
C820 vst.t1 vss 2.73243f
C821 vbn_vco.t2 vss 1.00541f
C822 vbn_vco.t3 vss 1.02117f
C823 vbn_vco.n0 vss 1.37178f
C824 vbn_vco.t1 vss 0.32873f
C825 vbn_vco.n1 vss 0.56567f
C826 vbn_vco.n2 vss 0.38945f
C827 vbn_vco.t4 vss 0.37668f
C828 vbn_vco.n3 vss 0.22993f
C829 vbn_vco.n4 vss 0.22981f
C830 vbn_vco.n5 vss 0.16577f
C831 vbn_vco.n6 vss 0.22981f
C832 vbn_vco.n7 vss 0.16773f
C833 vbn_vco.n8 vss 0.22981f
C834 vbn_vco.n9 vss 0.2647f
C835 vbn_vco.n10 vss 0.24154f
C836 vbn_vco.n11 vss 1.06247f
C837 vbn_vco.n12 vss 1.06256f
C838 vnt.t1 vss 1.01926f
C839 vnt.t6 vss 0.68774f
C840 vnt.t2 vss 1.01926f
C841 vnt.n0 vss 0.48797f
C842 vnt.t7 vss 0.66959f
C843 vnt.n1 vss 0.7169f
C844 vnt.t4 vss 0.71431f
C845 vnt.n2 vss 0.60532f
C846 vnt.t0 vss 0.71431f
C847 vnt.n3 vss 0.56847f
C848 vnt.t3 vss 0.71431f
C849 vnt.n4 vss 0.90737f
C850 vnt.t5 vss 0.75066f
C851 vnt.n5 vss 0.28538f
C852 vi.t0 vss 1.07939f
C853 vi.t2 vss 1.50371f
C854 vi.t3 vss 1.01718f
C855 vi.n0 vss 1.31615f
C856 vi.t4 vss 1.01718f
C857 vi.n1 vss 0.46626f
C858 vi.t1 vss 1.10146f
C859 vi.n2 vss 0.82593f
C860 a_15646_1524.t1 vss 0.30238f
C861 a_15646_1524.t3 vss 0.2343f
C862 a_15646_1524.t2 vss 0.23397f
C863 a_15646_1524.n0 vss 0.29304f
C864 a_15646_1524.n1 vss 0.40745f
C865 a_15646_1524.t0 vss 0.30435f
C866 a_16450_1524.t1 vss 0.33579f
C867 a_16450_1524.t3 vss 0.24207f
C868 a_16450_1524.t2 vss 0.24174f
C869 a_16450_1524.n0 vss 0.32741f
C870 a_16450_1524.n1 vss 0.45524f
C871 a_16450_1524.t0 vss 0.33799f
C872 a_17254_1524.t2 vss 0.3299f
C873 a_17254_1524.t1 vss 0.23946f
C874 a_17254_1524.t0 vss 0.23912f
C875 a_17254_1524.n0 vss 0.31583f
C876 a_17254_1524.n1 vss 0.43914f
C877 a_17254_1524.t3 vss 0.32777f
C878 a_18058_1524.t1 vss 0.3228f
C879 a_18058_1524.t3 vss 0.23878f
C880 a_18058_1524.t2 vss 0.23845f
C881 a_18058_1524.n0 vss 0.31286f
C882 a_18058_1524.n1 vss 0.43502f
C883 a_18058_1524.t0 vss 0.32491f
C884 a_18862_1524.t1 vss 0.32862f
C885 a_18862_1524.t3 vss 0.2394f
C886 a_18862_1524.t2 vss 0.23907f
C887 a_18862_1524.n0 vss 0.31559f
C888 a_18862_1524.n1 vss 0.43881f
C889 a_18862_1524.t0 vss 0.33076f
C890 r2.t0 vss 0.10739f
C891 r2.n0 vss 0.21433f
C892 r2.n1 vss 0.31923f
C893 r2.n2 vss 0.22951f
C894 r2.n3 vss 0.19363f
C895 r2.n4 vss 0.22127f
C896 r2.t2 vss 0.06072f
C897 r2.t3 vss 0.06058f
C898 r2.n5 vss 0.08618f
C899 r2.t1 vss 0.10727f
C900 r1.t2 vss 0.11059f
C901 r1.n0 vss 0.23117f
C902 r1.n1 vss 0.35495f
C903 r1.n2 vss 0.24754f
C904 r1.n3 vss 0.20884f
C905 r1.n4 vss 0.24927f
C906 r1.t0 vss 0.06231f
C907 r1.t1 vss 0.06216f
C908 r1.n5 vss 0.09295f
C909 r1.t3 vss 0.11071f
C910 r3.t2 vss 0.10875f
C911 r3.n0 vss 0.23118f
C912 r3.n1 vss 0.38546f
C913 r3.n2 vss 0.24948f
C914 r3.n3 vss 0.222f
C915 r3.n4 vss 0.27459f
C916 r3.t1 vss 0.06095f
C917 r3.t0 vss 0.06081f
C918 r3.n5 vss 0.10198f
C919 r3.t3 vss 0.10886f
C920 r5.t0 vss 0.11351f
C921 r5.n0 vss 0.22163f
C922 r5.n1 vss 0.33986f
C923 r5.n2 vss 0.23917f
C924 r5.n3 vss 0.21283f
C925 r5.n4 vss 0.2396f
C926 r5.n5 vss 0.22497f
C927 r5.n6 vss 0.21955f
C928 r5.n7 vss 0.29544f
C929 r5.n8 vss 0.18665f
C930 r5.t2 vss 0.0642f
C931 r5.t3 vss 0.06405f
C932 r5.n9 vss 0.09776f
C933 r5.t1 vss 0.11364f
C934 r4.t0 vss 0.11575f
C935 r4.n0 vss 0.22916f
C936 r4.n1 vss 0.39134f
C937 r4.n2 vss 0.2497f
C938 r4.n3 vss 0.23406f
C939 r4.n4 vss 0.27567f
C940 r4.t3 vss 0.06519f
C941 r4.t2 vss 0.06504f
C942 r4.n5 vss 0.11098f
C943 r4.t1 vss 0.11588f
C944 nb.t4 vss 0.09765f
C945 nb.n0 vss 0.22771f
C946 nb.t2 vss 0.08045f
C947 nb.t5 vss 0.08031f
C948 nb.n1 vss 0.14407f
C949 nb.t1 vss 0.08025f
C950 nb.t0 vss 0.08012f
C951 nb.n2 vss 0.15358f
C952 nb.n3 vss 0.37858f
C953 nb.n4 vss 0.3543f
C954 nb.n5 vss 0.25017f
C955 nb.n6 vss 0.25457f
C956 nb.n7 vss 0.19071f
C957 nb.n8 vss 0.29477f
C958 nb.n9 vss 0.30031f
C959 nb.t3 vss 0.09783f
C960 a_15650_0.t0 vss 0.08736f
C961 a_15650_0.t1 vss 0.08813f
C962 a_15650_0.t3 vss 0.0766f
C963 a_15650_0.t2 vss 0.07633f
C964 a_15650_0.n0 vss 0.05232f
C965 a_15650_0.n1 vss 0.19835f
C966 a_16454_0.t0 vss 0.08214f
C967 a_16454_0.n0 vss 0.07379f
C968 a_16454_0.t1 vss 0.11227f
C969 a_16454_0.t2 vss 0.11331f
C970 a_16454_0.n1 vss 0.27974f
C971 a_16454_0.t3 vss 0.0824f
C972 a_17258_0.t0 vss 0.08177f
C973 a_17258_0.n0 vss 0.07144f
C974 a_17258_0.t1 vss 0.11097f
C975 a_17258_0.t2 vss 0.11198f
C976 a_17258_0.n1 vss 0.27084f
C977 a_17258_0.t3 vss 0.0815f
C978 a_18062_0.t0 vss 0.10831f
C979 a_18062_0.t1 vss 0.10931f
C980 a_18062_0.t2 vss 0.08147f
C981 a_18062_0.t3 vss 0.08121f
C982 a_18062_0.n0 vss 0.07035f
C983 a_18062_0.n1 vss 0.2667f
C984 a_18866_0.t0 vss 0.08009f
C985 a_18866_0.n0 vss 0.06623f
C986 a_18866_0.t1 vss 0.1062f
C987 a_18866_0.t2 vss 0.10715f
C988 a_18866_0.n1 vss 0.25107f
C989 a_18866_0.t3 vss 0.08036f
C990 a_19968_0.t2 vss 0.07001f
C991 a_19968_0.n0 vss 0.04071f
C992 a_19968_0.t0 vss 0.1008f
C993 a_19968_0.t1 vss 0.09852f
C994 a_19968_0.n1 vss 0.16601f
C995 a_19968_0.t3 vss 0.06983f
C996 vss.t17 vss 0.29709f
C997 vss.t66 vss 0.43699f
C998 vss.t35 vss 0.43699f
C999 vss.t49 vss 0.29709f
C1000 vss.t125 vss 0.43545f
C1001 vss.t121 vss 0.42203f
C1002 vss.t1 vss 0.42203f
C1003 vss.t52 vss 0.42203f
C1004 vss.t115 vss 0.42203f
C1005 vss.t134 vss 0.42203f
C1006 vss.t81 vss 0.32977f
C1007 vss.t108 vss 0.32977f
C1008 vss.t75 vss 0.31233f
C1009 vss.t19 vss 0.14048f
C1010 vss.t47 vss 0.13273f
C1011 vss.t3 vss 0.13273f
C1012 vss.t7 vss 0.10363f
C1013 vss.t113 vss 0.13273f
C1014 vss.t13 vss 0.95536f
C1015 vss.t72 vss 1.06614f
C1016 vss.t56 vss 1.06614f
C1017 vss.t15 vss 1.06614f
C1018 vss.t77 vss 1.06614f
C1019 vss.t90 vss 0.95536f
C1020 vss.t83 vss 2.09881f
C1021 vss.t33 vss 0.16927f
C1022 vss.t5 vss 0.19732f
C1023 vss.t92 vss 1.4677f
C1024 vss.t123 vss 1.20776f
C1025 vss.t60 vss 1.18284f
C1026 vss.t58 vss 1.18284f
C1027 vss.t70 vss 1.18284f
C1028 vss.t29 vss 76.2313f
C1029 vss.t62 vss 0.0601f
C1030 vss.t132 vss 0.06023f
C1031 vss.t96 vss 0.05952f
C1032 vss.t98 vss 0.05971f
C1033 vss.t102 vss 0.06219f
C1034 vss.t142 vss 0.06245f
C1035 vss.t128 vss 0.06219f
C1036 vss.t86 vss 0.06245f
C1037 vss.t88 vss 0.06219f
C1038 vss.t25 vss 0.06245f
C1039 vss.t27 vss 0.06219f
C1040 vss.t117 vss 0.06245f
C1041 vss.t119 vss 0.06219f
C1042 vss.t144 vss 0.06245f
C1043 vss.t139 vss 65.9619f
C1044 vdd.t88 vss 3.04366f
C1045 vdd.n0 vss 2.52167f
C1046 vdd.t23 vss 3.17677f
C1047 vdd.n1 vss 0.09633f
C1048 vdd.t19 vss 3.17677f
C1049 vdd.n2 vss 0.09791f
C1050 vdd.n3 vss 0.27953f
C1051 vdd.t34 vss 3.04366f
C1052 vdd.n4 vss 0.08138f
C1053 vdd.t57 vss 1.31389f
C1054 vdd.n5 vss 0.21404f
C1055 vdd.t25 vss 1.28336f
C1056 vdd.n6 vss 0.21561f
C1057 vdd.n7 vss 0.27953f
C1058 vdd.t59 vss 1.28336f
C1059 vdd.n8 vss 0.19908f
C1060 vdd.t49 vss 1.28336f
C1061 vdd.n9 vss 0.21404f
C1062 vdd.t94 vss 1.28336f
C1063 vdd.n10 vss 0.21561f
C1064 vdd.n11 vss 0.27953f
C1065 vdd.t28 vss 1.28336f
C1066 vdd.n12 vss 0.19908f
C1067 vdd.t112 vss 0.8926f
C1068 vdd.n13 vss 0.21404f
C1069 vdd.t92 vss 1.28336f
C1070 vdd.n14 vss 0.21561f
C1071 vdd.n15 vss 0.27953f
C1072 vdd.t55 vss 1.28336f
C1073 vdd.n16 vss 0.19908f
C1074 vdd.t38 vss 1.28336f
C1075 vdd.n17 vss 0.21404f
C1076 vdd.t67 vss 1.28336f
C1077 vdd.n18 vss 0.21561f
C1078 vdd.n19 vss 0.27953f
C1079 vdd.t12 vss 1.28336f
C1080 vdd.n20 vss 0.19908f
C1081 vdd.t36 vss 1.28336f
C1082 vdd.n21 vss 0.21404f
C1083 vdd.t47 vss 1.28336f
C1084 vdd.n22 vss 0.21561f
C1085 vdd.n23 vss 2.73817f
C1086 vdd.n24 vss 2.73817f
C1087 vdd.n25 vss 2.73817f
C1088 vdd.n26 vss 2.73817f
C1089 vdd.n27 vss 2.73817f
C1090 vdd.t11 vss 3.07506f
C1091 vdd.t18 vss 3.07506f
C1092 vdd.t22 vss 3.52554f
C1093 vdd.t24 vss 3.07506f
C1094 vdd.t27 vss 3.07506f
C1095 vdd.t33 vss 3.07506f
C1096 vdd.t35 vss 3.52554f
C1097 vdd.t37 vss 3.52554f
C1098 vdd.t46 vss 3.56129f
C1099 vdd.t48 vss 3.52554f
C1100 vdd.t54 vss 3.07506f
C1101 vdd.t56 vss 3.52554f
C1102 vdd.t58 vss 3.07506f
C1103 vdd.t66 vss 3.07506f
C1104 vdd.t87 vss 3.56826f
C1105 vdd.t91 vss 3.07506f
C1106 vdd.t93 vss 3.07506f
C1107 vdd.t111 vss 3.52554f
C1108 vdd.n28 vss 3.25073f
C1109 vdd.n29 vss 1.05125f
C1110 vdd.n30 vss 0.18234f
C1111 vdd.t10 vss 0.61367f
C1112 vdd.n31 vss 0.0728f
C1113 vdd.t6 vss 0.74713f
C1114 vdd.n32 vss 0.08776f
C1115 vdd.t90 vss 0.74713f
C1116 vdd.n33 vss 0.08933f
C1117 vdd.n34 vss 0.11581f
C1118 vdd.t65 vss 0.61367f
C1119 vdd.n35 vss 0.0728f
C1120 vdd.t62 vss 0.3276f
C1121 vdd.n36 vss 0.0925f
C1122 vdd.t21 vss 0.54356f
C1123 vdd.n37 vss 0.08249f
C1124 vdd.t74 vss 0.17974f
C1125 vdd.n38 vss 0.09522f
C1126 vdd.t76 vss 0.17199f
C1127 vdd.n39 vss 0.09679f
C1128 vdd.n40 vss 0.1058f
C1129 vdd.t78 vss 0.19907f
C1130 vdd.n41 vss 0.07754f
C1131 vdd.t51 vss 2.05387f
C1132 vdd.n42 vss 0.11507f
C1133 vdd.n43 vss 0.16663f
C1134 vdd.t4 vss 0.31825f
C1135 vdd.n44 vss 0.09266f
C1136 vdd.t32 vss 0.37076f
C1137 vdd.n45 vss 0.06396f
C1138 vdd.t30 vss 0.37076f
C1139 vdd.n46 vss 0.06553f
C1140 vdd.n47 vss 0.10708f
C1141 vdd.t100 vss 0.31825f
C1142 vdd.n48 vss 0.05773f
C1143 vdd.t82 vss 0.17276f
C1144 vdd.n49 vss 0.09807f
C1145 vdd.n50 vss 0.61845f
C1146 vdd.n51 vss 0.6688f
C1147 vdd.n52 vss 0.71915f
C1148 vdd.n53 vss 0.54595f
C1149 vdd.n54 vss 1.04641f
C1150 vdd.n55 vss 0.56811f
C1151 vdd.t2 vss 0.70487f
C1152 vdd.t3 vss 0.60418f
C1153 vdd.t5 vss 0.90627f
C1154 vdd.t9 vss 0.79047f
C1155 vdd.t17 vss 0.70487f
C1156 vdd.t20 vss 0.55987f
C1157 vdd.t26 vss 0.70487f
C1158 vdd.t29 vss 0.5639f
C1159 vdd.t31 vss 0.60418f
C1160 vdd.t50 vss 1.50944f
C1161 vdd.t60 vss 0.5639f
C1162 vdd.t61 vss 0.64647f
C1163 vdd.t63 vss 0.60418f
C1164 vdd.t64 vss 0.70387f
C1165 vdd.t73 vss 0.55987f
C1166 vdd.t75 vss 0.53067f
C1167 vdd.t77 vss 1.02006f
C1168 vdd.t81 vss 0.57898f
C1169 vdd.t89 vss 0.79047f
C1170 vdd.t99 vss 0.55282f
C1171 vdd.t113 vss 0.68071f
C1172 vdd.t114 vss 0.63942f
C1173 vdd.t115 vss 0.63942f
C1174 vdd.t116 vss 0.63942f
C1175 vdd.t117 vss 0.70487f
C1176 vdd.n56 vss 0.80962f
C1177 vdd.n57 vss 0.30189f
C1178 vdd.t106 vss 0.71364f
C1179 vdd.n58 vss 0.0404f
C1180 vdd.n59 vss 0.0862f
C1181 vdd.n60 vss 0.0404f
C1182 vdd.n61 vss 0.18824f
C1183 vdd.n62 vss 0.03655f
C1184 vdd.n63 vss 0.18824f
C1185 vdd.n64 vss 0.03655f
C1186 vdd.t0 vss 0.22145f
C1187 vdd.t1 vss 0.65133f
C1188 vdd.t7 vss 0.90751f
C1189 vdd.t13 vss 0.69909f
C1190 vdd.t15 vss 0.17369f
C1191 vdd.t39 vss 1.76292f
C1192 vdd.t41 vss 0.22145f
C1193 vdd.t42 vss 0.65133f
C1194 vdd.t43 vss 0.65133f
C1195 vdd.t44 vss 0.75337f
C1196 vdd.t52 vss 0.88797f
C1197 vdd.t68 vss 0.22145f
C1198 vdd.t69 vss 0.72773f
C1199 vdd.t70 vss 0.21277f
C1200 vdd.t71 vss 0.90751f
C1201 vdd.t79 vss 0.85541f
C1202 vdd.t83 vss 0.80981f
C1203 vdd.t85 vss 0.90751f
C1204 vdd.t95 vss 0.63613f
C1205 vdd.t97 vss 0.17369f
C1206 vdd.t101 vss 0.22145f
C1207 vdd.t102 vss 0.69909f
C1208 vdd.t104 vss 0.17369f
C1209 vdd.t108 vss 0.17369f
C1210 vdd.t110 vss 0.65133f
C1211 vdd.t118 vss 0.82936f
C1212 vdd.t120 vss 0.17369f
C1213 vdd.t105 vss 0.26283f
C1214 vdd.n65 vss 0.10289f
C1215 vdd.t103 vss 0.2625f
C1216 vdd.n66 vss 0.0994f
C1217 vdd.t109 vss 0.26283f
C1218 vdd.n67 vss 0.09355f
C1219 vdd.t107 vss 0.2625f
C1220 vdd.n68 vss 0.08464f
C1221 vdd.t16 vss 0.26283f
C1222 vdd.n69 vss 0.0994f
C1223 vdd.t14 vss 0.2625f
C1224 vdd.n70 vss 0.0994f
C1225 vdd.t98 vss 0.26283f
C1226 vdd.n71 vss 0.0932f
C1227 vdd.t96 vss 0.2625f
C1228 vdd.n72 vss 0.08499f
C1229 vdd.t121 vss 0.26283f
C1230 vdd.n73 vss 0.0994f
C1231 vdd.t119 vss 0.2625f
C1232 vdd.n74 vss 0.10464f
C1233 vdd.t80 vss 0.11912f
C1234 vdd.n75 vss 0.1289f
C1235 vdd.t84 vss 0.11893f
C1236 vdd.n76 vss 0.12803f
C1237 vdd.t72 vss 0.10174f
C1238 vdd.n77 vss 0.13685f
C1239 vdd.t86 vss 0.1016f
C1240 vdd.n78 vss 0.13685f
C1241 vdd.t45 vss 0.14977f
C1242 vdd.n79 vss 0.12561f
C1243 vdd.t53 vss 0.14964f
C1244 vdd.n80 vss 0.13102f
C1245 vdd.t8 vss 0.14977f
C1246 vdd.n81 vss 0.28452f
C1247 vdd.t40 vss 0.15894f
C1248 vdd.n82 vss 1.45381f
C1249 vdd.n83 vss 1.41802f
C1250 pfd_dn.n0 vss 11.9824f
C1251 pfd_dn.n1 vss 11.3249f
C1252 cp_trim0.n0 vss 9.24656f
C1253 cp_trim1.n0 vss 8.97157f
C1254 vctrl.t0 vss 1.02421f
C1255 vctrl.t2 vss 0.62027f
C1256 vctrl.n0 vss 2.04283f
C1257 vctrl.n1 vss 0.36151f
C1258 vctrl.n2 vss 0.20246f
C1259 vctrl.n3 vss 0.20619f
C1260 vctrl.t1 vss 0.39558f
C1261 vctrl.n4 vss 0.57601f
C1262 vctrl.n5 vss 0.38964f
C1263 vctrl.n6 vss 0.52536f
C1264 vctrl.n7 vss 0.89142f
C1265 vctrl.n8 vss 0.69162f
C1266 vctrl.n9 vss 0.12766f
C1267 vctrl.n10 vss 0.5164f
C1268 pfd_up.n0 vss 5.19067f
C1269 pfd_up.n1 vss 11.4847f
C1270 pll_en.n0 vss 1.88227f
C1271 pll_en.n1 vss 2.40763f
C1272 pll_en.n2 vss 2.6176f
C1273 pll_en.n3 vss 2.47808f
C1274 pll_en.n4 vss 9.3545f
C1275 pll_en.n5 vss 2.02569f
C1276 pll_en.n6 vss 2.46459f
C1277 pll_en.n7 vss 0.32691f
C1278 pll_en.n8 vss 0.30151f
C1279 pll_en.n9 vss 0.39843f
C1280 bias_ref.t0 vss 0.37251f
C1281 bias_ref.t1 vss 0.214f
C1282 bias_ref.n0 vss 7.65986f
C1283 vco_out.t0 vss 0.11358f
C1284 vco_out.t2 vss 0.11345f
C1285 vco_out.n0 vss 0.2848f
C1286 vco_out.n1 vss 0.70577f
C1287 vco_out.t3 vss 0.11358f
C1288 vco_out.t4 vss 0.11345f
C1289 vco_out.n2 vss 0.22089f
C1290 vco_out.t5 vss 0.11341f
C1291 vco_out.t1 vss 0.11328f
C1292 vco_out.n3 vss 0.21595f
C1293 vco_out.n4 vss 0.31208f
.ends
