* NGSPICE file created from pll_analog.ext - technology: gf180mcuD

.subckt pll_analog vco_div2 pfd_up pfd_dn pll_en cp_trim0 cp_trim1 vctrl bias_ref vdd vss
X0 a_7800_17156 a_7200_11024 vss.t51 ppolyf_u r_width=1u r_length=30u
X1 a_16296_1350.t3 r3.t6 r4.t2 vdd.t15 pfet_03v3 ad=1.95p pd=7.3u as=0.78p ps=3.52u w=3u l=0.28u
X2 vnt.t3 vref.t8 vss.t130 vss.t129 nfet_03v3 ad=1.22p pd=5.22u as=1.22p ps=5.22u w=2u l=2u
X3 vcl.t0 vref.t14 vss.t71 vss.t70 nfet_03v3 ad=6.1p pd=21.22u as=6.1p ps=21.22u w=10u l=2u
X4 vdd.t53 nb.t10 vco_out.t5 vdd.t15 pfet_03v3 ad=1.95p pd=7.3u as=0.78p ps=3.52u w=3u l=0.28u
X5 vcl.t2 vref.t13 vss.t76 vss.t75 nfet_03v3 ad=6.1p pd=21.22u as=6.1p ps=21.22u w=10u l=2u
X6 r4.t3 r3.t7 a_16296_1350.t2 vdd.t15 pfet_03v3 ad=0.78p pd=3.52u as=1.95p ps=7.3u w=3u l=0.28u
X7 vss.t12 nb.t6 vco_out.t0 vss.t11 nfet_03v3 ad=1.83p pd=7.22u as=0.78p ps=3.52u w=3u l=0.28u
X8 vbh.t3 vbh.t2 vdd.t65 vdd.t64 pfet_03v3 ad=2.6p pd=9.3u as=2.6p ps=9.3u w=4u l=2u
X9 vbp.t0 vst.t4 vss.t78 vss.t77 nfet_03v3 ad=0.305p pd=2.22u as=0.305p ps=2.22u w=0.5u l=4u
X10 dn_b.t1 pfd_dn.t1 vss.t67 vss.t66 nfet_03v3 ad=0.61p pd=3.22u as=0.61p ps=3.22u w=1u l=0.28u
X11 a_13200_18476 a_13800_11024 vss.t57 ppolyf_u r_width=1u r_length=36.6u
X12 vbp.t3 va.t3 vref.t1 vss.t131 nfet_03v3 ad=2.44p pd=9.22u as=2.44p ps=9.22u w=4u l=1u
X13 vcl.t4 a_4200_11024 vss.t96 ppolyf_u r_width=1u r_length=17.5u
X14 vref.t0 en_b.t3 vss.t90 vss.t89 nfet_03v3 ad=0.61p pd=3.22u as=0.61p ps=3.22u w=1u l=0.28u
X15 vss.t5 vbn_vco.t5 a_17668_0.t0 vss.t4 nfet_03v3 ad=1.22p pd=5.22u as=0.52p ps=2.52u w=2u l=0.5u
X16 vcp_n.t1 vcp_n.t0 vss.t99 vss.t98 nfet_03v3 ad=6.1p pd=21.22u as=6.1p ps=21.22u w=10u l=2u
X17 vcp_n.t4 cp_trim0.t1 t1a.t0 vss.t2 nfet_03v3 ad=1.22p pd=5.22u as=1.22p ps=5.22u w=2u l=0.28u
X18 dx.t1 dqn.t4 vss.t181 vss.t180 nfet_03v3 ad=0.61p pd=3.22u as=0.61p ps=3.22u w=1u l=0.28u
X19 vfilt vss.t29 cap_nmos_03v3_b c_width=35u c_length=12u
X20 vfilt vss.t39 cap_nmos_03v3_b c_width=35u c_length=12u
X21 vfilt a_2000_11024 vss.t134 ppolyf_u r_width=2u r_length=37.5u
X22 vdd.t48 vbp_vco.t9 a_16980_1350.t2 vdd.t21 pfet_03v3 ad=3.25p pd=11.3u as=1.3p ps=5.52u w=5u l=0.5u
X23 a_10800_18476 a_10200_11024 vss.t55 ppolyf_u r_width=1u r_length=36.6u
X24 t1c.t0 cp_trim0.t0 t1b.t0 vss.t3 nfet_03v3 ad=1.22p pd=5.22u as=1.22p ps=5.22u w=2u l=0.28u
X25 vcl.t1 vref.t12 vss.t74 vss.t73 nfet_03v3 ad=6.1p pd=21.22u as=6.1p ps=21.22u w=10u l=2u
X26 vbl.t4 vctrl.t10 vbt.t8 vdd.t95 pfet_03v3 ad=3.25p pd=11.3u as=3.25p ps=11.3u w=5u l=1u
X27 vbl.t5 vctrl.t7 vbt.t11 vdd.t98 pfet_03v3 ad=3.25p pd=11.3u as=3.25p ps=11.3u w=5u l=1u
X28 dqn.t2 pll_en.t2 vdd.t75 vdd.t74 pfet_03v3 ad=0.325p pd=2.3u as=0.325p ps=2.3u w=0.5u l=0.28u
X29 vbh.t5 vctrl.t5 vnt.t7 vss.t176 nfet_03v3 ad=3.05p pd=11.22u as=3.05p ps=11.22u w=5u l=1u
X30 t1a.t1 vbp.t12 vdd.t37 vdd.t36 pfet_03v3 ad=2.6p pd=9.3u as=2.6p ps=9.3u w=4u l=2u
X31 a_16296_1350.t1 vbp_vco.t12 vdd.t67 vdd.t21 pfet_03v3 ad=1.3p pd=5.52u as=3.25p ps=11.3u w=5u l=0.5u
X32 vfilt vss.t45 cap_nmos_03v3_b c_width=35u c_length=12u
X33 a_18352_n100.t0 r5.t4 nb.t0 vss.t16 nfet_03v3 ad=1.22p pd=5.22u as=0.52p ps=2.52u w=2u l=0.28u
X34 r5.t2 r4.t5 a_17668_0.t3 vss.t104 nfet_03v3 ad=0.39p pd=2.02u as=0.915p ps=4.22u w=1.5u l=0.28u
X35 vdump.t0 vbl.t9 vss.t64 vss.t63 nfet_03v3 ad=1.22p pd=5.22u as=1.22p ps=5.22u w=2u l=2u
X36 vbp_vco.t5 pll_en.t6 vi.t1 vss.t161 nfet_03v3 ad=3.05p pd=11.22u as=3.05p ps=11.22u w=5u l=0.28u
X37 vbl.t1 vbl.t0 vss.t88 vss.t87 nfet_03v3 ad=1.22p pd=5.22u as=1.22p ps=5.22u w=2u l=2u
X38 a_6600_17156 a_6000_11024 vss.t54 ppolyf_u r_width=1u r_length=30u
X39 vss.t7 a_15000_11024 vss.t6 ppolyf_u r_width=1u r_length=36.6u
X40 vdump.t12 vdump.t11 vbt.t4 vdd.t35 pfet_03v3 ad=3.25p pd=11.3u as=3.25p ps=11.3u w=5u l=1u
X41 up_b.t0 pfd_up.t1 vdd.t31 vdd.t30 pfet_03v3 ad=1.3p pd=5.3u as=1.3p ps=5.3u w=2u l=0.28u
X42 vbn_vco.t0 vbp_vco.t17 vdd.t1 vdd.t0 pfet_03v3 ad=3.25p pd=11.3u as=3.25p ps=11.3u w=5u l=0.5u
X43 vco_div2.t3 dqb.t3 vss.t133 vss.t132 nfet_03v3 ad=0.39p pd=2.02u as=0.915p ps=4.22u w=1.5u l=0.28u
X44 vdd.t22 vbp_vco.t7 a_17664_1350.t2 vdd.t21 pfet_03v3 ad=3.25p pd=11.3u as=1.3p ps=5.52u w=5u l=0.5u
X45 vfilt vss.t37 cap_nmos_03v3_b c_width=35u c_length=12u
X46 vfilt vss.t27 cap_nmos_03v3_b c_width=35u c_length=12u
X47 a_12000_18476 a_12600_11024 vss.t59 ppolyf_u r_width=1u r_length=36.6u
X48 vco_div2.t2 dqb.t5 vdd.t45 vdd.t15 pfet_03v3 ad=0.78p pd=3.52u as=1.95p ps=7.3u w=3u l=0.28u
X49 up_s.t0 vcp_p.t8 vdd.t20 vdd.t19 pfet_03v3 ad=16.25p pd=51.3u as=16.25p ps=51.3u w=25u l=2u
X50 dqb.t1 dqn.t3 vss.t121 vss.t120 nfet_03v3 ad=0.61p pd=3.22u as=0.61p ps=3.22u w=1u l=0.28u
X51 vcp_p.t4 vcp_p.t3 vdd.t7 vdd.t6 pfet_03v3 ad=16.25p pd=51.3u as=16.25p ps=51.3u w=25u l=2u
X52 vbt.t7 vbp.t15 vdd.t94 vdd.t93 pfet_03v3 ad=2.6p pd=9.3u as=2.6p ps=9.3u w=4u l=2u
X53 vco_out.t3 nb.t11 vdd.t33 vdd.t15 pfet_03v3 ad=0.78p pd=3.52u as=1.95p ps=7.3u w=3u l=0.28u
X54 vbt.t0 vbp.t7 vdd.t5 vdd.t4 pfet_03v3 ad=2.6p pd=9.3u as=2.6p ps=9.3u w=4u l=2u
X55 vctrl.t1 pfd_dn.t2 dn_s.t1 vss.t65 nfet_03v3 ad=1.22p pd=5.22u as=1.22p ps=5.22u w=2u l=0.5u
X56 vco_out.t1 nb.t7 vss.t69 vss.t68 nfet_03v3 ad=0.78p pd=3.52u as=1.83p ps=7.22u w=3u l=0.28u
X57 a_7800_17156 a_8400_11024 vss.t56 ppolyf_u r_width=1u r_length=30u
X58 dx.t0 vco_out.t9 a_20918_1350 vdd.t11 pfet_03v3 ad=1.3p pd=5.3u as=1.3p ps=5.3u w=2u l=0.28u
X59 a_17664_1350.t1 r4.t6 r5.t0 vdd.t15 pfet_03v3 ad=1.95p pd=7.3u as=0.78p ps=3.52u w=3u l=0.28u
X60 up_s.t3 vcp_p.t7 vdd.t47 vdd.t46 pfet_03v3 ad=16.25p pd=51.3u as=16.25p ps=51.3u w=25u l=2u
X61 vbl.t7 vctrl.t9 vbt.t9 vdd.t96 pfet_03v3 ad=3.25p pd=11.3u as=3.25p ps=11.3u w=5u l=1u
X62 r3.t1 r2.t5 a_14932_0.t2 vss.t97 nfet_03v3 ad=0.39p pd=2.02u as=0.915p ps=4.22u w=1.5u l=0.28u
X63 vcp_n.t7 vbp.t14 vdd.t55 vdd.t54 pfet_03v3 ad=2.6p pd=9.3u as=2.6p ps=9.3u w=4u l=2u
X64 vdump.t17 dn_b.t2 dn_s.t0 vss.t158 nfet_03v3 ad=1.22p pd=5.22u as=1.22p ps=5.22u w=2u l=0.5u
X65 vctrl.t0 up_b.t2 up_s.t1 vdd.t8 pfet_03v3 ad=2.6p pd=9.3u as=2.6p ps=9.3u w=4u l=0.5u
X66 vcp_p.t0 vcp_n.t15 vss.t119 vss.t118 nfet_03v3 ad=6.1p pd=21.22u as=6.1p ps=21.22u w=10u l=2u
X67 vcp_n.t5 vbp.t6 vdd.t14 vdd.t13 pfet_03v3 ad=2.6p pd=9.3u as=2.6p ps=9.3u w=4u l=2u
X68 a_14928_1350.t1 r2.t6 r3.t2 vdd.t15 pfet_03v3 ad=1.95p pd=7.3u as=0.78p ps=3.52u w=3u l=0.28u
X69 a_14400_18476 a_13800_11024 vss.t155 ppolyf_u r_width=1u r_length=36.6u
X70 a_16984_0.t0 vbn_vco.t8 vss.t20 vss.t19 nfet_03v3 ad=0.52p pd=2.52u as=1.22p ps=5.22u w=2u l=0.5u
X71 a_15616_0.t0 r1.t4 r2.t1 vss.t93 nfet_03v3 ad=0.915p pd=4.22u as=0.39p ps=2.02u w=1.5u l=0.28u
X72 vdump.t6 vdump.t5 vbt.t2 vdd.t24 pfet_03v3 ad=3.25p pd=11.3u as=3.25p ps=11.3u w=5u l=1u
X73 a_20918_1350 dqn.t6 vdd.t68 vdd.t11 pfet_03v3 ad=1.3p pd=5.3u as=1.3p ps=5.3u w=2u l=0.28u
X74 vcp_p.t6 vcp_p.t5 vdd.t70 vdd.t69 pfet_03v3 ad=16.25p pd=51.3u as=16.25p ps=51.3u w=25u l=2u
X75 vbp.t2 vbp.t1 vdd.t104 vdd.t103 pfet_03v3 ad=2.6p pd=9.3u as=2.6p ps=9.3u w=4u l=2u
X76 vss.t166 pll_en.t0 a_18352_n100.t3 vss.t165 nfet_03v3 ad=1.22p pd=5.22u as=0.52p ps=2.52u w=2u l=0.28u
X77 vnt.t2 vref.t5 vss.t110 vss.t109 nfet_03v3 ad=1.22p pd=5.22u as=1.22p ps=5.22u w=2u l=2u
X78 t2.t2 vbp.t13 vdd.t92 vdd.t91 pfet_03v3 ad=2.6p pd=9.3u as=2.6p ps=9.3u w=4u l=2u
X79 vdd.t58 vbp_vco.t13 a_15612_1350.t2 vdd.t21 pfet_03v3 ad=3.25p pd=11.3u as=1.3p ps=5.52u w=5u l=0.5u
X80 vnt.t1 vref.t9 vss.t18 vss.t17 nfet_03v3 ad=1.22p pd=5.22u as=1.22p ps=5.22u w=2u l=2u
X81 en_b.t1 pll_en.t11 vss.t160 vss.t159 nfet_03v3 ad=0.61p pd=3.22u as=0.61p ps=3.22u w=1u l=0.28u
X82 r2.t0 r1.t5 a_15616_0.t1 vss.t94 nfet_03v3 ad=0.39p pd=2.02u as=0.915p ps=4.22u w=1.5u l=0.28u
X83 t1b.t1 vbp.t10 vdd.t51 vdd.t50 pfet_03v3 ad=2.6p pd=9.3u as=2.6p ps=9.3u w=4u l=2u
X84 a_21350_n100 vco_out.t7 vss.t10 vss.t9 nfet_03v3 ad=1.22p pd=5.22u as=1.22p ps=5.22u w=2u l=0.28u
X85 vi.t0 vref.t10 vss.t136 vss.t135 nfet_03v3 ad=1.22p pd=5.22u as=1.22p ps=5.22u w=2u l=2u
X86 vfilt vss.t33 cap_nmos_03v3_b c_width=35u c_length=12u
X87 vbt.t6 vbp.t5 vdd.t88 vdd.t87 pfet_03v3 ad=2.6p pd=9.3u as=2.6p ps=9.3u w=4u l=2u
X88 vdd.t73 pll_en.t3 nb.t5 vdd.t11 pfet_03v3 ad=1.3p pd=5.3u as=0.52p ps=2.52u w=2u l=0.28u
X89 vfilt vss.t23 cap_nmos_03v3_b c_width=35u c_length=12u
X90 a_17668_0.t1 vbn_vco.t6 vss.t50 vss.t49 nfet_03v3 ad=0.52p pd=2.52u as=1.22p ps=5.22u w=2u l=0.5u
X91 a_16980_1350.t1 r5.t10 r1.t3 vdd.t15 pfet_03v3 ad=1.95p pd=7.3u as=0.78p ps=3.52u w=3u l=0.28u
X92 dn_s.t3 vcp_n.t14 vss.t157 vss.t156 nfet_03v3 ad=6.1p pd=21.22u as=6.1p ps=21.22u w=10u l=2u
X93 a_10800_18476 a_11400_11024 vss.t0 ppolyf_u r_width=1u r_length=36.6u
X94 va.t0 en_b.t4 vss.t53 vss.t52 nfet_03v3 ad=0.61p pd=3.22u as=0.61p ps=3.22u w=1u l=0.28u
X95 vbt.t1 vbp.t17 vdd.t43 vdd.t42 pfet_03v3 ad=2.6p pd=9.3u as=2.6p ps=9.3u w=4u l=2u
X96 vss.t22 vbn_vco.t9 a_16300_0.t0 vss.t21 nfet_03v3 ad=1.22p pd=5.22u as=0.52p ps=2.52u w=2u l=0.5u
X97 va.t2 vbp.t11 vdd.t63 vdd.t62 pfet_03v3 ad=2.6p pd=9.3u as=2.6p ps=9.3u w=4u l=2u
X98 vcl.t3 vref.t11 vss.t92 vss.t91 nfet_03v3 ad=6.1p pd=21.22u as=6.1p ps=21.22u w=10u l=2u
X99 en_b.t0 pll_en.t8 vdd.t83 vdd.t82 pfet_03v3 ad=1.3p pd=5.3u as=1.3p ps=5.3u w=2u l=0.28u
X100 dqn.t1 dy.t3 vdd.t101 vdd.t11 pfet_03v3 ad=1.3p pd=5.3u as=1.3p ps=5.3u w=2u l=0.28u
X101 dn_s.t2 vcp_n.t13 vss.t138 vss.t137 nfet_03v3 ad=6.1p pd=21.22u as=6.1p ps=21.22u w=10u l=2u
X102 a_16300_0.t1 r3.t4 r4.t0 vss.t128 nfet_03v3 ad=0.915p pd=4.22u as=0.39p ps=2.02u w=1.5u l=0.28u
X103 r1.t0 r5.t11 a_16980_1350.t0 vdd.t15 pfet_03v3 ad=0.78p pd=3.52u as=1.95p ps=7.3u w=3u l=0.28u
X104 vi.t4 vctrl.t4 vs.t1 vss.t177 nfet_03v3 ad=3.05p pd=11.22u as=3.05p ps=11.22u w=5u l=1u
X105 t2.t0 vbp.t9 vdd.t27 vdd.t26 pfet_03v3 ad=2.6p pd=9.3u as=2.6p ps=9.3u w=4u l=2u
X106 a_15612_1350.t1 r1.t6 r2.t3 vdd.t15 pfet_03v3 ad=1.95p pd=7.3u as=0.78p ps=3.52u w=3u l=0.28u
X107 vst.t1 vref.t4 vss.t80 vss.t79 nfet_03v3 ad=3.05p pd=11.22u as=3.05p ps=11.22u w=5u l=1u
X108 r4.t1 r3.t5 a_16300_0.t2 vss.t139 nfet_03v3 ad=0.39p pd=2.02u as=0.915p ps=4.22u w=1.5u l=0.28u
X109 va.t1 vref.t7 vss.t123 vss.t122 nfet_03v3 ad=1.22p pd=5.22u as=1.22p ps=5.22u w=2u l=2u
X110 a_6600_17156 a_7200_11024 vss.t152 ppolyf_u r_width=1u r_length=30u
X111 vss.t115 vbn_vco.t13 a_14932_0.t3 vss.t114 nfet_03v3 ad=1.22p pd=5.22u as=0.52p ps=2.52u w=2u l=0.5u
X112 a_16984_0.t3 r5.t6 r1.t2 vss.t127 nfet_03v3 ad=0.915p pd=4.22u as=0.39p ps=2.02u w=1.5u l=0.28u
X113 vcp_n.t8 vbp.t16 vdd.t61 vdd.t60 pfet_03v3 ad=2.6p pd=9.3u as=2.6p ps=9.3u w=4u l=2u
X114 vbp.t4 pll_en.t9 vdd.t81 vdd.t80 pfet_03v3 ad=0.65p pd=3.3u as=0.65p ps=3.3u w=1u l=0.28u
X115 vdd.t16 nb.t8 vco_out.t2 vdd.t15 pfet_03v3 ad=1.95p pd=7.3u as=0.78p ps=3.52u w=3u l=0.28u
X116 vdd.t34 r5.t8 nb.t1 vdd.t11 pfet_03v3 ad=1.3p pd=5.3u as=0.52p ps=2.52u w=2u l=0.28u
X117 vdd.t85 vbp_vco.t15 a_14928_1350.t2 vdd.t21 pfet_03v3 ad=3.25p pd=11.3u as=1.3p ps=5.52u w=5u l=0.5u
X118 vctrl.t11 vss.t173 cap_nmos_03v3_b c_width=43u c_length=12u
X119 vfilt vss.t43 cap_nmos_03v3_b c_width=35u c_length=12u
X120 vcp_n.t9 cp_trim1.t1 t2.t1 vss.t147 nfet_03v3 ad=1.22p pd=5.22u as=1.22p ps=5.22u w=2u l=0.28u
X121 vbl.t6 vctrl.t8 vbt.t10 vdd.t97 pfet_03v3 ad=3.25p pd=11.3u as=3.25p ps=11.3u w=5u l=1u
X122 a_15616_0.t2 vbn_vco.t12 vss.t113 vss.t112 nfet_03v3 ad=0.52p pd=2.52u as=1.22p ps=5.22u w=2u l=0.5u
X123 r1.t1 r5.t7 a_16984_0.t1 vss.t105 nfet_03v3 ad=0.39p pd=2.02u as=0.915p ps=4.22u w=1.5u l=0.28u
X124 vbn_vco.t4 vbn_vco.t3 vss.t117 vss.t116 nfet_03v3 ad=2.44p pd=9.22u as=2.44p ps=9.22u w=4u l=0.5u
X125 vst.t0 en_b.t6 vdd.t18 vdd.t17 pfet_03v3 ad=0.325p pd=2.3u as=0.325p ps=2.3u w=0.5u l=10u
X126 up_b.t1 pfd_up.t2 vss.t86 vss.t85 nfet_03v3 ad=0.61p pd=3.22u as=0.61p ps=3.22u w=1u l=0.28u
X127 vctrl.t2 a_400_11024 vss.t95 ppolyf_u r_width=2u r_length=37.5u
X128 a_13200_18476 a_12600_11024 vss.t58 ppolyf_u r_width=1u r_length=36.6u
X129 vs.t0 a_4200_11024 vss.t111 ppolyf_u r_width=1u r_length=17.5u
X130 a_16980_1350.t3 vbp_vco.t10 vdd.t49 vdd.t21 pfet_03v3 ad=1.3p pd=5.52u as=3.25p ps=11.3u w=5u l=0.5u
X131 vfilt vss.t35 cap_nmos_03v3_b c_width=35u c_length=12u
X132 vcp_n.t6 en_b.t7 vss.t168 vss.t167 nfet_03v3 ad=0.61p pd=3.22u as=0.61p ps=3.22u w=1u l=0.28u
X133 dqn.t0 vco_out.t6 a_22044_n100.t0 vss.t8 nfet_03v3 ad=1.22p pd=5.22u as=1.22p ps=5.22u w=2u l=0.28u
X134 r5.t1 r4.t7 a_17664_1350.t0 vdd.t15 pfet_03v3 ad=0.78p pd=3.52u as=1.95p ps=7.3u w=3u l=0.28u
X135 vfilt vss.t25 cap_nmos_03v3_b c_width=35u c_length=12u
X136 vbn_vco.t1 vbp_vco.t18 vdd.t3 vdd.t2 pfet_03v3 ad=3.25p pd=11.3u as=3.25p ps=11.3u w=5u l=0.5u
X137 a_1200_18656 a_400_11024 vss.t108 ppolyf_u r_width=2u r_length=37.5u
X138 bias_ref.t0 a_10200_11024 vss.t1 ppolyf_u r_width=1u r_length=36.6u
X139 a_17668_0.t2 r4.t4 r5.t3 vss.t103 nfet_03v3 ad=0.915p pd=4.22u as=0.39p ps=2.02u w=1.5u l=0.28u
X140 dqb.t0 dqn.t5 vdd.t102 vdd.t11 pfet_03v3 ad=1.3p pd=5.3u as=1.3p ps=5.3u w=2u l=0.28u
X141 bias_ref.t1 a_8400_11024 vss.t84 ppolyf_u r_width=1u r_length=30u
X142 r3.t3 r2.t7 a_14928_1350.t0 vdd.t15 pfet_03v3 ad=0.78p pd=3.52u as=1.95p ps=7.3u w=3u l=0.28u
X143 vbp_vco.t4 pll_en.t7 vdd.t79 vdd.t78 pfet_03v3 ad=0.65p pd=3.3u as=0.65p ps=3.3u w=1u l=0.28u
X144 vbp_vco.t6 pll_en.t5 vi.t2 vss.t162 nfet_03v3 ad=3.05p pd=11.22u as=3.05p ps=11.22u w=5u l=0.28u
X145 vfilt vss.t31 cap_nmos_03v3_b c_width=35u c_length=12u
X146 vfilt vss.t41 cap_nmos_03v3_b c_width=35u c_length=12u
X147 vcp_n.t11 vbp.t8 vdd.t90 vdd.t89 pfet_03v3 ad=2.6p pd=9.3u as=2.6p ps=9.3u w=4u l=2u
X148 dn_b.t0 pfd_dn.t0 vdd.t10 vdd.t9 pfet_03v3 ad=1.3p pd=5.3u as=1.3p ps=5.3u w=2u l=0.28u
X149 vdump.t14 vdump.t13 vbt.t3 vdd.t44 pfet_03v3 ad=3.25p pd=11.3u as=3.25p ps=11.3u w=5u l=1u
X150 vss.t83 dqb.t2 vco_div2.t0 vss.t82 nfet_03v3 ad=0.915p pd=4.22u as=0.39p ps=2.02u w=1.5u l=0.28u
X151 vbl.t3 vbl.t2 vss.t48 vss.t47 nfet_03v3 ad=1.22p pd=5.22u as=1.22p ps=5.22u w=2u l=2u
X152 vst.t3 vref.t3 vss.t143 vss.t142 nfet_03v3 ad=3.05p pd=11.22u as=3.05p ps=11.22u w=5u l=1u
X153 vref.t2 a_6000_11024 vss.t146 ppolyf_u r_width=1u r_length=30u
X154 a_14400_18476 a_15000_11024 vss.t81 ppolyf_u r_width=1u r_length=36.6u
X155 nb.t4 pll_en.t4 vdd.t84 vdd.t11 pfet_03v3 ad=0.52p pd=2.52u as=1.3p ps=5.3u w=2u l=0.28u
X156 a_17664_1350.t3 vbp_vco.t8 vdd.t23 vdd.t21 pfet_03v3 ad=1.3p pd=5.52u as=3.25p ps=11.3u w=5u l=0.5u
X157 nb.t3 r5.t5 a_18352_n100.t1 vss.t126 nfet_03v3 ad=0.52p pd=2.52u as=1.22p ps=5.22u w=2u l=0.28u
X158 vdump.t3 vbh.t7 vdd.t57 vdd.t56 pfet_03v3 ad=2.6p pd=9.3u as=2.6p ps=9.3u w=4u l=2u
X159 vss.t107 vbn_vco.t7 a_16984_0.t2 vss.t106 nfet_03v3 ad=1.22p pd=5.22u as=0.52p ps=2.52u w=2u l=0.5u
X160 vnt.t4 vref.t6 vss.t141 vss.t140 nfet_03v3 ad=1.22p pd=5.22u as=1.22p ps=5.22u w=2u l=2u
X161 dy.t1 dx.t2 a_21350_n100.t0 vss.t179 nfet_03v3 ad=1.22p pd=5.22u as=1.22p ps=5.22u w=2u l=0.28u
X162 vbp_vco.t1 vbp_vco.t0 vdd.t29 vdd.t28 pfet_03v3 ad=3.25p pd=11.3u as=3.25p ps=11.3u w=5u l=0.5u
X163 vcp_p.t2 pll_en.t10 vdd.t77 vdd.t76 pfet_03v3 ad=0.65p pd=3.3u as=0.65p ps=3.3u w=1u l=0.28u
X164 a_14928_1350.t3 vbp_vco.t16 vdd.t86 vdd.t21 pfet_03v3 ad=1.3p pd=5.52u as=3.25p ps=11.3u w=5u l=0.5u
X165 vst.t2 en_b.t5 vss.t125 vss.t124 nfet_03v3 ad=0.61p pd=3.22u as=0.61p ps=3.22u w=1u l=0.28u
X166 vdump.t8 vdump.t7 vnt.t5 vss.t151 nfet_03v3 ad=3.05p pd=11.22u as=3.05p ps=11.22u w=5u l=1u
X167 a_12000_18476 a_11400_11024 vss.t60 ppolyf_u r_width=1u r_length=36.6u
X168 vbp_vco.t3 vbp_vco.t2 vdd.t72 vdd.t71 pfet_03v3 ad=3.25p pd=11.3u as=3.25p ps=11.3u w=5u l=0.5u
X169 r2.t2 r1.t7 a_15612_1350.t0 vdd.t15 pfet_03v3 ad=0.78p pd=3.52u as=1.95p ps=7.3u w=3u l=0.28u
X170 a_1200_18656 a_2000_11024 vss.t100 ppolyf_u r_width=2u r_length=37.5u
X171 vdump.t16 vdump.t15 vbt.t5 vdd.t25 pfet_03v3 ad=3.25p pd=11.3u as=3.25p ps=11.3u w=5u l=1u
X172 vco_out.t4 nb.t9 vdd.t52 vdd.t15 pfet_03v3 ad=0.78p pd=3.52u as=1.95p ps=7.3u w=3u l=0.28u
X173 nb.t2 r5.t9 vdd.t38 vdd.t11 pfet_03v3 ad=0.52p pd=2.52u as=1.3p ps=5.3u w=2u l=0.28u
X174 a_14932_0.t1 r2.t4 r3.t0 vss.t72 nfet_03v3 ad=0.915p pd=4.22u as=0.39p ps=2.02u w=1.5u l=0.28u
X175 vcp_p.t1 vcp_n.t12 vss.t145 vss.t144 nfet_03v3 ad=6.1p pd=21.22u as=6.1p ps=21.22u w=10u l=2u
X176 a_16300_0.t3 vbn_vco.t10 vss.t170 vss.t169 nfet_03v3 ad=0.52p pd=2.52u as=1.22p ps=5.22u w=2u l=0.5u
X177 vdump.t2 pfd_up.t0 up_s.t2 vdd.t32 pfet_03v3 ad=2.6p pd=9.3u as=2.6p ps=9.3u w=4u l=0.5u
X178 vdd.t66 vbp_vco.t11 a_16296_1350.t0 vdd.t21 pfet_03v3 ad=3.25p pd=11.3u as=1.3p ps=5.52u w=5u l=0.5u
X179 vdump.t1 vbl.t8 vss.t154 vss.t153 nfet_03v3 ad=1.22p pd=5.22u as=1.22p ps=5.22u w=2u l=2u
X180 vdump.t4 vbh.t6 vdd.t100 vdd.t99 pfet_03v3 ad=2.6p pd=9.3u as=2.6p ps=9.3u w=4u l=2u
X181 vbn_vco.t2 en_b.t2 vss.t14 vss.t13 nfet_03v3 ad=0.61p pd=3.22u as=0.61p ps=3.22u w=1u l=0.28u
X182 a_14932_0.t0 vbn_vco.t14 vss.t62 vss.t61 nfet_03v3 ad=0.52p pd=2.52u as=1.22p ps=5.22u w=2u l=0.5u
X183 a_15612_1350.t3 vbp_vco.t14 vdd.t59 vdd.t21 pfet_03v3 ad=1.3p pd=5.52u as=3.25p ps=11.3u w=5u l=0.5u
X184 vdump.t10 vdump.t9 vnt.t0 vss.t15 nfet_03v3 ad=3.05p pd=11.22u as=3.05p ps=11.22u w=5u l=1u
X185 vcp_n.t10 cp_trim1.t0 t1c.t1 vss.t148 nfet_03v3 ad=1.22p pd=5.22u as=1.22p ps=5.22u w=2u l=0.28u
X186 vss.t172 vbn_vco.t11 a_15616_0.t3 vss.t171 nfet_03v3 ad=1.22p pd=5.22u as=0.52p ps=2.52u w=2u l=0.5u
X187 vbh.t1 vbh.t0 vdd.t41 vdd.t40 pfet_03v3 ad=2.6p pd=9.3u as=2.6p ps=9.3u w=4u l=2u
X188 dy.t0 vco_out.t8 vdd.t12 vdd.t11 pfet_03v3 ad=1.3p pd=5.3u as=1.3p ps=5.3u w=2u l=0.28u
X189 vbh.t4 vctrl.t6 vnt.t6 vss.t175 nfet_03v3 ad=3.05p pd=11.22u as=3.05p ps=11.22u w=5u l=1u
X190 a_22044_n100.t1 dy.t2 vss.t102 vss.t101 nfet_03v3 ad=1.22p pd=5.22u as=1.22p ps=5.22u w=2u l=0.28u
X191 vcp_n.t3 vcp_n.t2 vss.t150 vss.t149 nfet_03v3 ad=6.1p pd=21.22u as=6.1p ps=21.22u w=10u l=2u
X192 vi.t3 vctrl.t3 vs.t2 vss.t178 nfet_03v3 ad=3.05p pd=11.22u as=3.05p ps=11.22u w=5u l=1u
X193 vdd.t39 dqb.t4 vco_div2.t1 vdd.t15 pfet_03v3 ad=1.95p pd=7.3u as=0.78p ps=3.52u w=3u l=0.28u
X194 a_18352_n100.t2 pll_en.t1 vss.t164 vss.t163 nfet_03v3 ad=0.52p pd=2.52u as=1.22p ps=5.22u w=2u l=0.28u
R0 vco_div2 vco_div2.n2 9.7235
R1 vco_div2.n2 vco_div2.n1 8.19066
R2 vco_div2.n1 vco_div2.t3 1.0925
R3 vco_div2.n1 vco_div2.t0 1.0925
R4 vco_div2.n2 vco_div2.n0 7.10634
R5 vco_div2.n0 vco_div2.t2 0.607167
R6 vco_div2.n0 vco_div2.t1 0.607167
R7 bias_ref bias_ref.n0 37.1795
R8 bias_ref.n0 bias_ref.t0 20.1588
R9 bias_ref.n0 bias_ref.t1 22.9937
R10 pll_en pll_en.n0 7.4675
R11 pll_en.n4 pll_en.n3 4.5005
R12 pll_en.n4 pll_en.n10 10.184
R13 pll_en.n0 pll_en.n4 4.6145
R14 pll_en.n8 pll_en.n7 4.5005
R15 pll_en.n10 pll_en.n8 3.6275
R16 pll_en.n10 pll_en.n9 8.4965
R17 pll_en.n9 pll_en.t5 95.5714
R18 pll_en.n9 pll_en.t6 94.4689
R19 pll_en.n6 pll_en.n5 1.121
R20 pll_en.n7 pll_en.n6 5.531
R21 pll_en.n7 pll_en.t7 46.2098
R22 pll_en.n6 pll_en.t8 56.073
R23 pll_en.n5 pll_en.t9 43.2623
R24 pll_en.n5 pll_en.t10 43.8878
R25 pll_en.n8 pll_en.t11 71.4568
R26 pll_en.n3 pll_en.n2 5.53503
R27 pll_en.n2 pll_en.t0 45.7328
R28 pll_en.n2 pll_en.t1 45.5434
R29 pll_en.n3 pll_en.n1 4.94576
R30 pll_en.n1 pll_en.t3 45.7328
R31 pll_en.n1 pll_en.t4 45.5434
R32 pll_en.n0 pll_en.t2 35.435
R33 pfd_up.n0 pfd_up.n1 7.5875
R34 pfd_up pfd_up.n0 11.138
R35 pfd_up.n1 pfd_up.t2 70.0393
R36 pfd_up.n0 pfd_up.t0 55.5402
R37 pfd_up.n1 pfd_up.t1 57.2205
R38 cp_trim1 cp_trim1.n0 20.5475
R39 cp_trim1.n0 cp_trim1.t0 58.2418
R40 cp_trim1.n0 cp_trim1.t1 59.4568
R41 cp_trim0 cp_trim0.n0 21.155
R42 cp_trim0.n0 cp_trim0.t0 57.7018
R43 cp_trim0.n0 cp_trim0.t1 58.9168
R44 pfd_dn.n0 pfd_dn.n1 24.8067
R45 pfd_dn pfd_dn.n0 18.167
R46 pfd_dn.n1 pfd_dn.t1 45.1386
R47 pfd_dn.n1 pfd_dn.t2 47.1975
R48 pfd_dn.n0 pfd_dn.t0 56.973
R49 vctrl.n4 vctrl.n3 4.5005
R50 vctrl.n10 vctrl.n9 4.5005
R51 vctrl vctrl.n10 18.2075
R52 vctrl.n10 vctrl.n4 3.6275
R53 vctrl.n4 vctrl.n6 10.823
R54 vctrl.n6 vctrl.n5 4.60625
R55 vctrl.n9 vctrl.n7 3.686
R56 vctrl.n9 vctrl.n8 16.8395
R57 vctrl.n8 vctrl.t3 40.7877
R58 vctrl.n8 vctrl.t4 40.0182
R59 vctrl.n7 vctrl.t5 40.0182
R60 vctrl.n7 vctrl.t6 42.3267
R61 vctrl.n6 vctrl.t2 24.3534
R62 vctrl.n5 vctrl.t1 20.2391
R63 vctrl.n5 vctrl.t11 61.6502
R64 vctrl.n1 vctrl.n0 1.283
R65 vctrl.n3 vctrl.n1 2.336
R66 vctrl.n3 vctrl.n2 0.0275
R67 vctrl.n2 vctrl.t0 24.6622
R68 vctrl.n2 vctrl.t7 40.1274
R69 vctrl.n1 vctrl.t8 40.1274
R70 vctrl.n0 vctrl.t9 40.1274
R71 vctrl.n0 vctrl.t10 42.4899
R72 vdd.n89 vdd.n88 4.5005
R73 vdd vdd.n89 21.2945
R74 vdd.n89 vdd.n28 28.0558
R75 vdd.n30 vdd.n29 3.6455
R76 vdd.n31 vdd.n30 0.43475
R77 vdd.n32 vdd.n31 1.013
R78 vdd.n33 vdd.n32 1.013
R79 vdd.n34 vdd.n33 1.07375
R80 vdd.n35 vdd.n34 0.43475
R81 vdd.n36 vdd.n35 1.013
R82 vdd.n37 vdd.n36 0.626
R83 vdd.n88 vdd.n37 0.22325
R84 vdd.n88 vdd.n38 0.40325
R85 vdd.n38 vdd.n39 0.626
R86 vdd.n39 vdd.n40 0.68675
R87 vdd.n40 vdd.n41 0.43475
R88 vdd.n41 vdd.n42 0.626
R89 vdd.n42 vdd.n56 0.28625
R90 vdd.n56 vdd.n43 2.588
R91 vdd.n43 vdd.n44 1.78475
R92 vdd.n44 vdd.n45 0.6755
R93 vdd.n45 vdd.n46 0.6755
R94 vdd.n46 vdd.n47 0.73625
R95 vdd.n47 vdd.n48 0.43475
R96 vdd.n48 vdd.n49 0.6755
R97 vdd.n56 vdd.n57 23.9203
R98 vdd.n57 vdd.n64 0.344
R99 vdd.n64 vdd.n65 0.3545
R100 vdd.n65 vdd.n66 0.1595
R101 vdd.n66 vdd.n59 0.344
R102 vdd.n59 vdd.n67 0.011
R103 vdd.n67 vdd.n68 0.1595
R104 vdd.n68 vdd.n69 0.3545
R105 vdd.n69 vdd.n70 0.1595
R106 vdd.n70 vdd.n71 0.3545
R107 vdd.n71 vdd.n72 0.1595
R108 vdd.n72 vdd.n60 0.005
R109 vdd.n60 vdd.n73 0.35
R110 vdd.n73 vdd.n74 0.1595
R111 vdd.n74 vdd.n75 0.2885
R112 vdd.n75 vdd.n76 0.1595
R113 vdd.n76 vdd.n61 0.245
R114 vdd.n61 vdd.n77 0.044
R115 vdd.n77 vdd.n78 0.1595
R116 vdd.n78 vdd.n79 0.2885
R117 vdd.n79 vdd.n80 0.1595
R118 vdd.n80 vdd.n81 0.2885
R119 vdd.n81 vdd.n82 0.1595
R120 vdd.n82 vdd.n62 0.104
R121 vdd.n62 vdd.n83 0.551
R122 vdd.n83 vdd.n84 0.3275
R123 vdd.n84 vdd.n63 0.323
R124 vdd.n63 vdd.n85 0.005
R125 vdd.n85 vdd.n86 0.3275
R126 vdd.n86 vdd.n87 0.3275
R127 vdd.n87 vdd.t39 4.86639
R128 vdd.n87 vdd.t45 4.57839
R129 vdd.n86 vdd.t102 5.88015
R130 vdd.n85 vdd.t101 5.88015
R131 vdd.n84 vdd.t75 13.9344
R132 vdd.n83 vdd.t12 5.88015
R133 vdd.n82 vdd.t68 5.88015
R134 vdd.n81 vdd.t16 4.57839
R135 vdd.n80 vdd.t52 4.57839
R136 vdd.n79 vdd.t53 4.57839
R137 vdd.n78 vdd.t33 4.57839
R138 vdd.n77 vdd.t73 5.88015
R139 vdd.n76 vdd.t84 5.88015
R140 vdd.n75 vdd.t34 5.88015
R141 vdd.n74 vdd.t38 5.88015
R142 vdd.n73 vdd.t22 2.01891
R143 vdd.n72 vdd.t23 2.01891
R144 vdd.n71 vdd.t48 2.01891
R145 vdd.n70 vdd.t49 2.01891
R146 vdd.n69 vdd.t66 2.01891
R147 vdd.n68 vdd.t67 2.01891
R148 vdd.n67 vdd.t58 2.01891
R149 vdd.n66 vdd.t59 2.01891
R150 vdd.n65 vdd.t85 2.01891
R151 vdd.n64 vdd.t86 2.01891
R152 vdd.n57 vdd.n58 12.6005
R153 vdd.n58 vdd.n59 12.6005
R154 vdd.n58 vdd.n60 12.6005
R155 vdd.n58 vdd.n61 12.6005
R156 vdd.n58 vdd.n62 12.6005
R157 vdd.n58 vdd.n63 12.6005
R158 vdd.t11 vdd.t74 14.9885
R159 vdd.t15 vdd.t11 9.99251
R160 vdd.t21 vdd.t15 143.886
R161 vdd.n58 vdd.t21 83.9334
R162 vdd.n29 vdd.t95 438.584
R163 vdd.t95 vdd.t24 505.781
R164 vdd.t24 vdd.t44 505.781
R165 vdd.t96 vdd.t44 505.781
R166 vdd.n50 vdd.t96 411.851
R167 vdd.n50 vdd.t97 411.851
R168 vdd.t97 vdd.t35 505.781
R169 vdd.t35 vdd.t25 505.781
R170 vdd.t98 vdd.t25 505.781
R171 vdd.n51 vdd.t98 411.851
R172 vdd.n51 vdd.t40 484.104
R173 vdd.t40 vdd.t56 650.289
R174 vdd.t99 vdd.t56 650.289
R175 vdd.n52 vdd.t99 484.104
R176 vdd.n52 vdd.t64 484.104
R177 vdd.t64 vdd.t30 526.013
R178 vdd.t30 vdd.t9 401.735
R179 vdd.t76 vdd.t9 401.735
R180 vdd.t80 vdd.t76 401.735
R181 vdd.n53 vdd.t80 359.827
R182 vdd.n53 vdd.t82 359.827
R183 vdd.t82 vdd.t17 1104.05
R184 vdd.n54 vdd.t17 1062.14
R185 vdd.n54 vdd.t8 375.724
R186 vdd.t8 vdd.t32 433.526
R187 vdd.t32 vdd.t28 433.526
R188 vdd.t28 vdd.t2 433.526
R189 vdd.t0 vdd.t2 433.526
R190 vdd.n55 vdd.t0 375.724
R191 vdd.n55 vdd.t71 375.724
R192 vdd.t71 vdd.t78 417.63
R193 vdd.n49 vdd.t78 383.603
R194 vdd.n47 vdd.n55 23.09
R195 vdd.n43 vdd.n54 23.09
R196 vdd.n40 vdd.n53 23.09
R197 vdd.n34 vdd.n52 23.09
R198 vdd.n30 vdd.n51 23.09
R199 vdd.n29 vdd.n50 23.09
R200 vdd.n49 vdd.t79 18.6345
R201 vdd.n48 vdd.t72 11.2274
R202 vdd.n46 vdd.t1 11.2274
R203 vdd.n45 vdd.t3 11.2274
R204 vdd.n44 vdd.t29 11.2274
R205 vdd.n42 vdd.t18 21.6308
R206 vdd.n41 vdd.t83 13.5844
R207 vdd.n39 vdd.t81 18.6345
R208 vdd.n38 vdd.t77 18.6345
R209 vdd.n37 vdd.t10 13.5844
R210 vdd.n36 vdd.t31 13.5844
R211 vdd.n35 vdd.t65 11.646
R212 vdd.n33 vdd.t100 11.646
R213 vdd.n32 vdd.t57 11.646
R214 vdd.n31 vdd.t41 11.646
R215 vdd.n1 vdd.n0 1.013
R216 vdd.n2 vdd.n1 1.013
R217 vdd.n3 vdd.n2 1.07375
R218 vdd.n4 vdd.n3 0.43475
R219 vdd.n5 vdd.n4 1.013
R220 vdd.n6 vdd.n5 1.013
R221 vdd.n7 vdd.n6 1.07375
R222 vdd.n8 vdd.n7 0.43475
R223 vdd.n9 vdd.n8 1.013
R224 vdd.n10 vdd.n9 1.013
R225 vdd.n11 vdd.n10 1.07375
R226 vdd.n12 vdd.n11 0.43475
R227 vdd.n13 vdd.n12 1.013
R228 vdd.n14 vdd.n13 1.013
R229 vdd.n28 vdd.n14 0.06125
R230 vdd.n28 vdd.n15 1.013
R231 vdd.n15 vdd.n16 0.43475
R232 vdd.n16 vdd.n17 1.013
R233 vdd.n17 vdd.n18 1.013
R234 vdd.n18 vdd.n19 1.07375
R235 vdd.n19 vdd.n20 0.43475
R236 vdd.n20 vdd.n21 1.013
R237 vdd.n21 vdd.n22 1.013
R238 vdd.n0 vdd.t6 152.468
R239 vdd.t6 vdd.t19 167.162
R240 vdd.t46 vdd.t19 167.162
R241 vdd.n23 vdd.t46 124.444
R242 vdd.n23 vdd.t69 124.444
R243 vdd.t69 vdd.t42 167.162
R244 vdd.t60 vdd.t42 167.162
R245 vdd.n24 vdd.t60 124.444
R246 vdd.n24 vdd.t93 124.444
R247 vdd.t93 vdd.t54 167.162
R248 vdd.t91 vdd.t54 167.162
R249 vdd.n25 vdd.t91 124.444
R250 vdd.n25 vdd.t36 124.444
R251 vdd.t36 vdd.t103 167.162
R252 vdd.t62 vdd.t103 167.162
R253 vdd.n26 vdd.t62 124.444
R254 vdd.n26 vdd.t50 124.444
R255 vdd.t50 vdd.t26 167.162
R256 vdd.t26 vdd.t89 167.162
R257 vdd.n27 vdd.t89 124.444
R258 vdd.n27 vdd.t4 124.444
R259 vdd.t4 vdd.t13 167.162
R260 vdd.t13 vdd.t87 167.162
R261 vdd.n22 vdd.t87 153.107
R262 vdd.n19 vdd.n27 27.59
R263 vdd.n15 vdd.n26 27.59
R264 vdd.n11 vdd.n25 27.59
R265 vdd.n7 vdd.n24 27.59
R266 vdd.n3 vdd.n23 27.59
R267 vdd.n22 vdd.t88 16.146
R268 vdd.n21 vdd.t14 16.146
R269 vdd.n20 vdd.t5 16.146
R270 vdd.n18 vdd.t90 16.146
R271 vdd.n17 vdd.t27 16.146
R272 vdd.n16 vdd.t51 16.146
R273 vdd.n14 vdd.t63 16.146
R274 vdd.n13 vdd.t104 16.146
R275 vdd.n12 vdd.t37 16.146
R276 vdd.n10 vdd.t92 16.146
R277 vdd.n9 vdd.t55 16.146
R278 vdd.n8 vdd.t94 16.146
R279 vdd.n6 vdd.t61 16.146
R280 vdd.n5 vdd.t43 16.146
R281 vdd.n4 vdd.t70 12.6482
R282 vdd.n2 vdd.t47 12.6482
R283 vdd.n1 vdd.t20 12.6482
R284 vdd.n0 vdd.t7 12.6482
R285 vss.n72 vss.n71 4.5005
R286 vss.n74 vss.n73 4.5005
R287 vss.n76 vss.n75 4.5005
R288 vss.n188 vss.n187 4.5005
R289 vss vss.n188 17.6675
R290 vss.n188 vss.n76 14.81
R291 vss.n76 vss.n74 4.06625
R292 vss.n74 vss.n72 18.7059
R293 vss.n72 vss.n32 15.6189
R294 vss.n78 vss.n77 0.43025
R295 vss.n79 vss.n78 0.995
R296 vss.n80 vss.n79 0.995
R297 vss.n81 vss.n80 1.06025
R298 vss.n82 vss.n81 0.43025
R299 vss.n83 vss.n82 0.995
R300 vss.n84 vss.n83 0.995
R301 vss.n85 vss.n84 1.06025
R302 vss.n86 vss.n85 0.43025
R303 vss.n87 vss.n86 0.995
R304 vss.n187 vss.n87 0.08375
R305 vss.n187 vss.n88 0.91175
R306 vss.n88 vss.n89 1.06025
R307 vss.n89 vss.n90 0.43025
R308 vss.n90 vss.n102 1.55975
R309 vss.n102 vss.n91 0.20525
R310 vss.n91 vss.n92 0.77
R311 vss.n92 vss.n93 0.83525
R312 vss.n93 vss.n94 0.43025
R313 vss.n94 vss.n95 1.445
R314 vss.n95 vss.n96 0.608
R315 vss.n96 vss.n97 0.608
R316 vss.n97 vss.n98 0.67325
R317 vss.n98 vss.n99 0.43025
R318 vss.n99 vss.n100 0.6575
R319 vss.n100 vss.n101 2.81975
R320 vss.n104 vss.n103 10.4005
R321 vss.n106 vss.n105 10.4005
R322 vss.n108 vss.n107 10.4005
R323 vss.n110 vss.n109 10.4005
R324 vss.n112 vss.n111 10.4005
R325 vss.n167 vss.n166 10.4005
R326 vss.n102 vss.n104 26.252
R327 vss.n104 vss.n186 0.344
R328 vss.n186 vss.n185 0.3485
R329 vss.n185 vss.n184 0.1655
R330 vss.n184 vss.n106 0.344
R331 vss.n106 vss.n183 0.005
R332 vss.n183 vss.n182 0.1655
R333 vss.n182 vss.n181 0.3485
R334 vss.n181 vss.n180 0.1655
R335 vss.n180 vss.n179 0.3485
R336 vss.n179 vss.n178 0.1655
R337 vss.n178 vss.n108 0.005
R338 vss.n108 vss.n177 0.344
R339 vss.n177 vss.n176 0.6125
R340 vss.n176 vss.n110 0.245
R341 vss.n110 vss.n175 0.038
R342 vss.n175 vss.n174 0.1655
R343 vss.n174 vss.n173 0.2825
R344 vss.n173 vss.n172 0.6125
R345 vss.n172 vss.n112 0.104
R346 vss.n112 vss.n171 0.224
R347 vss.n171 vss.n167 0.977
R348 vss.n167 vss.n170 0.005
R349 vss.n170 vss.n169 0.3275
R350 vss.n169 vss.n168 0.3275
R351 vss.n186 vss.t62 3.85787
R352 vss.n185 vss.t115 3.85787
R353 vss.n184 vss.t113 3.85787
R354 vss.n183 vss.t172 3.85787
R355 vss.n182 vss.t170 3.85787
R356 vss.n181 vss.t22 3.85787
R357 vss.n180 vss.t20 3.85787
R358 vss.n179 vss.t107 3.85787
R359 vss.n178 vss.t50 3.85787
R360 vss.n177 vss.t5 3.85787
R361 vss.n176 vss.t164 4.97103
R362 vss.n175 vss.t166 4.97103
R363 vss.n174 vss.t69 3.59261
R364 vss.n173 vss.t12 3.59261
R365 vss.n172 vss.t181 10.5494
R366 vss.n171 vss.t10 4.97103
R367 vss.n170 vss.t102 4.97103
R368 vss.n169 vss.t121 10.5494
R369 vss.n168 vss.t133 6.50024
R370 vss.n168 vss.t83 6.78224
R371 vss.n103 vss.n161 370.06
R372 vss.n103 vss.t97 616.043
R373 vss.t97 vss.t61 23.9456
R374 vss.t61 vss.t72 150.202
R375 vss.t72 vss.t114 71.8357
R376 vss.t114 vss.t94 498.493
R377 vss.t112 vss.t94 23.9456
R378 vss.t93 vss.t112 150.202
R379 vss.t171 vss.t93 71.8357
R380 vss.n105 vss.t171 134.964
R381 vss.n105 vss.t139 363.531
R382 vss.t139 vss.t169 23.9456
R383 vss.t169 vss.t128 150.202
R384 vss.t128 vss.t21 71.8357
R385 vss.t21 vss.t105 498.493
R386 vss.t19 vss.t105 23.9456
R387 vss.t127 vss.t19 150.202
R388 vss.t106 vss.t127 71.8357
R389 vss.n107 vss.t106 387.476
R390 vss.n107 vss.t104 111.019
R391 vss.t104 vss.t49 23.9456
R392 vss.t49 vss.t103 150.202
R393 vss.t103 vss.t4 71.8357
R394 vss.t4 vss.t126 498.493
R395 vss.t126 vss.t16 174.147
R396 vss.t163 vss.t16 474.548
R397 vss.t165 vss.t163 174.147
R398 vss.n109 vss.t165 63.1284
R399 vss.n109 vss.t68 411.421
R400 vss.t68 vss.t11 174.147
R401 vss.t11 vss.t180 1123.24
R402 vss.n111 vss.t180 32.6529
R403 vss.n111 vss.t9 441.897
R404 vss.t9 vss.t179 474.548
R405 vss.t8 vss.t179 474.548
R406 vss.n166 vss.t8 350.469
R407 vss.n166 vss.t101 124.079
R408 vss.t101 vss.t120 474.548
R409 vss.t120 vss.t132 474.548
R410 vss.t132 vss.t82 174.147
R411 vss.n77 vss.t175 219.07
R412 vss.t175 vss.t151 236.893
R413 vss.t151 vss.t15 236.893
R414 vss.t176 vss.t15 236.893
R415 vss.n162 vss.t176 194.641
R416 vss.n162 vss.t87 229.274
R417 vss.t87 vss.t63 306.159
R418 vss.t153 vss.t63 306.159
R419 vss.n163 vss.t153 229.274
R420 vss.n163 vss.t47 229.274
R421 vss.t47 vss.t135 306.159
R422 vss.t17 vss.t135 306.159
R423 vss.n164 vss.t17 229.274
R424 vss.n164 vss.t129 229.274
R425 vss.t129 vss.t122 306.159
R426 vss.t122 vss.t140 306.159
R427 vss.n165 vss.t140 229.274
R428 vss.n165 vss.t109 229.274
R429 vss.t109 vss.t131 271.526
R430 vss.n161 vss.t131 61.648
R431 vss.n89 vss.n165 20.8562
R432 vss.n85 vss.n164 20.8562
R433 vss.n81 vss.n163 20.8562
R434 vss.n77 vss.n162 20.8562
R435 vss.n161 vss.t79 481.693
R436 vss.t79 vss.t142 651.143
R437 vss.n113 vss.t142 535.004
R438 vss.n113 vss.t77 820.592
R439 vss.t77 vss.t124 868.191
R440 vss.t52 vss.t124 514.061
R441 vss.t89 vss.t52 514.061
R442 vss.n114 vss.t89 466.462
R443 vss.n114 vss.t116 487.406
R444 vss.t116 vss.t13 535.004
R445 vss.t13 vss.t177 582.601
R446 vss.t177 vss.t178 651.143
R447 vss.t161 vss.t178 582.601
R448 vss.n115 vss.t161 466.462
R449 vss.n115 vss.n160 396.017
R450 vss.n160 vss.t162 70.4457
R451 vss.t162 vss.n101 488.421
R452 vss.n124 vss.n116 21.9812
R453 vss.n128 vss.n117 21.9812
R454 vss.n129 vss.n118 21.9812
R455 vss.n135 vss.n119 21.9812
R456 vss.n139 vss.t95 3.46717
R457 vss.n140 vss.t108 3.46717
R458 vss.n141 vss.t100 3.46717
R459 vss.n142 vss.t134 3.46717
R460 vss.n143 vss.t111 10.4005
R461 vss.n144 vss.t96 10.4005
R462 vss.n145 vss.t146 10.4005
R463 vss.n146 vss.t54 10.4005
R464 vss.n147 vss.t152 10.4005
R465 vss.n148 vss.t51 10.4005
R466 vss.n149 vss.t56 10.4005
R467 vss.n150 vss.t84 10.4005
R468 vss.n151 vss.t1 10.4005
R469 vss.n152 vss.t55 10.4005
R470 vss.n153 vss.t0 10.4005
R471 vss.n154 vss.t60 10.4005
R472 vss.n155 vss.t59 10.4005
R473 vss.n156 vss.t58 10.4005
R474 vss.n157 vss.t57 10.4005
R475 vss.n158 vss.t155 10.4005
R476 vss.n159 vss.t81 8.87793
R477 vss.n121 vss.t95 126.885
R478 vss.t95 vss.t98 33.8503
R479 vss.t98 vss.t108 133.31
R480 vss.t108 vss.t118 51.4021
R481 vss.t118 vss.t100 115.758
R482 vss.t100 vss.t156 68.9538
R483 vss.t156 vss.t134 98.2068
R484 vss.t134 vss.n116 40.1188
R485 vss.n116 vss.t137 138.326
R486 vss.t111 vss.t137 93.192
R487 vss.t111 vss.t144 91.5204
R488 vss.t96 vss.t144 33.8503
R489 vss.t96 vss.t149 150.863
R490 vss.t146 vss.t149 99.8783
R491 vss.t146 vss.t65 53.4916
R492 vss.t65 vss.t54 71.8791
R493 vss.t54 vss.n117 35.104
R494 vss.n117 vss.t152 90.2667
R495 vss.t152 vss.t158 16.7165
R496 vss.t158 vss.t51 108.654
R497 vss.t51 vss.t2 8.77638
R498 vss.t2 vss.t147 112.834
R499 vss.t56 vss.t147 3.76159
R500 vss.t56 vss.t3 109.073
R501 vss.t84 vss.t3 16.2986
R502 vss.t84 vss.t148 96.5352
R503 vss.n118 vss.t148 102.385
R504 vss.n118 vss.t1 51.82
R505 vss.t1 vss.t85 50.5663
R506 vss.t85 vss.t55 74.8044
R507 vss.t55 vss.t66 38.0293
R508 vss.t66 vss.t0 87.3414
R509 vss.t0 vss.t167 25.4923
R510 vss.t167 vss.t60 99.8783
R511 vss.t60 vss.t159 12.9554
R512 vss.t159 vss.t59 112.415
R513 vss.t59 vss.t70 36.3577
R514 vss.t70 vss.t58 89.013
R515 vss.t58 vss.n119 49.3126
R516 vss.n119 vss.t57 76.0581
R517 vss.t57 vss.t75 62.2674
R518 vss.t75 vss.t155 63.1032
R519 vss.t155 vss.t73 121.609
R520 vss.t81 vss.t73 3.76159
R521 vss.n159 vss.t6 9.4844
R522 vss.t6 vss.t91 55.5811
R523 vss.t91 vss.n120 138.326
R524 vss.n120 vss.n160 3561.15
R525 vss.n139 vss.n140 0.947868
R526 vss.n140 vss.n141 0.947868
R527 vss.n141 vss.n142 0.947868
R528 vss.n142 vss.n143 1.53997
R529 vss.n143 vss.n144 0.711026
R530 vss.n144 vss.n145 1.42155
R531 vss.n145 vss.n146 0.711026
R532 vss.n146 vss.n147 0.711026
R533 vss.n147 vss.n148 0.711026
R534 vss.n148 vss.n149 0.711026
R535 vss.n149 vss.n150 0.711026
R536 vss.n150 vss.n151 1.42155
R537 vss.n151 vss.n152 0.711026
R538 vss.n152 vss.n153 0.711026
R539 vss.n153 vss.n154 0.711026
R540 vss.n154 vss.n155 0.711026
R541 vss.n155 vss.n156 0.711026
R542 vss.n156 vss.n157 0.711026
R543 vss.n157 vss.n158 0.711026
R544 vss.n158 vss.n159 1.49822
R545 vss.n75 vss.n139 30.7502
R546 vss.n75 vss.t7 25.4912
R547 vss.n138 vss.n120 23.041
R548 vss.n122 vss.n121 0.995
R549 vss.n123 vss.n122 0.995
R550 vss.n124 vss.n123 1.06025
R551 vss.n125 vss.n124 0.43025
R552 vss.n126 vss.n125 0.995
R553 vss.n127 vss.n126 0.995
R554 vss.n128 vss.n127 1.71725
R555 vss.n129 vss.n128 3.5825
R556 vss.n130 vss.n129 0.43025
R557 vss.n73 vss.n130 0.41225
R558 vss.n73 vss.n131 0.19625
R559 vss.n131 vss.n132 0.608
R560 vss.n132 vss.n133 0.608
R561 vss.n133 vss.n134 0.608
R562 vss.n134 vss.n135 1.06025
R563 vss.n135 vss.n136 0.43025
R564 vss.n136 vss.n137 0.995
R565 vss.n137 vss.n138 0.995
R566 vss.n138 vss.t92 11.1876
R567 vss.n137 vss.t74 11.1876
R568 vss.n136 vss.t76 11.1876
R569 vss.n134 vss.t71 11.1876
R570 vss.n133 vss.t160 20.4058
R571 vss.n132 vss.t168 20.4058
R572 vss.n131 vss.t67 20.4058
R573 vss.n130 vss.t86 20.4058
R574 vss.n127 vss.t150 11.1876
R575 vss.n126 vss.t145 11.1876
R576 vss.n125 vss.t138 11.1876
R577 vss.n123 vss.t157 11.1876
R578 vss.n122 vss.t119 11.1876
R579 vss.n121 vss.t99 11.1876
R580 vss.n101 vss.n115 20.8562
R581 vss.n98 vss.n114 20.8562
R582 vss.n93 vss.n113 20.8562
R583 vss.n100 vss.t14 19.2808
R584 vss.n99 vss.t117 11.6644
R585 vss.n97 vss.t90 19.2808
R586 vss.n96 vss.t53 19.2808
R587 vss.n95 vss.t125 19.2808
R588 vss.n94 vss.t78 21.857
R589 vss.n92 vss.t143 11.2319
R590 vss.n91 vss.t80 11.2319
R591 vss.n90 vss.t110 13.7073
R592 vss.n88 vss.t141 13.7073
R593 vss.n87 vss.t123 13.7073
R594 vss.n86 vss.t130 13.7073
R595 vss.n84 vss.t18 13.7073
R596 vss.n83 vss.t136 13.7073
R597 vss.n82 vss.t48 13.7073
R598 vss.n80 vss.t154 13.7073
R599 vss.n79 vss.t64 13.7073
R600 vss.n78 vss.t88 13.7073
R601 vss.n34 vss.n33 3.3485
R602 vss.n35 vss.n34 3.3485
R603 vss.n71 vss.n35 2.13575
R604 vss.n71 vss.n36 1.21325
R605 vss.n36 vss.n37 3.3485
R606 vss.n39 vss.n38 0.0868014
R607 vss.n40 vss.n39 0.0868014
R608 vss.n37 vss.n40 14.3926
R609 vss.n40 vss.n70 4.57882
R610 vss.t45 vss.n70 0.0473
R611 vss.n42 vss.n41 0.0868014
R612 vss.n44 vss.n43 0.0868014
R613 vss.n46 vss.n45 0.0868014
R614 vss.n47 vss.n46 0.0868014
R615 vss.n49 vss.n48 0.0868014
R616 vss.n51 vss.n50 0.0868014
R617 vss.n52 vss.n51 0.0868014
R618 vss.n54 vss.n53 0.0868014
R619 vss.n56 vss.n55 0.0868014
R620 vss.n57 vss.n56 0.0868014
R621 vss.n59 vss.n58 0.0868014
R622 vss.n61 vss.n60 0.0868014
R623 vss.n62 vss.n61 0.0868014
R624 vss.n64 vss.n63 0.0868014
R625 vss.n66 vss.n65 0.0868014
R626 vss.n67 vss.n66 0.0868014
R627 vss.n69 vss.n68 0.0868014
R628 vss.n41 vss.n43 353.161
R629 vss.n43 vss.n45 66.5544
R630 vss.n45 vss.n48 353.075
R631 vss.n48 vss.n50 66.5544
R632 vss.n50 vss.n53 353.075
R633 vss.n53 vss.n55 66.5544
R634 vss.n55 vss.n58 353.075
R635 vss.n58 vss.n60 66.5544
R636 vss.n60 vss.n63 353.075
R637 vss.n63 vss.n65 66.5544
R638 vss.n65 vss.n68 353.075
R639 vss.n68 vss.n38 66.5544
R640 vss.n38 vss.n70 353.161
R641 vss.n69 vss.n67 4.57882
R642 vss.n37 vss.n67 11.0446
R643 vss.t43 vss.n69 0.0473
R644 vss.n66 vss.t43 0.0473
R645 vss.n64 vss.n62 4.57882
R646 vss.n36 vss.n62 11.0446
R647 vss.t41 vss.n64 0.0473
R648 vss.n61 vss.t41 0.0473
R649 vss.n59 vss.n57 4.57882
R650 vss.n35 vss.n57 11.0446
R651 vss.t39 vss.n59 0.0473
R652 vss.n56 vss.t39 0.0473
R653 vss.n54 vss.n52 4.57882
R654 vss.n34 vss.n52 11.0446
R655 vss.t37 vss.n54 0.0473
R656 vss.n51 vss.t37 0.0473
R657 vss.n49 vss.n47 4.57882
R658 vss.n33 vss.n47 11.0446
R659 vss.t35 vss.n49 0.0473
R660 vss.n46 vss.t35 0.0473
R661 vss.n44 vss.n42 4.57882
R662 vss.n33 vss.n42 14.3926
R663 vss.t33 vss.n44 0.0473
R664 vss.n41 vss.t33 0.0473
R665 vss.n39 vss.t45 0.0473
R666 vss.n1 vss.n0 3.3485
R667 vss.n2 vss.n1 3.3485
R668 vss.n32 vss.n2 2.13575
R669 vss.n32 vss.n3 1.21325
R670 vss.n5 vss.n4 0.0697308
R671 vss.n6 vss.n5 0.0697308
R672 vss.n3 vss.n6 14.7418
R673 vss.n6 vss.n31 5.26015
R674 vss.t173 vss.n31 0.038593
R675 vss.n8 vss.n7 0.0868014
R676 vss.n10 vss.n9 0.0868014
R677 vss.n12 vss.n11 0.0868014
R678 vss.n13 vss.n12 0.0868014
R679 vss.n15 vss.n14 0.0868014
R680 vss.n17 vss.n16 0.0868014
R681 vss.n18 vss.n17 0.0868014
R682 vss.n20 vss.n19 0.0868014
R683 vss.n22 vss.n21 0.0868014
R684 vss.n23 vss.n22 0.0868014
R685 vss.n25 vss.n24 0.0868014
R686 vss.n27 vss.n26 0.0868014
R687 vss.n28 vss.n27 0.0868014
R688 vss.n30 vss.n29 0.0868014
R689 vss.n7 vss.n9 288.168
R690 vss.n9 vss.n11 54.3033
R691 vss.n11 vss.n14 288.082
R692 vss.n14 vss.n16 54.3033
R693 vss.n16 vss.n19 288.082
R694 vss.n19 vss.n21 54.3033
R695 vss.n21 vss.n24 288.082
R696 vss.n24 vss.n26 54.3033
R697 vss.n26 vss.n29 288.082
R698 vss.n29 vss.n4 54.3033
R699 vss.n4 vss.n31 288.151
R700 vss.n30 vss.n28 4.57882
R701 vss.n3 vss.n28 12.8446
R702 vss.t31 vss.n30 0.0473
R703 vss.n27 vss.t31 0.0473
R704 vss.n25 vss.n23 4.57882
R705 vss.n2 vss.n23 12.8446
R706 vss.t29 vss.n25 0.0473
R707 vss.n22 vss.t29 0.0473
R708 vss.n20 vss.n18 4.57882
R709 vss.n1 vss.n18 12.8446
R710 vss.t27 vss.n20 0.0473
R711 vss.n17 vss.t27 0.0473
R712 vss.n15 vss.n13 4.57882
R713 vss.n0 vss.n13 12.8446
R714 vss.t25 vss.n15 0.0473
R715 vss.n12 vss.t25 0.0473
R716 vss.n10 vss.n8 4.57882
R717 vss.n0 vss.n8 16.1926
R718 vss.t23 vss.n10 0.0473
R719 vss.n7 vss.t23 0.0473
R720 vss.n5 vss.t173 0.038593
R721 a_22044_n100 a_22044_n100.n0 0.662
R722 a_22044_n100.n0 a_22044_n100.t0 1.2605
R723 a_22044_n100.n0 a_22044_n100.t1 15.6061
R724 a_21350_n100 a_21350_n100.t0 16.3801
R725 a_18352_n100.t2 a_18352_n100.n0 0.8195
R726 a_18352_n100.n0 a_18352_n100.t3 0.8195
R727 a_18352_n100.n1 a_18352_n100.n0 7.26555
R728 a_18352_n100.n2 a_18352_n100.n1 7.22955
R729 a_18352_n100 a_18352_n100.n2 0.662
R730 a_18352_n100.n2 a_18352_n100.t1 1.2605
R731 a_18352_n100.n1 a_18352_n100.t0 8.06655
R732 a_17668_0.n0 a_17668_0.t1 0.8195
R733 a_17668_0.n0 a_17668_0.t0 0.8195
R734 a_17668_0.n2 a_17668_0.n0 7.36905
R735 a_17668_0.n1 a_17668_0.n2 8.17078
R736 a_17668_0 a_17668_0.n1 0.8825
R737 a_17668_0.n1 a_17668_0.t3 1.6805
R738 a_17668_0.n2 a_17668_0.t2 9.75178
R739 a_16984_0.t0 a_16984_0.n0 0.8195
R740 a_16984_0.n0 a_16984_0.t2 0.8195
R741 a_16984_0.n2 a_16984_0.n0 7.36905
R742 a_16984_0.n1 a_16984_0.n2 8.17078
R743 a_16984_0 a_16984_0.n1 0.8825
R744 a_16984_0.n1 a_16984_0.t1 1.6805
R745 a_16984_0.n2 a_16984_0.t3 9.75178
R746 a_16300_0.n0 a_16300_0.t3 0.8195
R747 a_16300_0.n0 a_16300_0.t0 0.8195
R748 a_16300_0.n2 a_16300_0.n0 7.36905
R749 a_16300_0.n1 a_16300_0.n2 8.17078
R750 a_16300_0 a_16300_0.n1 0.8825
R751 a_16300_0.n1 a_16300_0.t2 1.6805
R752 a_16300_0.n2 a_16300_0.t1 9.75178
R753 a_15616_0.t0 a_15616_0.n2 9.75178
R754 a_15616_0.n2 a_15616_0.n1 7.36905
R755 a_15616_0.n1 a_15616_0.t2 0.8195
R756 a_15616_0.n1 a_15616_0.t3 0.8195
R757 a_15616_0.n0 a_15616_0.n2 8.17078
R758 a_15616_0 a_15616_0.n0 0.8825
R759 a_15616_0.n0 a_15616_0.t1 1.6805
R760 a_14932_0.t0 a_14932_0.n0 0.8195
R761 a_14932_0.n0 a_14932_0.t3 0.8195
R762 a_14932_0.n2 a_14932_0.n0 7.36905
R763 a_14932_0.n1 a_14932_0.n2 8.17078
R764 a_14932_0 a_14932_0.n1 0.8825
R765 a_14932_0.n1 a_14932_0.t2 1.6805
R766 a_14932_0.n2 a_14932_0.t1 9.75178
R767 dx.t0 dx.n0 13.6519
R768 dx.n0 dx.t2 55.1459
R769 dx dx.n0 0.1595
R770 dx dx.t1 18.7857
R771 dy.t0 dy.n0 9.15189
R772 dy.n0 dy.t1 8.45955
R773 dy dy.n0 4.9775
R774 dy dy.n1 4.9775
R775 dy.n1 dy.t2 50.3579
R776 dy.n1 dy.t3 51.2086
R777 dqn.t0 dqn.n0 8.69955
R778 dqn.n4 dqn.n0 4.5005
R779 dqn.n0 dqn.t2 16.6027
R780 dqn.n4 dqn.n2 0.6365
R781 dqn.n2 dqn.n3 4.7885
R782 dqn.n3 dqn.t3 37.5622
R783 dqn.n3 dqn.t5 50.9686
R784 dqn.n2 dqn.t1 13.4119
R785 dqn dqn.n4 0.6365
R786 dqn dqn.n1 6.1205
R787 dqn.n1 dqn.t4 37.5622
R788 dqn.n1 dqn.t6 50.9686
R789 vco_out.n0 vco_out.t1 0.5465
R790 vco_out.n0 vco_out.t0 0.5465
R791 vco_out.n1 vco_out.n0 6.95734
R792 vco_out.n1 vco_out.n7 6.62634
R793 vco_out.n7 vco_out.t3 0.607167
R794 vco_out.n7 vco_out.t5 0.607167
R795 vco_out.n3 vco_out.n1 5.3705
R796 vco_out vco_out.n3 0.8195
R797 vco_out.n5 vco_out.n4 4.5005
R798 vco_out vco_out.n5 0.4115
R799 vco_out.n5 vco_out.n6 0.6245
R800 vco_out.n6 vco_out.t6 55.9619
R801 vco_out.n6 vco_out.t8 55.2286
R802 vco_out.n4 vco_out.t7 50.8379
R803 vco_out.n4 vco_out.t9 50.7286
R804 vco_out.n3 vco_out.n2 11.1263
R805 vco_out.n2 vco_out.t4 0.607167
R806 vco_out.n2 vco_out.t2 0.607167
R807 dqb.t0 dqb.n0 9.15189
R808 dqb.n0 dqb.t1 13.8088
R809 dqb dqb.n0 4.6505
R810 dqb dqb.n3 4.6505
R811 dqb.n3 dqb.n2 4.81503
R812 dqb.n2 dqb.t2 39.215
R813 dqb.n2 dqb.t3 39.0255
R814 dqb.n3 dqb.n1 5.66576
R815 dqb.n1 dqb.t4 58.7685
R816 dqb.n1 dqb.t5 58.5791
R817 nb.n0 nb.t4 0.9105
R818 nb.n0 nb.t5 0.9105
R819 nb.n9 nb.n0 12.1819
R820 nb nb.n9 0.2855
R821 nb.n7 nb.n6 4.5005
R822 nb nb.n7 0.2915
R823 nb.n7 nb.n8 11.0298
R824 nb.n8 nb.t8 58.7685
R825 nb.n8 nb.t9 58.5791
R826 nb.n6 nb.n5 4.81503
R827 nb.n5 nb.t6 58.7685
R828 nb.n5 nb.t7 58.5791
R829 nb.n6 nb.n4 5.66576
R830 nb.n4 nb.t10 58.7685
R831 nb.n4 nb.t11 58.5791
R832 nb.n9 nb.n3 5.3705
R833 nb.n3 nb.n2 7.19955
R834 nb.n2 nb.t3 0.8195
R835 nb.n2 nb.t0 0.8195
R836 nb.n3 nb.n1 7.68189
R837 nb.n1 nb.t2 0.9105
R838 nb.n1 nb.t1 0.9105
R839 r4.n0 r4.t3 0.607167
R840 r4.n0 r4.t2 0.607167
R841 r4.n1 r4.n0 6.86634
R842 r4.n1 r4.n5 8.43066
R843 r4.n5 r4.t1 1.0925
R844 r4.n5 r4.t0 1.0925
R845 r4 r4.n1 5.3705
R846 r4 r4.n4 5.3705
R847 r4.n4 r4.n3 5.05503
R848 r4.n3 r4.t4 39.215
R849 r4.n3 r4.t5 39.0255
R850 r4.n4 r4.n2 5.42576
R851 r4.n2 r4.t6 58.7685
R852 r4.n2 r4.t7 58.5791
R853 r5.n0 r5.t1 0.607167
R854 r5.n0 r5.t0 0.607167
R855 r5.n1 r5.n0 6.62634
R856 r5.n8 r5.n1 4.5005
R857 r5.n1 r5.n9 8.67066
R858 r5.n9 r5.t2 1.0925
R859 r5.n9 r5.t3 1.0925
R860 r5.n8 r5.n7 5.2145
R861 r5.n7 r5.n6 5.29503
R862 r5.n6 r5.t4 45.7328
R863 r5.n6 r5.t5 45.5434
R864 r5.n7 r5.n5 5.18576
R865 r5.n5 r5.t8 45.7328
R866 r5.n5 r5.t9 45.5434
R867 r5 r5.n8 0.2675
R868 r5 r5.n4 5.5115
R869 r5.n4 r5.n3 5.29503
R870 r5.n3 r5.t6 39.215
R871 r5.n3 r5.t7 39.0255
R872 r5.n4 r5.n2 5.18576
R873 r5.n2 r5.t11 58.5791
R874 r5.n2 r5.t10 58.7685
R875 r3.n0 r3.t3 0.607167
R876 r3.n0 r3.t2 0.607167
R877 r3.n1 r3.n0 6.62634
R878 r3.n1 r3.n5 8.67066
R879 r3.n5 r3.t1 1.0925
R880 r3.n5 r3.t0 1.0925
R881 r3 r3.n1 5.3705
R882 r3 r3.n4 5.3705
R883 r3.n4 r3.n3 5.29503
R884 r3.n3 r3.t4 39.215
R885 r3.n3 r3.t5 39.0255
R886 r3.n4 r3.n2 5.18576
R887 r3.n2 r3.t6 58.7685
R888 r3.n2 r3.t7 58.5791
R889 r1.t0 r1.n0 0.607167
R890 r1.n0 r1.t3 0.607167
R891 r1.n1 r1.n0 7.10634
R892 r1.n1 r1.n5 8.19066
R893 r1.n5 r1.t1 1.0925
R894 r1.n5 r1.t2 1.0925
R895 r1 r1.n1 5.6495
R896 r1 r1.n4 5.6555
R897 r1.n4 r1.n3 4.81503
R898 r1.n3 r1.t4 39.215
R899 r1.n3 r1.t5 39.0255
R900 r1.n4 r1.n2 5.66576
R901 r1.n2 r1.t7 58.5791
R902 r1.n2 r1.t6 58.7685
R903 r2.t2 r2.n0 0.607167
R904 r2.n0 r2.t3 0.607167
R905 r2.n1 r2.n0 6.86634
R906 r2.n1 r2.n5 8.43066
R907 r2.n5 r2.t0 1.0925
R908 r2.n5 r2.t1 1.0925
R909 r2 r2.n1 5.1365
R910 r2 r2.n4 5.1425
R911 r2.n4 r2.n3 5.05503
R912 r2.n3 r2.t4 39.215
R913 r2.n3 r2.t5 39.0255
R914 r2.n4 r2.n2 5.42576
R915 r2.n2 r2.t7 58.5791
R916 r2.n2 r2.t6 58.7685
R917 a_17664_1350.t1 a_17664_1350.n1 7.12409
R918 a_17664_1350.n2 a_17664_1350.n1 6.24309
R919 a_17664_1350 a_17664_1350.n2 0.537167
R920 a_17664_1350.n2 a_17664_1350.t0 0.9805
R921 a_17664_1350.n1 a_17664_1350.n0 6.20245
R922 a_17664_1350.n0 a_17664_1350.t3 0.3645
R923 a_17664_1350.n0 a_17664_1350.t2 0.3645
R924 a_16980_1350.t1 a_16980_1350.n1 7.12409
R925 a_16980_1350.n2 a_16980_1350.n1 6.24309
R926 a_16980_1350 a_16980_1350.n2 0.537167
R927 a_16980_1350.n2 a_16980_1350.t0 0.9805
R928 a_16980_1350.n1 a_16980_1350.n0 6.20245
R929 a_16980_1350.n0 a_16980_1350.t3 0.3645
R930 a_16980_1350.n0 a_16980_1350.t2 0.3645
R931 a_16296_1350 a_16296_1350.n0 0.537167
R932 a_16296_1350.n0 a_16296_1350.t2 0.9805
R933 a_16296_1350.n0 a_16296_1350.n2 6.24309
R934 a_16296_1350.n2 a_16296_1350.t3 7.12409
R935 a_16296_1350.n2 a_16296_1350.n1 6.20245
R936 a_16296_1350.n1 a_16296_1350.t1 0.3645
R937 a_16296_1350.n1 a_16296_1350.t0 0.3645
R938 a_15612_1350.t1 a_15612_1350.n1 7.12409
R939 a_15612_1350.n2 a_15612_1350.n1 6.24309
R940 a_15612_1350 a_15612_1350.n2 0.537167
R941 a_15612_1350.n2 a_15612_1350.t0 0.9805
R942 a_15612_1350.n1 a_15612_1350.n0 6.20245
R943 a_15612_1350.n0 a_15612_1350.t3 0.3645
R944 a_15612_1350.n0 a_15612_1350.t2 0.3645
R945 a_14928_1350.t1 a_14928_1350.n1 7.12409
R946 a_14928_1350.n2 a_14928_1350.n1 6.24309
R947 a_14928_1350 a_14928_1350.n2 0.537167
R948 a_14928_1350.n2 a_14928_1350.t0 0.9805
R949 a_14928_1350.n1 a_14928_1350.n0 6.20245
R950 a_14928_1350.n0 a_14928_1350.t3 0.3645
R951 a_14928_1350.n0 a_14928_1350.t2 0.3645
R952 vi.n2 vi.t1 11.9519
R953 vi vi.n0 6.16325
R954 vi.n0 vi.n1 0.77
R955 vi.n1 vi.n2 0.365
R956 vi.n2 vi.t2 13.0544
R957 vi.n1 vi.t3 11.9519
R958 vi.n0 vi.t4 11.9519
R959 vi vi.t0 22.8266
R960 vnt.n5 vnt.t0 11.4119
R961 vnt.n5 vnt.n0 0.77
R962 vnt.n1 vnt.n5 0.77
R963 vnt vnt.n1 5.01125
R964 vnt vnt.n2 2.35175
R965 vnt.n2 vnt.n3 1.49
R966 vnt.n3 vnt.n4 1.9895
R967 vnt.n4 vnt.t2 15.3768
R968 vnt.n4 vnt.t4 13.8873
R969 vnt.n3 vnt.t3 13.8873
R970 vnt.n2 vnt.t1 13.8873
R971 vnt.n1 vnt.t7 11.4119
R972 vnt.n0 vnt.t5 11.4119
R973 vnt.n0 vnt.t6 12.1814
R974 vbn_vco.t0 vbn_vco.n12 11.7674
R975 vbn_vco.n11 vbn_vco.n12 12.0042
R976 vbn_vco vbn_vco.n3 20.3461
R977 vbn_vco vbn_vco.n1 2.48338
R978 vbn_vco.n1 vbn_vco.n11 0.00725
R979 vbn_vco.n3 vbn_vco.n5 0.9965
R980 vbn_vco.n5 vbn_vco.n7 0.9965
R981 vbn_vco.n7 vbn_vco.n9 0.9965
R982 vbn_vco.n9 vbn_vco.n10 10.4541
R983 vbn_vco.n10 vbn_vco.t5 29.8501
R984 vbn_vco.n10 vbn_vco.t6 29.6085
R985 vbn_vco.n9 vbn_vco.n8 9.45808
R986 vbn_vco.n8 vbn_vco.t7 29.8501
R987 vbn_vco.n8 vbn_vco.t8 29.6085
R988 vbn_vco.n7 vbn_vco.n6 9.45808
R989 vbn_vco.n6 vbn_vco.t9 29.8501
R990 vbn_vco.n6 vbn_vco.t10 29.6085
R991 vbn_vco.n5 vbn_vco.n4 9.45808
R992 vbn_vco.n4 vbn_vco.t11 29.8501
R993 vbn_vco.n4 vbn_vco.t12 29.6085
R994 vbn_vco.n3 vbn_vco.n2 9.45808
R995 vbn_vco.n2 vbn_vco.t13 29.8501
R996 vbn_vco.n2 vbn_vco.t14 29.6085
R997 vbn_vco.n11 vbn_vco.t2 21.1415
R998 vbn_vco.n1 vbn_vco.n0 11.0368
R999 vbn_vco.n0 vbn_vco.t4 1.88813
R1000 vbn_vco.n0 vbn_vco.t3 44.5424
R1001 vbn_vco.n12 vbn_vco.t1 12.4424
R1002 vst.t1 vst.n0 12.1814
R1003 vst vst.n0 0.88925
R1004 vst vst.n2 0.0725
R1005 vst.n2 vst.n1 1.148
R1006 vst.n2 vst.t0 36.9645
R1007 vst.n1 vst.t2 19.8995
R1008 vst.n1 vst.t4 13.747
R1009 vst.n0 vst.t3 11.4119
R1010 vbh.t5 vbh.n5 11.5919
R1011 vbh vbh.n5 2.03338
R1012 vbh vbh.n4 16.7889
R1013 vbh.n4 vbh.n1 0.0275
R1014 vbh.n1 vbh.n2 1.013
R1015 vbh.n2 vbh.n3 11.3292
R1016 vbh.n3 vbh.t3 1.83599
R1017 vbh.n3 vbh.t2 12.2744
R1018 vbh.n2 vbh.t6 22.039
R1019 vbh.n1 vbh.t7 22.039
R1020 vbh.n4 vbh.n0 11.1447
R1021 vbh.n0 vbh.t1 1.83599
R1022 vbh.n0 vbh.t0 12.2744
R1023 vbh.n5 vbh.t4 13.9004
R1024 vbl.t4 vbl.n0 13.9499
R1025 vbl.n1 vbl.n0 1.283
R1026 vbl.n2 vbl.n1 1.24475
R1027 vbl.n7 vbl.n2 12.0875
R1028 vbl.n4 vbl.n7 0.059
R1029 vbl vbl.n4 0.5765
R1030 vbl vbl.n5 0.419
R1031 vbl.n5 vbl.n6 12.452
R1032 vbl.n6 vbl.t3 3.47655
R1033 vbl.n6 vbl.t2 8.58548
R1034 vbl.n5 vbl.t8 19.4863
R1035 vbl.n4 vbl.t9 19.4863
R1036 vbl.n7 vbl.n3 12.236
R1037 vbl.n3 vbl.t1 3.47655
R1038 vbl.n3 vbl.t0 8.58548
R1039 vbl.n2 vbl.t5 12.7057
R1040 vbl.n1 vbl.t6 11.5874
R1041 vbl.n0 vbl.t7 11.5874
R1042 vbp_vco.t6 vbp_vco.n0 13.7744
R1043 vbp_vco vbp_vco.n16 19.1311
R1044 vbp_vco vbp_vco.n1 1.85562
R1045 vbp_vco.n1 vbp_vco.n0 1.66775
R1046 vbp_vco.n16 vbp_vco.n10 0.7775
R1047 vbp_vco.n10 vbp_vco.n12 0.9965
R1048 vbp_vco.n12 vbp_vco.n14 0.9965
R1049 vbp_vco.n14 vbp_vco.n15 10.4558
R1050 vbp_vco.n15 vbp_vco.t7 51.8961
R1051 vbp_vco.n15 vbp_vco.t8 51.6545
R1052 vbp_vco.n14 vbp_vco.n13 9.45982
R1053 vbp_vco.n13 vbp_vco.t9 51.8961
R1054 vbp_vco.n13 vbp_vco.t10 51.6545
R1055 vbp_vco.n12 vbp_vco.n11 9.45982
R1056 vbp_vco.n11 vbp_vco.t11 51.8961
R1057 vbp_vco.n11 vbp_vco.t12 51.6545
R1058 vbp_vco.n10 vbp_vco.n9 9.45982
R1059 vbp_vco.n9 vbp_vco.t13 51.8961
R1060 vbp_vco.n9 vbp_vco.t14 51.6545
R1061 vbp_vco.n16 vbp_vco.n8 9.64882
R1062 vbp_vco.n8 vbp_vco.t15 51.8961
R1063 vbp_vco.n8 vbp_vco.t16 51.6545
R1064 vbp_vco.n1 vbp_vco.n7 11.5475
R1065 vbp_vco.n4 vbp_vco.n3 0.6755
R1066 vbp_vco.n6 vbp_vco.n4 1.00175
R1067 vbp_vco.n7 vbp_vco.n6 0.00725
R1068 vbp_vco.n7 vbp_vco.t4 19.6132
R1069 vbp_vco.n6 vbp_vco.n5 9.94325
R1070 vbp_vco.n5 vbp_vco.t3 1.6447
R1071 vbp_vco.n5 vbp_vco.t2 51.9932
R1072 vbp_vco.n4 vbp_vco.t17 61.7152
R1073 vbp_vco.n3 vbp_vco.t18 61.7152
R1074 vbp_vco.n3 vbp_vco.n2 10.787
R1075 vbp_vco.n2 vbp_vco.t1 1.6447
R1076 vbp_vco.n2 vbp_vco.t0 51.9932
R1077 vbp_vco.n0 vbp_vco.t5 12.6719
R1078 vs.n0 vs.t1 11.5919
R1079 vs.n0 vs.t0 67.3435
R1080 vs vs.n0 0.352625
R1081 vs vs.t2 12.0093
R1082 vcl.t0 vcl.n0 13.2171
R1083 vcl.n2 vcl.n0 0.18275
R1084 vcl.n2 vcl.n1 0.81275
R1085 vcl vcl.n2 18.365
R1086 vcl vcl.t4 30.475
R1087 vcl.n1 vcl.t3 12.7221
R1088 vcl.n1 vcl.t1 11.7276
R1089 vcl.n0 vcl.t2 11.7276
R1090 up_b.t0 up_b.n0 14.3606
R1091 up_b up_b.n0 3.15838
R1092 up_b.n0 up_b.t1 46.0827
R1093 up_b up_b.t2 58.2143
R1094 en_b.t0 en_b.n0 17.4656
R1095 en_b.n5 en_b.n0 6.1385
R1096 en_b.n4 en_b.n5 7.9475
R1097 en_b.n2 en_b.n4 0.563
R1098 en_b.n3 en_b.n2 0.608
R1099 en_b en_b.n3 0.27275
R1100 en_b en_b.t2 45.6133
R1101 en_b.n3 en_b.t3 44.126
R1102 en_b.n2 en_b.t4 44.126
R1103 en_b.n4 en_b.t5 44.1711
R1104 en_b.n5 en_b.n1 25.655
R1105 en_b.n1 en_b.t1 20.7657
R1106 en_b.n1 en_b.t7 44.9698
R1107 en_b.n0 en_b.t6 13.6789
R1108 t1c.t0 t1c 16.6346
R1109 t1c t1c.t1 16.6346
R1110 vdump.t2 vdump.n8 22.1535
R1111 vdump.n15 vdump.n9 4.5005
R1112 vdump.n4 vdump.n2 2.858
R1113 vdump.n6 vdump.n4 0.788
R1114 vdump.n9 vdump.n6 0.02975
R1115 vdump.n9 vdump.n7 3.27875
R1116 vdump.n7 vdump.n8 1.013
R1117 vdump.n14 vdump.n15 8.1275
R1118 vdump vdump.n12 1.73975
R1119 vdump vdump.n13 1.51475
R1120 vdump.n13 vdump.n14 0.47075
R1121 vdump.n14 vdump.t1 14.9516
R1122 vdump.n13 vdump.t0 14.4273
R1123 vdump.n12 vdump.n11 10.2695
R1124 vdump.n11 vdump.t10 1.68292
R1125 vdump.n11 vdump.t9 30.1453
R1126 vdump.n12 vdump.n10 11.039
R1127 vdump.n10 vdump.t8 1.68292
R1128 vdump.n10 vdump.t7 30.1453
R1129 vdump.n15 vdump.t17 36.8193
R1130 vdump.n8 vdump.t4 12.366
R1131 vdump.n7 vdump.t3 12.366
R1132 vdump.n6 vdump.n5 10.3032
R1133 vdump.n5 vdump.t16 1.6447
R1134 vdump.n5 vdump.t15 30.2254
R1135 vdump.n4 vdump.n3 10.3032
R1136 vdump.n3 vdump.t12 1.6447
R1137 vdump.n3 vdump.t11 30.2254
R1138 vdump.n2 vdump.n1 10.3032
R1139 vdump.n1 vdump.t14 1.6447
R1140 vdump.n1 vdump.t13 30.2254
R1141 vdump.n2 vdump.n0 11.0908
R1142 vdump.n0 vdump.t6 1.6447
R1143 vdump.n0 vdump.t5 30.2254
R1144 dn_b.t0 dn_b 14.139
R1145 dn_b dn_b.n0 24.9834
R1146 dn_b.n0 dn_b.t1 21.0245
R1147 dn_b.n0 dn_b.t2 45.5055
R1148 dn_s.n1 dn_s.t0 16.5243
R1149 dn_s dn_s.n0 1.0085
R1150 dn_s dn_s.n1 1.346
R1151 dn_s.n1 dn_s.t1 15.3723
R1152 dn_s.n0 dn_s.t2 11.7276
R1153 dn_s.n0 dn_s.t3 13.2171
R1154 vref.n12 vref.t1 12.5644
R1155 vref.n1 vref.n0 1.49
R1156 vref.n2 vref.n1 0.995
R1157 vref.n3 vref.n2 0.995
R1158 vref vref.n3 1.45963
R1159 vref vref.n4 0.030875
R1160 vref.n4 vref.n7 0.041
R1161 vref.n7 vref.n12 0.15575
R1162 vref.n12 vref.n5 1.34375
R1163 vref.n5 vref.n6 0.77
R1164 vref.n7 vref.n11 19.31
R1165 vref.n11 vref.n10 8.56625
R1166 vref.n11 vref.t2 35.3913
R1167 vref.n10 vref.n8 1.067
R1168 vref.n8 vref.n9 0.995
R1169 vref.n9 vref.t11 34.4058
R1170 vref.n9 vref.t12 33.4113
R1171 vref.n8 vref.t13 33.4113
R1172 vref.n10 vref.t14 33.8343
R1173 vref.n6 vref.t0 23.774
R1174 vref.n6 vref.t3 40.3782
R1175 vref.n5 vref.t4 40.3782
R1176 vref.n4 vref.t5 19.4863
R1177 vref.n3 vref.t6 19.4863
R1178 vref.n2 vref.t7 19.4863
R1179 vref.n1 vref.t8 19.4863
R1180 vref.n0 vref.t9 19.4863
R1181 vref.n0 vref.t10 20.4808
R1182 t1b t1b.t0 19.0432
R1183 t1b t1b.t1 37.5581
R1184 va.t0 va 23.6143
R1185 va.n0 va.n1 0.1895
R1186 va va.n0 0.55175
R1187 va.n1 va.t2 56.25
R1188 va.n0 va.t3 36.4132
R1189 va.n1 va.t1 17.3006
R1190 t1a t1a.t0 16.6807
R1191 t1a t1a.t1 36.7481
R1192 t2 t2.t1 16.3769
R1193 t2 t2.n0 17.5921
R1194 t2.n0 t2.t0 23.0242
R1195 t2.n0 t2.t2 17.1202
R1196 vcp_n.t3 vcp_n.n0 1.64987
R1197 vcp_n.n0 vcp_n.t2 23.1665
R1198 vcp_n.n13 vcp_n.n0 9.71825
R1199 vcp_n.n3 vcp_n.n2 0.995
R1200 vcp_n.n4 vcp_n.n3 1.49
R1201 vcp_n.n5 vcp_n.n4 0.995
R1202 vcp_n.n13 vcp_n.n5 0.82625
R1203 vcp_n vcp_n.n13 0.545
R1204 vcp_n vcp_n.n6 1.8725
R1205 vcp_n.n6 vcp_n.n9 0.03425
R1206 vcp_n.n9 vcp_n.n7 0.57425
R1207 vcp_n.n7 vcp_n.n8 1.2155
R1208 vcp_n.n9 vcp_n.n12 17.8475
R1209 vcp_n.n12 vcp_n.n10 0.17375
R1210 vcp_n.n10 vcp_n.n11 8.078
R1211 vcp_n.n11 vcp_n.t5 19.386
R1212 vcp_n.n11 vcp_n.t11 16.866
R1213 vcp_n.n10 vcp_n.t7 16.866
R1214 vcp_n.n12 vcp_n.t8 19.2127
R1215 vcp_n.n8 vcp_n.t6 22.9033
R1216 vcp_n.n8 vcp_n.t10 15.0123
R1217 vcp_n.n7 vcp_n.t9 15.0123
R1218 vcp_n.n6 vcp_n.t4 15.0123
R1219 vcp_n.n5 vcp_n.t12 32.6913
R1220 vcp_n.n4 vcp_n.t13 32.6913
R1221 vcp_n.n3 vcp_n.t14 32.6913
R1222 vcp_n.n2 vcp_n.t15 32.6913
R1223 vcp_n.n2 vcp_n.n1 10.8815
R1224 vcp_n.n1 vcp_n.t1 1.64987
R1225 vcp_n.n1 vcp_n.t0 23.1665
R1226 vbt.n9 vbt.t5 11.4074
R1227 vbt.n1 vbt.n0 0.788
R1228 vbt.n2 vbt.n1 0.788
R1229 vbt vbt.n2 0.64175
R1230 vbt vbt.n3 0.64175
R1231 vbt.n3 vbt.n4 0.788
R1232 vbt.n4 vbt.n5 0.69125
R1233 vbt.n5 vbt.n9 0.09725
R1234 vbt.n5 vbt.n6 32.6165
R1235 vbt.n6 vbt.n7 2.5205
R1236 vbt.n7 vbt.n8 10.598
R1237 vbt.n8 vbt.t6 18.351
R1238 vbt.n8 vbt.t0 16.326
R1239 vbt.n7 vbt.t7 16.326
R1240 vbt.n6 vbt.t1 16.326
R1241 vbt.n9 vbt.t11 12.1949
R1242 vbt.n4 vbt.t4 11.4074
R1243 vbt.n3 vbt.t10 11.4074
R1244 vbt.n2 vbt.t9 11.4074
R1245 vbt.n1 vbt.t3 11.4074
R1246 vbt.n0 vbt.t2 11.4074
R1247 vbt.n0 vbt.t8 12.1949
R1248 vbp.t3 vbp.n15 12.7444
R1249 vbp.n15 vbp.n0 9.40775
R1250 vbp vbp.n15 1.00962
R1251 vbp.n0 vbp.n14 27.6957
R1252 vbp.n2 vbp.n1 1.508
R1253 vbp.n3 vbp.n2 1.013
R1254 vbp.n4 vbp.n3 1.013
R1255 vbp.n5 vbp.n4 1.508
R1256 vbp.n7 vbp.n5 0.84425
R1257 vbp.n8 vbp.n7 1.18175
R1258 vbp.n14 vbp.n8 0.5135
R1259 vbp.n14 vbp.n9 0.995
R1260 vbp.n9 vbp.n10 1.013
R1261 vbp.n10 vbp.n11 1.013
R1262 vbp.n11 vbp.n12 1.508
R1263 vbp.n12 vbp.n13 1.013
R1264 vbp.n13 vbp.t5 27.9115
R1265 vbp.n13 vbp.t6 26.899
R1266 vbp.n12 vbp.t7 26.899
R1267 vbp.n11 vbp.t8 26.899
R1268 vbp.n10 vbp.t9 26.899
R1269 vbp.n9 vbp.t10 26.899
R1270 vbp.n8 vbp.t11 26.899
R1271 vbp.n7 vbp.n6 14.8505
R1272 vbp.n6 vbp.t2 1.83599
R1273 vbp.n6 vbp.t1 12.2744
R1274 vbp.n5 vbp.t12 26.899
R1275 vbp.n4 vbp.t13 26.899
R1276 vbp.n3 vbp.t14 26.899
R1277 vbp.n2 vbp.t15 26.899
R1278 vbp.n1 vbp.t16 26.899
R1279 vbp.n1 vbp.t17 27.9115
R1280 vbp.n0 vbp.t4 24.0548
R1281 vbp vbp.t0 25.4064
R1282 up_s.t0 up_s.n0 14.0207
R1283 up_s.n1 up_s.n0 47.615
R1284 up_s up_s.n1 0.29975
R1285 up_s up_s.t2 13.4235
R1286 up_s.n1 up_s.t1 13.1242
R1287 up_s.n0 up_s.t3 13.0082
R1288 vcp_p.t6 vcp_p.n0 3.11042
R1289 vcp_p.n0 vcp_p.t5 50.5496
R1290 vcp_p.n3 vcp_p.n0 11.057
R1291 vcp_p.n4 vcp_p.n2 0.9635
R1292 vcp_p.n4 vcp_p.n3 0.05
R1293 vcp_p.n6 vcp_p.n5 4.5005
R1294 vcp_p.n6 vcp_p.n4 12.6275
R1295 vcp_p vcp_p.n6 24.4861
R1296 vcp_p vcp_p.t2 24.8119
R1297 vcp_p.n5 vcp_p.t1 13.8629
R1298 vcp_p.n5 vcp_p.t0 12.7109
R1299 vcp_p.n3 vcp_p.t7 60.139
R1300 vcp_p.n2 vcp_p.t8 60.139
R1301 vcp_p.n2 vcp_p.n1 10.8995
R1302 vcp_p.n1 vcp_p.t4 3.11042
R1303 vcp_p.n1 vcp_p.t3 50.5496
C0 vbt a_6000_11024 0
C1 vcp_n vctrl 0.34295f
C2 dn_b vs 0.04385f
C3 r5 r1 0.38587f
C4 vdump vcp_n 0.64496f
C5 vdd vbl 1.02105f
C6 vref pfd_up 0.10761f
C7 a_21350_n100 a_22044_n100 0.01236f
C8 pll_en pfd_dn 0.09331f
C9 a_16980_1350 r3 0
C10 vbp a_12000_18476 0.00764f
C11 vdd a_16296_1350 0.54024f
C12 vctrl pfd_up 0.0472f
C13 vcp_p vdd 10.4695f
C14 vdump pfd_up 0.40291f
C15 r5 a_16980_1350 0.10979f
C16 dn_s vbp 0.00596f
C17 pll_en vcp_n 0.00414f
C18 a_16296_1350 r3 0.09961f
C19 dn_b vref 0.061f
C20 r4 r2 0.01867f
C21 pll_en nb 0.56138f
C22 vs a_12000_18476 0.00168f
C23 dqb a_22044_n100 0.00317f
C24 r5 a_16296_1350 0
C25 dn_b vctrl 0.0624f
C26 dn_b vdump 0.57805f
C27 vbl vbh 0.19544f
C28 vbn_vco vi 0.13466f
C29 pll_en pfd_up 0.12181f
C30 va a_15000_11024 0.00339f
C31 dn_s vs 0
C32 r4 a_17664_1350 0.09586f
C33 vcp_p vbh 0.00561f
C34 vref a_12000_18476 0.00106f
C35 va vcp_p 0
C36 dn_b pll_en 0.0102f
C37 t1b vfilt 0.02246f
C38 vref a_6600_17156 0.00948f
C39 a_16300_0 vbn_vco 0.28232f
C40 vbl a_4200_11024 0
C41 a_20918_1350 dx 0.06711f
C42 bias_ref cp_trim0 0
C43 up_s vfilt 0.06736f
C44 vref dn_s 0.01204f
C45 vctrl a_6600_17156 0.00648f
C46 vcp_p a_4200_11024 0.0049f
C47 vfilt pfd_dn 0.08905f
C48 a_15616_0 vbn_vco 0.28811f
C49 dn_s vctrl 0.5338f
C50 bias_ref vs 0.13938f
C51 vbt vbl 2.07198f
C52 vdump dn_s 0.75951f
C53 vbn_vco en_b 1.19135f
C54 up_b a_13800_11024 0
C55 vbn_vco vdd 1.58096f
C56 t1a vfilt 0.03168f
C57 pll_en a_22044_n100 0
C58 vctrl a_6000_11024 0.01456f
C59 a_15612_1350 r2 0.24421f
C60 en_b vi 0.38028f
C61 vdd vi 0.13531f
C62 vdump a_6000_11024 0.00304f
C63 vcp_n vfilt 0.59388f
C64 vbt vcp_p 0.33363f
C65 vbn_vco r3 0.06692f
C66 vcl en_b 0.82718f
C67 vcl cp_trim1 0.00301f
C68 vcl vdd 0.04414f
C69 dqb vco_div2 0.33611f
C70 vbp_vco r4 0.03122f
C71 vbp a_16980_1350 0.00118f
C72 bias_ref vref 0.13459f
C73 nb a_17664_1350 0.00237f
C74 up_b a_10800_18476 0.00344f
C75 a_18352_n100 r1 0
C76 vbn_vco r5 0.02158f
C77 a_15616_0 a_16300_0 0.05369f
C78 a_14928_1350 r2 0.10255f
C79 dy a_22044_n100 0.08834f
C80 a_17668_0 r1 0.00191f
C81 a_16300_0 vdd 0.00238f
C82 bias_ref vctrl 0.11158f
C83 vdump bias_ref 0.06049f
C84 a_14928_1350 a_14932_0 0.00266f
C85 a_13200_18476 a_14400_18476 0.00585f
C86 a_16300_0 r3 0.06965f
C87 vbp vcp_p 0.07181f
C88 vbh vi 0.09413f
C89 dn_b vfilt 0.03905f
C90 va vbn_vco 0.03922f
C91 up_s vbp_vco 0.01462f
C92 a_16984_0 r1 0.12076f
C93 a_15616_0 vdd 0.00238f
C94 a_16300_0 r5 0
C95 up_s vst 0.04556f
C96 va vi 0.05216f
C97 vdd en_b 3.49983f
C98 en_b cp_trim1 0
C99 vdd cp_trim1 0.20013f
C100 vcp_p a_11400_11024 0
C101 vbp_vco pfd_dn 0.11709f
C102 vctrl a_1200_18656 0.01597f
C103 a_15616_0 r3 0.00275f
C104 vcl va 0.41335f
C105 up_b t1b 0
C106 vst pfd_dn 0.10061f
C107 vdd r3 0.41614f
C108 a_16984_0 a_16980_1350 0.00266f
C109 up_b up_s 0.24478f
C110 vcp_p vs 0.01841f
C111 pfd_dn vnt 0
C112 pll_en vco_div2 0.09649f
C113 up_b pfd_dn 0.18418f
C114 vdd vco_out 0.98614f
C115 vdd r5 0.82475f
C116 vref vbl 0.02239f
C117 pll_en a_20918_1350 0.01284f
C118 a_15612_1350 vbp_vco 0.38827f
C119 vctrl a_15000_11024 0
C120 vdump a_15000_11024 0
C121 r5 r3 0.02161f
C122 up_b t1a 0.02861f
C123 vcl t2 0
C124 a_2000_11024 a_4200_11024 0.00234f
C125 vbp_vco pfd_up 0.03194f
C126 vdd vbh 4.90095f
C127 vctrl vbl 2.93372f
C128 vref vcp_p 0.00349f
C129 dn_s vfilt 0.14028f
C130 up_b vcp_n 0.31252f
C131 vdump vbl 2.10419f
C132 vcl vbt 0.18891f
C133 vst pfd_up 0.1208f
C134 va en_b 0.56301f
C135 t1b t1c 0.64688f
C136 a_13200_18476 a_12000_18476 0.00585f
C137 a_14928_1350 vbp_vco 0.413f
C138 va cp_trim1 0.06961f
C139 r5 vco_out 0.00247f
C140 va vdd 2.25738f
C141 dy a_20918_1350 0.00184f
C142 vcp_p vctrl 0.17471f
C143 pfd_up vnt 0
C144 vdump vcp_p 1.9844f
C145 a_7800_17156 a_6600_17156 0.00585f
C146 pll_en a_16980_1350 0.00255f
C147 up_b pfd_up 3.52859f
C148 vbp vbn_vco 0.51175f
C149 pfd_dn t1c 0.08129f
C150 vbp vi 0.09054f
C151 vcl vbp 0.10943f
C152 t1a t1c 0.06958f
C153 pll_en vcp_p 0.33323f
C154 t2 cp_trim1 0.2775f
C155 t2 vdd 2.60432f
C156 dn_b up_b 0.42265f
C157 vcp_n t1c 0.41366f
C158 vbt cp_trim1 0.00826f
C159 vcl cp_trim0 0.63963f
C160 vbt vdd 9.68036f
C161 bias_ref a_8400_11024 0.0018f
C162 vbn_vco a_17668_0 0.18888f
C163 vbn_vco vs 0.19054f
C164 a_10200_11024 pfd_dn 0
C165 a_7200_11024 a_6000_11024 0.00585f
C166 vs vi 0.49788f
C167 t1c pfd_up 0
C168 r2 r1 0.42709f
C169 bias_ref a_7800_17156 0.00948f
C170 vcl vs 2.19498f
C171 vdd dx 0.12354f
C172 vfilt a_1200_18656 0.00928f
C173 vbn_vco a_16984_0 0.28019f
C174 a_16300_0 a_18352_n100 0
C175 pfd_dn a_13800_11024 0
C176 a_14932_0 r1 0
C177 vref vbn_vco 0.1597f
C178 up_b a_12000_18476 0
C179 vbp en_b 0.16358f
C180 vbp vdd 26.9226f
C181 vdd a_21350_n100 0.00228f
C182 vbp cp_trim1 0.14849f
C183 dn_b t1c 0.06526f
C184 a_17664_1350 r1 0.00202f
C185 a_400_11024 vbl 0
C186 vbt vbh 0
C187 vref vi 2.95099f
C188 cp_trim0 en_b 0.31865f
C189 vbn_vco vctrl 0.13985f
C190 vco_out dx 0.31621f
C191 t2 va 0.59898f
C192 cp_trim0 cp_trim1 0.79081f
C193 vdd cp_trim0 0.06566f
C194 vcl vref 4.16764f
C195 a_10200_11024 pfd_up 0
C196 vdump vbn_vco 0.00112f
C197 vdd a_12600_11024 0.00153f
C198 vdd a_11400_11024 0.01151f
C199 va vbt 0.0848f
C200 vctrl vi 3.65475f
C201 a_400_11024 vcp_p 0.00113f
C202 pfd_dn a_10800_18476 0.01033f
C203 vdump vi 0
C204 vdd a_18352_n100 0.00689f
C205 a_16300_0 a_16984_0 0.05369f
C206 a_16296_1350 r2 0.00202f
C207 a_16980_1350 a_17664_1350 0.08564f
C208 vcl vctrl 0.10093f
C209 vco_out a_21350_n100 0.01534f
C210 vdump vcl 0.0829f
C211 vs en_b 0.3314f
C212 vs cp_trim1 0.00101f
C213 vdd a_17668_0 0.00238f
C214 vdd vs 0.22162f
C215 vbt a_4200_11024 0.00785f
C216 a_13800_11024 pfd_up 0.00557f
C217 dn_b a_10200_11024 0.0025f
C218 vdd dqb 0.58284f
C219 vfilt vcp_p 0.07239f
C220 pll_en vbn_vco 0.43835f
C221 a_2000_11024 vctrl 0
C222 vdump a_2000_11024 0.00395f
C223 vcp_p a_8400_11024 0.00353f
C224 bias_ref vnt 0.10244f
C225 vco_out a_18352_n100 0.0037f
C226 r5 a_18352_n100 0.08457f
C227 pll_en vi 0.40577f
C228 t2 vbt 0.12594f
C229 vdd a_16984_0 0.00238f
C230 vbp va 1.95097f
C231 up_s t1b 0.08426f
C232 vcl pll_en 0.21603f
C233 up_b bias_ref 0.00175f
C234 a_17668_0 vco_out 0
C235 r5 a_17668_0 0.1222f
C236 vref en_b 1.08083f
C237 vref cp_trim1 0.34969f
C238 vref vdd 0.67355f
C239 pfd_up a_10800_18476 0.01304f
C240 t1b pfd_dn 0.03281f
C241 dqb vco_out 0
C242 nb dqn 0.02794f
C243 r4 nb 0.00273f
C244 va cp_trim0 0.05063f
C245 a_16984_0 r3 0
C246 a_15612_1350 r4 0.00202f
C247 vbp_vco r1 0.02785f
C248 up_s pfd_dn 0.08862f
C249 vctrl en_b 0.31515f
C250 vdd vctrl 3.3102f
C251 vdump en_b 1.02541f
C252 vdump vdd 3.07226f
C253 r5 a_16984_0 0.07245f
C254 t1a t1b 0.09526f
C255 va vs 0.05797f
C256 dn_b a_10800_18476 0.01243f
C257 t1b vcp_n 0.17079f
C258 up_s t1a 0.08486f
C259 vbp t2 2.72289f
C260 a_7200_11024 vcp_p 0.00353f
C261 vbp_vco a_16980_1350 0.37969f
C262 up_s vcp_n 0.26351f
C263 vbp vbt 5.28987f
C264 t1a pfd_dn 0.05385f
C265 t2 cp_trim0 0.46407f
C266 pll_en en_b 3.00273f
C267 bias_ref t1c 0.00215f
C268 vref vbh 0.13429f
C269 pll_en cp_trim1 0
C270 pll_en vdd 5.81897f
C271 vcp_n pfd_dn 0.19733f
C272 t1b pfd_up 0.00277f
C273 vbt cp_trim0 0
C274 vbn_vco r2 0.15313f
C275 vbp_vco a_16296_1350 0.38352f
C276 vref va 2.22773f
C277 up_s pfd_up 0.30919f
C278 up_b a_15000_11024 0
C279 dx a_21350_n100 0.07283f
C280 vctrl vbh 2.66724f
C281 vbl vnt 0.17164f
C282 vdump vbh 0.97487f
C283 t2 vs 0
C284 t1a vcp_n 1.07252f
C285 vst a_16296_1350 0
C286 pfd_dn pfd_up 5.5399f
C287 vbt vs 0.0788f
C288 vbn_vco a_14932_0 0.31195f
C289 a_12000_18476 a_10800_18476 0.00585f
C290 va vctrl 1.51072f
C291 dn_b t1b 0.03197f
C292 vdump va 0.05061f
C293 pll_en vco_out 0.62478f
C294 pll_en r5 0.03735f
C295 dy vdd 0.42004f
C296 bias_ref a_10200_11024 0.01361f
C297 dqn a_22044_n100 0.1022f
C298 a_400_11024 a_2000_11024 0.00585f
C299 up_b vcp_p 0.08716f
C300 vcl vfilt 0.09853f
C301 t1a pfd_up 0.0048f
C302 vbp cp_trim0 0.06665f
C303 vctrl a_4200_11024 0
C304 vcp_n pfd_up 0.06644f
C305 pll_en vbh 0
C306 a_16300_0 r2 0.00191f
C307 vdump a_4200_11024 0
C308 dn_b pfd_dn 3.58679f
C309 vbp a_12600_11024 0.01436f
C310 vbp a_11400_11024 0.00244f
C311 vref t2 0.00612f
C312 dqb dx 0
C313 vref vbt 0.00547f
C314 dy vco_out 0.21633f
C315 pll_en va 0.14652f
C316 vcl a_13200_18476 0.00132f
C317 vbp vs 0.05935f
C318 a_11400_11024 a_12600_11024 0.00585f
C319 dn_b t1a 0.96541f
C320 a_14928_1350 a_15612_1350 0.08564f
C321 vbt vctrl 1.11719f
C322 a_15616_0 r2 0.11441f
C323 dqb a_21350_n100 0
C324 vdump vbt 2.88875f
C325 dn_b vcp_n 0.19577f
C326 vs cp_trim0 0.00101f
C327 vdd r2 0.38146f
C328 a_15616_0 a_14932_0 0.05369f
C329 bias_ref a_10800_18476 0.00953f
C330 a_17668_0 a_18352_n100 0.0416f
C331 r2 r3 0.57744f
C332 vfilt vdd 0.64136f
C333 vfilt cp_trim1 0.00597f
C334 vdd a_14932_0 0.00238f
C335 dn_b pfd_up 0.14217f
C336 vref vbp 2.21685f
C337 dn_s up_s 0
C338 en_b a_17664_1350 0
C339 vdd a_17664_1350 0.6635f
C340 vbn_vco vbp_vco 3.05745f
C341 a_14932_0 r3 0.11452f
C342 vref cp_trim0 0.8812f
C343 dn_s pfd_dn 0.16656f
C344 vbp vctrl 0.43053f
C345 a_16984_0 a_18352_n100 0
C346 vref a_12600_11024 0.00454f
C347 vdump vbp 0.11635f
C348 vbp_vco vi 0.92122f
C349 vst vbn_vco 0.11539f
C350 a_16984_0 a_17668_0 0.05369f
C351 vst vi 0.05622f
C352 vbn_vco vnt 0
C353 vco_div2 dqn 0
C354 a_13800_11024 a_15000_11024 0.00585f
C355 vcp_p a_10200_11024 0.00353f
C356 pll_en dx 0.03766f
C357 vdump cp_trim0 0
C358 vctrl a_11400_11024 0
C359 vctrl a_12600_11024 0
C360 vref vs 0.14103f
C361 vdump a_12600_11024 0
C362 vdump a_11400_11024 0
C363 vco_out a_17664_1350 0
C364 r5 a_17664_1350 0.2568f
C365 up_b vbn_vco 0
C366 dn_s vcp_n 1.36315f
C367 vnt vi 0.03911f
C368 a_20918_1350 dqn 0.01517f
C369 up_b vi 0
C370 pll_en vbp 0.55749f
C371 vctrl vs 0.68186f
C372 pll_en a_21350_n100 0
C373 up_b vcl 0.02975f
C374 r4 r1 0.26836f
C375 vdump vs 0.04935f
C376 va vfilt 0.05613f
C377 dy dx 0.09274f
C378 bias_ref pfd_dn 0.00199f
C379 pll_en cp_trim0 0.06917f
C380 pll_en a_18352_n100 0.06257f
C381 r4 a_16980_1350 0.00279f
C382 a_13200_18476 va 0.0036f
C383 vbp_vco en_b 0.15763f
C384 dy a_21350_n100 0.06414f
C385 vbp_vco vdd 7.2047f
C386 vref vctrl 0.67157f
C387 pll_en vs 0.34971f
C388 pll_en a_17668_0 0
C389 bias_ref vcp_n 0
C390 dn_b dn_s 0.04766f
C391 vdump vref 0.10204f
C392 vst en_b 1.08808f
C393 vst vdd 0.62575f
C394 pll_en dqb 0.11437f
C395 vbp_vco r3 0.0616f
C396 t2 vfilt 0.0728f
C397 vdd vnt 0.08573f
C398 vdump vctrl 5.69842f
C399 r4 a_16296_1350 0.24896f
C400 vbt vfilt 0.28746f
C401 vcl t1c 0
C402 up_b en_b 0.1339f
C403 up_b vdd 3.50253f
C404 up_b cp_trim1 0.01011f
C405 bias_ref pfd_up 0.00295f
C406 vbp_vco r5 0.04056f
C407 pll_en vref 0.48496f
C408 up_s a_15000_11024 0.00107f
C409 vcp_n a_1200_18656 0.00174f
C410 dy dqb 0.00547f
C411 a_20918_1350 nb 0.00624f
C412 pfd_dn a_15000_11024 0
C413 pll_en vctrl 0.41216f
C414 dn_b bias_ref 0.00244f
C415 vdump pll_en 0.07952f
C416 nb r1 0.00205f
C417 a_15612_1350 r1 0.09617f
C418 va vbp_vco 0.04169f
C419 vbp vfilt 0.21533f
C420 up_s vcp_p 2.4573f
C421 vbh vnt 1.98218f
C422 va vst 0.67084f
C423 up_b vbh 0.01113f
C424 vcp_p pfd_dn 0.32379f
C425 vfilt cp_trim0 0.01233f
C426 a_16980_1350 nb 0
C427 va vnt 0.49737f
C428 vdd t1c 0.02974f
C429 t1c cp_trim1 0.17179f
C430 a_14928_1350 r1 0
C431 up_b va 0.05067f
C432 a_13200_18476 vbp 0.00418f
C433 a_15000_11024 pfd_up 0.00557f
C434 vfilt vs 0.71378f
C435 vcp_n vcp_p 1.87181f
C436 a_15612_1350 a_16296_1350 0.08564f
C437 a_17668_0 a_17664_1350 0.00266f
C438 vco_div2 a_22044_n100 0
C439 pll_en dy 0.1287f
C440 vcl a_10800_18476 0.00132f
C441 vbn_vco r4 0.03849f
C442 a_13200_18476 vs 0.00168f
C443 vcp_p pfd_up 0.04833f
C444 a_400_11024 vctrl 0.00176f
C445 vdump a_400_11024 0
C446 vref vfilt 0.111f
C447 a_13800_11024 en_b 0
C448 vfilt vctrl 5.96211f
C449 dn_b vcp_p 0.05729f
C450 vdump vfilt 0.1481f
C451 vbp vbp_vco 0.04316f
C452 a_13200_18476 vref 0.01727f
C453 a_8400_11024 vctrl 0
C454 vdump a_8400_11024 0
C455 a_16300_0 r4 0.11476f
C456 vbp vst 0.48214f
C457 up_s vbn_vco 0
C458 vcl t1b 0
C459 up_s vi 0
C460 vbp vnt 0.00258f
C461 vbn_vco pfd_dn 0.05603f
C462 vdd a_10800_18476 0
C463 up_b vbp 0.09944f
C464 vcl up_s 0.0197f
C465 a_7800_17156 vctrl 0
C466 t2 t1c 0.10629f
C467 pfd_dn vi 0
C468 a_15616_0 r4 0.00191f
C469 vbp_vco vs 0.61296f
C470 vcl pfd_dn 0.03078f
C471 up_b cp_trim0 0.04536f
C472 pll_en a_17664_1350 0.01914f
C473 vdd dqn 0.75291f
C474 vdd r4 0.38676f
C475 up_b a_11400_11024 0.0096f
C476 up_b a_12600_11024 0
C477 a_7200_11024 vctrl 0.00329f
C478 va a_13800_11024 0.01435f
C479 vdump a_7200_11024 0
C480 r4 r3 0.30134f
C481 a_15612_1350 vbn_vco 0.01256f
C482 vcl t1a 0
C483 a_6000_11024 vbl 0
C484 dn_s vcp_p 0.68209f
C485 up_b vs 0.037f
C486 vcl vcp_n 0.04253f
C487 vref vbp_vco 0.08834f
C488 vbn_vco pfd_up 0.00544f
C489 t1b en_b 0
C490 vco_out dqn 0.52411f
C491 r5 r4 0.59901f
C492 t1b cp_trim1 1.52676f
C493 t1b vdd 1.66469f
C494 vcl a_14400_18476 0.00123f
C495 vcp_p a_6000_11024 0.00353f
C496 vref vst 0.67466f
C497 pfd_up vi 0
C498 up_s en_b 0.83044f
C499 vbp t1c 0
C500 a_14928_1350 vbn_vco 0.04947f
C501 up_s cp_trim1 0.07199f
C502 up_s vdd 4.05065f
C503 vbp_vco vctrl 0.05182f
C504 vcl pfd_up 0.03006f
C505 vref vnt 1.62789f
C506 vdump vbp_vco 0.01437f
C507 cp_trim0 t1c 1.07447f
C508 pfd_dn en_b 0.90025f
C509 vst vctrl 0.15852f
C510 vdd pfd_dn 0.66477f
C511 pfd_dn cp_trim1 0.24514f
C512 up_b vref 0.09653f
C513 vdump vst 0.09224f
C514 vctrl vnt 0.71316f
C515 vdump vnt 0.94882f
C516 dn_b vi 0
C517 up_b vctrl 1.59591f
C518 bias_ref vcp_p 0.06097f
C519 t1a vdd 1.37505f
C520 t1a cp_trim1 0.13592f
C521 dn_b vcl 0.03675f
C522 vdump up_b 0.05754f
C523 a_14932_0 r2 0.0814f
C524 vs t1c 0
C525 vcp_n en_b 0.52234f
C526 pll_en vbp_vco 1.84455f
C527 vcp_n vdd 4.43137f
C528 vcp_n cp_trim1 1.05619f
C529 a_15616_0 a_15612_1350 0.00266f
C530 vdd nb 1.20287f
C531 pll_en vst 0.10226f
C532 a_16980_1350 r1 0.24402f
C533 a_15612_1350 vdd 0.54021f
C534 va t1b 0.93846f
C535 a_11400_11024 a_10200_11024 0.00585f
C536 pll_en vnt 0
C537 en_b pfd_up 0.11699f
C538 vdd pfd_up 1.12703f
C539 cp_trim1 pfd_up 0.1647f
C540 pfd_dn vbh 0
C541 a_15612_1350 r3 0.0142f
C542 up_s va 0.08493f
C543 up_b pll_en 1.05529f
C544 vcp_p a_1200_18656 0.00697f
C545 vref t1c 0.01204f
C546 a_16296_1350 r1 0.00382f
C547 va pfd_dn 0.05058f
C548 nb vco_out 0.66809f
C549 r5 nb 0.31295f
C550 a_14928_1350 vdd 0.60244f
C551 vcl a_12000_18476 0.00132f
C552 a_13800_11024 a_12600_11024 0.00585f
C553 dn_b en_b 0
C554 a_14928_1350 r3 0.25032f
C555 dn_b cp_trim1 0.07889f
C556 dn_b vdd 0.63261f
C557 dqn dx 0.21614f
C558 t2 t1b 0.18883f
C559 vcl dn_s 0
C560 a_16296_1350 a_16980_1350 0.08564f
C561 va vcp_n 0.11263f
C562 t1b vbt 0.08426f
C563 up_s t2 0.12594f
C564 vbh pfd_up 0.00826f
C565 up_s vbt 2.54586f
C566 vcp_p vbl 0.00934f
C567 a_7200_11024 a_8400_11024 0.00585f
C568 va a_14400_18476 0.00672f
C569 dqn a_21350_n100 0.00189f
C570 t2 pfd_dn 0.2255f
C571 vctrl a_10200_11024 0
C572 vbp_vco r2 0.03427f
C573 vbt pfd_dn 0.0023f
C574 va pfd_up 0.061f
C575 vdump a_10200_11024 0
C576 vs a_10800_18476 0.00168f
C577 vdd a_22044_n100 0.00404f
C578 vref a_13800_11024 0.00398f
C579 t2 t1a 0.36991f
C580 vdd a_12000_18476 0.00672f
C581 dn_b vbh 0.00796f
C582 bias_ref vi 0.05055f
C583 r4 a_18352_n100 0.0018f
C584 t1a vbt 0.08486f
C585 t2 vcp_n 1.94515f
C586 vbp t1b 1.907f
C587 vbp_vco a_17664_1350 0.28051f
C588 vcl bias_ref 0.00215f
C589 vbt vcp_n 0.43414f
C590 vctrl a_13800_11024 0
C591 r4 a_17668_0 0.0725f
C592 dn_b va 0
C593 vdump a_13800_11024 0
C594 dn_s vdd 0.02751f
C595 up_s vbp 3.11325f
C596 dqb dqn 0.1844f
C597 t1b cp_trim0 0.05587f
C598 vco_out a_22044_n100 0.05502f
C599 vref a_10800_18476 0.00106f
C600 t2 pfd_up 0.00175f
C601 vbp pfd_dn 0.1009f
C602 up_s cp_trim0 0.06681f
C603 r4 a_16984_0 0.00733f
C604 vbn_vco r1 0.10304f
C605 nb dx 0.00442f
C606 pfd_dn cp_trim0 0.73576f
C607 t1b vs 0
C608 a_11400_11024 pfd_dn 0
C609 pfd_dn a_12600_11024 0
C610 vbp t1a 1.40087f
C611 up_s vs 0.07346f
C612 vbp vcp_n 7.47115f
C613 dn_b t2 0.03559f
C614 nb a_21350_n100 0
C615 t1a cp_trim0 0.14684f
C616 vs pfd_dn 0.10049f
C617 bias_ref cp_trim1 0
C618 bias_ref vdd 0.19297f
C619 vcp_n cp_trim0 0.5852f
C620 vref t1b 0.00924f
C621 vbp pfd_up 0.0647f
C622 a_16300_0 r1 0.01603f
C623 vbl vi 0.01838f
C624 t1a vs 0
C625 vdd vco_div2 0.27243f
C626 nb a_18352_n100 0.19005f
C627 vbn_vco a_16296_1350 0.00348f
C628 vref up_s 0.04368f
C629 vcp_n vs 0.01665f
C630 cp_trim0 pfd_up 0.10106f
C631 a_17668_0 nb 0.0032f
C632 pfd_up a_12600_11024 0.00557f
C633 vst vbp_vco 0.17446f
C634 a_11400_11024 pfd_up 0.01173f
C635 pll_en dqn 0.29871f
C636 pll_en r4 0.00532f
C637 a_20918_1350 vdd 0.33527f
C638 vref pfd_dn 0.10935f
C639 vcp_p vi 0
C640 a_15616_0 r1 0.08366f
C641 up_s vctrl 0.40817f
C642 vs a_14400_18476 0.00168f
C643 dn_b vbp 0.00407f
C644 vdump up_s 0.33478f
C645 vbp_vco vnt 0
C646 vcl vcp_p 0.00659f
C647 vdd r1 0.36805f
C648 a_6000_11024 a_4200_11024 0.00234f
C649 a_2000_11024 vbl 0
C650 vs pfd_up 0.10183f
C651 up_b vbp_vco 0.00984f
C652 vctrl pfd_dn 0.69813f
C653 vco_div2 vco_out 0
C654 bias_ref vbh 0.15735f
C655 vst vnt 0.00255f
C656 vref t1a 0.00602f
C657 vdump pfd_dn 0.24647f
C658 dn_b cp_trim0 0.69419f
C659 up_b vst 0.09999f
C660 dn_b a_11400_11024 0
C661 vref vcp_n 0.02372f
C662 dn_s vbt 0.08611f
C663 r1 r3 0.2114f
C664 a_8400_11024 a_10200_11024 0.00234f
C665 a_16300_0 a_16296_1350 0.00266f
C666 dx a_22044_n100 0.00219f
C667 dy dqn 0.50938f
C668 a_20918_1350 vco_out 0.0543f
C669 pll_en t1b 0
C670 bias_ref va 0
C671 vcp_p a_2000_11024 0.02136f
C672 en_b a_15000_11024 0
C673 vdd a_16980_1350 0.54226f
C674 vdump t1a 0.04835f
C675 pll_en up_s 0.14607f
C676 vco_div2 vss 0.210661f
C677 bias_ref vss 6.53433f
C678 pll_en vss 4.25414f
C679 pfd_up vss 1.57181f
C680 cp_trim1 vss 2.18411f
C681 cp_trim0 vss 1.38048f
C682 pfd_dn vss 1.31966f
C683 vctrl vss 20.6419f
C684 vdd vss 396.954f
C685 a_22044_n100 vss 0.255159f
C686 a_21350_n100 vss 0.186011f
C687 a_18352_n100 vss 0.310281f
C688 a_17668_0 vss 0.170323f
C689 a_16984_0 vss 0.118285f
C690 a_16300_0 vss 0.117082f
C691 a_15616_0 vss 0.117146f
C692 a_14932_0 vss 0.176969f
C693 dx vss 0.255925f
C694 a_20918_1350 vss 0.17451f
C695 dy vss 0.224565f
C696 dqn vss 0.471213f
C697 vco_out vss 0.365574f
C698 dqb vss 0.372556f
C699 nb vss 0.43177f
C700 r4 vss 0.24306f
C701 r5 vss 0.504069f
C702 r3 vss 0.252913f
C703 r1 vss 0.269351f
C704 r2 vss 0.28926f
C705 a_17664_1350 vss 0.00370423f
C706 a_16980_1350 vss 0.00103879f
C707 a_16296_1350 vss 0.00103038f
C708 a_15612_1350 vss 0.00106774f
C709 a_14928_1350 vss 0.00696934f
C710 vi vss 0.931476f
C711 vnt vss 2.61265f
C712 vbn_vco vss 3.41127f
C713 vst vss 2.09654f
C714 vbh vss 0.939241f
C715 vbl vss 3.18547f
C716 vbp_vco vss 1.49283f
C717 a_15000_11024 vss 0.66425f
C718 a_14400_18476 vss 0.68276f
C719 a_13800_11024 vss 0.65668f
C720 a_13200_18476 vss 0.67329f
C721 a_12600_11024 vss 0.65668f
C722 a_12000_18476 vss 0.67329f
C723 a_11400_11024 vss 0.65668f
C724 a_10800_18476 vss 0.67854f
C725 a_10200_11024 vss 0.67606f
C726 a_8400_11024 vss 0.6626f
C727 a_7800_17156 vss 0.66004f
C728 a_7200_11024 vss 0.65668f
C729 a_6600_17156 vss 0.66004f
C730 a_6000_11024 vss 0.6626f
C731 a_4200_11024 vss 0.66852f
C732 vs vss 4.66364f
C733 a_2000_11024 vss 1.06033f
C734 a_1200_18656 vss 1.08054f
C735 a_400_11024 vss 1.07671f
C736 vcl vss 2.60143f
C737 up_b vss 0.474399f
C738 en_b vss 3.02019f
C739 t1c vss 0.518606f
C740 vdump vss 1.72921f
C741 dn_b vss 1.90436f
C742 dn_s vss 1.16885f
C743 vref vss 13.2505f
C744 t1b vss 0.877856f
C745 va vss 1.94253f
C746 t1a vss 0.993277f
C747 t2 vss 0.475239f
C748 vcp_n vss 6.1224f
C749 vbt vss 0.667881f
C750 vbp vss 1.48624f
C751 up_s vss 1.38717f
C752 vcp_p vss 4.43385f
C753 vcp_p.t6 vss 0.874544f
C754 vcp_p.n0 vss 0.376243f
C755 vcp_p.t4 vss 0.874544f
C756 vcp_p.n1 vss 0.375407f
C757 vcp_p.n2 vss 0.334816f
C758 vcp_p.n3 vss 0.322926f
C759 vcp_p.n4 vss 0.116338f
C760 vcp_p.t0 vss 0.509781f
C761 vcp_p.t1 vss 0.517214f
C762 vcp_p.n5 vss 0.171476f
C763 vcp_p.n6 vss 0.606141f
C764 vcp_p.t2 vss 0.103897f
C765 up_s.t0 vss 0.907534f
C766 up_s.t3 vss 0.902282f
C767 up_s.n0 vss 1.08259f
C768 up_s.t1 vss 0.201277f
C769 up_s.t2 vss 0.188812f
C770 up_s.n1 vss 0.884425f
C771 vbp.t3 vss 0.17488f
C772 vbp.t0 vss 0.122281f
C773 vbp.t4 vss 0.0756058f
C774 vbp.n0 vss 0.786908f
C775 vbp.n1 vss 0.507094f
C776 vbp.n2 vss 0.27341f
C777 vbp.n3 vss 0.262609f
C778 vbp.n4 vss 0.27341f
C779 vbp.n5 vss 0.269728f
C780 vbp.t2 vss 0.147606f
C781 vbp.n6 vss 0.260073f
C782 vbp.n7 vss 0.173798f
C783 vbp.n8 vss 0.255392f
C784 vbp.n9 vss 0.262217f
C785 vbp.n10 vss 0.262609f
C786 vbp.n11 vss 0.27341f
C787 vbp.n12 vss 0.27341f
C788 vbp.n13 vss 0.496293f
C789 vbp.n14 vss 0.458426f
C790 vbp.n15 vss 0.165619f
C791 vbt.t5 vss 0.133682f
C792 vbt.t8 vss 0.110333f
C793 vbt.t2 vss 0.133682f
C794 vbt.n0 vss 0.0812184f
C795 vbt.t3 vss 0.133682f
C796 vbt.n1 vss 0.0474918f
C797 vbt.t9 vss 0.107482f
C798 vbt.n2 vss 0.0450934f
C799 vbt.t10 vss 0.107482f
C800 vbt.n3 vss 0.0450934f
C801 vbt.t4 vss 0.133682f
C802 vbt.n4 vss 0.045906f
C803 vbt.t11 vss 0.109811f
C804 vbt.n5 vss 0.401367f
C805 vbt.t1 vss 0.270593f
C806 vbt.n6 vss 0.537387f
C807 vbt.t7 vss 0.267197f
C808 vbt.n7 vss 0.320692f
C809 vbt.t0 vss 0.267197f
C810 vbt.n8 vss 0.437373f
C811 vbt.t6 vss 0.286072f
C812 vbt.n9 vss 0.069891f
C813 vcp_n.t3 vss 0.503585f
C814 vcp_n.n0 vss 0.308316f
C815 vcp_n.t1 vss 0.503585f
C816 vcp_n.n1 vss 0.314608f
C817 vcp_n.n2 vss 0.284621f
C818 vcp_n.n3 vss 0.241395f
C819 vcp_n.n4 vss 0.241395f
C820 vcp_n.n5 vss 0.222451f
C821 vcp_n.t4 vss 0.153828f
C822 vcp_n.n6 vss 0.152832f
C823 vcp_n.t9 vss 0.146239f
C824 vcp_n.n7 vss 0.149494f
C825 vcp_n.t10 vss 0.14267f
C826 vcp_n.n8 vss 0.369016f
C827 vcp_n.t6 vss 0.123808f
C828 vcp_n.n9 vss 0.272427f
C829 vcp_n.t8 vss 0.665328f
C830 vcp_n.t7 vss 0.632388f
C831 vcp_n.n10 vss 0.435615f
C832 vcp_n.t11 vss 0.632388f
C833 vcp_n.n11 vss 0.741511f
C834 vcp_n.t5 vss 0.668087f
C835 vcp_n.n12 vss 0.563744f
C836 vcp_n.n13 vss 0.0621664f
C837 t2.t1 vss 0.0931093f
C838 t2.t2 vss 0.282754f
C839 t2.t0 vss 0.341956f
C840 t2.n0 vss 0.549062f
C841 t1a.t0 vss 0.130364f
C842 t1a.t1 vss 0.648259f
C843 va.t0 vss 0.120315f
C844 va.t1 vss 0.206377f
C845 va.n0 vss 0.129103f
C846 va.n1 vss 1.62646f
C847 va.t2 vss 1.45467f
C848 t1b.t0 vss 0.140923f
C849 t1b.t1 vss 0.549672f
C850 vref.t1 vss 0.415862f
C851 vref.n0 vss 0.459618f
C852 vref.n1 vss 0.263166f
C853 vref.n2 vss 0.243115f
C854 vref.n3 vss 0.261937f
C855 vref.n4 vss 0.165414f
C856 vref.n5 vss 0.246827f
C857 vref.n6 vss 0.590289f
C858 vref.t0 vss 0.181877f
C859 vref.n7 vss 0.470839f
C860 vref.n8 vss 0.370172f
C861 vref.n9 vss 0.688315f
C862 vref.n10 vss 0.44386f
C863 vref.t2 vss 0.339024f
C864 vref.n11 vss 1.63688f
C865 vref.n12 vss 0.154533f
C866 dn_s.t0 vss 0.185213f
C867 dn_s.t3 vss 0.563339f
C868 dn_s.t2 vss 0.553799f
C869 dn_s.n0 vss 0.183189f
C870 dn_s.t1 vss 0.210554f
C871 dn_s.n1 vss 0.284591f
C872 dn_b.t0 vss 0.156784f
C873 dn_b.t1 vss 0.146648f
C874 dn_b.n0 vss 1.3502f
C875 vdump.t2 vss 0.298347f
C876 vdump.t6 vss 0.135517f
C877 vdump.n0 vss 0.14891f
C878 vdump.t14 vss 0.135517f
C879 vdump.n1 vss 0.145181f
C880 vdump.n2 vss 0.165339f
C881 vdump.t12 vss 0.135517f
C882 vdump.n3 vss 0.145181f
C883 vdump.n4 vss 0.116546f
C884 vdump.t16 vss 0.135517f
C885 vdump.n5 vss 0.145181f
C886 vdump.n6 vss 0.0511163f
C887 vdump.t3 vss 0.251316f
C888 vdump.n7 vss 0.149402f
C889 vdump.t4 vss 0.251316f
C890 vdump.n8 vss 0.455533f
C891 vdump.n9 vss 0.0765186f
C892 vdump.t17 vss 0.38854f
C893 vdump.t8 vss 0.134481f
C894 vdump.n10 vss 0.143101f
C895 vdump.t10 vss 0.134481f
C896 vdump.n11 vss 0.139522f
C897 vdump.n12 vss 0.137227f
C898 vdump.t0 vss 0.149285f
C899 vdump.n13 vss 0.109674f
C900 vdump.t1 vss 0.152018f
C901 vdump.n14 vss 0.136625f
C902 vdump.n15 vss 0.765036f
C903 t1c.t0 vss 0.170421f
C904 t1c.t1 vss 0.166543f
C905 en_b.t0 vss 0.220556f
C906 en_b.n0 vss 0.614481f
C907 en_b.t1 vss 0.355554f
C908 en_b.n1 vss 1.30797f
C909 en_b.n2 vss 0.257004f
C910 en_b.n3 vss 0.244653f
C911 en_b.n4 vss 0.30388f
C912 en_b.n5 vss 1.216f
C913 up_b.t0 vss 0.0808599f
C914 up_b.n0 vss 0.68419f
C915 up_b.t1 vss 0.3913f
C916 vcl.t0 vss 0.556302f
C917 vcl.t2 vss 0.54465f
C918 vcl.n0 vss 0.182184f
C919 vcl.t1 vss 0.54465f
C920 vcl.n1 vss 0.17623f
C921 vcl.t3 vss 0.553291f
C922 vcl.n2 vss 0.224817f
C923 vcl.t4 vss 0.189123f
C924 vs.t1 vss 0.265666f
C925 vs.t2 vss 0.268817f
C926 vs.t0 vss 1.26001f
C927 vs.n0 vss 1.86578f
C928 vbp_vco.t6 vss 0.226133f
C929 vbp_vco.t5 vss 0.216889f
C930 vbp_vco.n0 vss 0.251394f
C931 vbp_vco.n1 vss 0.172963f
C932 vbp_vco.t1 vss 0.125248f
C933 vbp_vco.n2 vss 0.151455f
C934 vbp_vco.n3 vss 0.173091f
C935 vbp_vco.n4 vss 0.126612f
C936 vbp_vco.t3 vss 0.125248f
C937 vbp_vco.n5 vss 0.147136f
C938 vbp_vco.n6 vss 0.057308f
C939 vbp_vco.t4 vss 0.0783479f
C940 vbp_vco.n7 vss 0.190516f
C941 vbp_vco.n8 vss 0.0785341f
C942 vbp_vco.n9 vss 0.0782347f
C943 vbp_vco.n10 vss 0.0388871f
C944 vbp_vco.n11 vss 0.0782347f
C945 vbp_vco.n12 vss 0.0423464f
C946 vbp_vco.n13 vss 0.0782347f
C947 vbp_vco.n14 vss 0.0677085f
C948 vbp_vco.n15 vss 0.0809065f
C949 vbp_vco.n16 vss 0.259588f
C950 vbl.t4 vss 0.290111f
C951 vbl.t7 vss 0.263139f
C952 vbl.n0 vss 0.316232f
C953 vbl.t6 vss 0.263139f
C954 vbl.n1 vss 0.151179f
C955 vbl.t5 vss 0.272109f
C956 vbl.n2 vss 0.299918f
C957 vbl.t1 vss 0.140401f
C958 vbl.n3 vss 0.233942f
C959 vbl.n4 vss 0.173626f
C960 vbl.n5 vss 0.336195f
C961 vbl.t3 vss 0.140401f
C962 vbl.n6 vss 0.236813f
C963 vbl.n7 vss 0.278256f
C964 vbh.t5 vss 0.157461f
C965 vbh.t4 vss 0.173633f
C966 vbh.t1 vss 0.161041f
C967 vbh.n0 vss 0.173776f
C968 vbh.n1 vss 0.105466f
C969 vbh.n2 vss 0.189359f
C970 vbh.t3 vss 0.161041f
C971 vbh.n3 vss 0.175103f
C972 vbh.n4 vss 0.210978f
C973 vbh.n5 vss 0.214932f
C974 vst.t1 vss 0.311553f
C975 vst.t3 vss 0.306401f
C976 vst.n0 vss 0.188562f
C977 vst.n1 vss 0.282544f
C978 vst.t2 vss 0.102285f
C979 vst.n2 vss 0.474215f
C980 vst.t0 vss 0.827473f
C981 vbn_vco.t0 vss 0.324187f
C982 vbn_vco.t1 vss 0.329617f
C983 vbn_vco.t4 vss 0.137198f
C984 vbn_vco.n0 vss 0.228825f
C985 vbn_vco.n1 vss 0.18613f
C986 vbn_vco.t2 vss 0.139131f
C987 vbn_vco.n2 vss 0.077924f
C988 vbn_vco.n3 vss 0.447691f
C989 vbn_vco.n4 vss 0.077924f
C990 vbn_vco.n5 vss 0.0608615f
C991 vbn_vco.n6 vss 0.077924f
C992 vbn_vco.n7 vss 0.0608615f
C993 vbn_vco.n8 vss 0.077924f
C994 vbn_vco.n9 vss 0.0973327f
C995 vbn_vco.n10 vss 0.0817626f
C996 vbn_vco.n11 vss 0.335948f
C997 vbn_vco.n12 vss 0.322371f
C998 vnt.t0 vss 0.302096f
C999 vnt.t6 vss 0.227456f
C1000 vnt.t5 vss 0.302096f
C1001 vnt.n0 vss 0.16041f
C1002 vnt.t7 vss 0.22142f
C1003 vnt.n1 vss 0.235666f
C1004 vnt.t1 vss 0.199425f
C1005 vnt.n2 vss 0.198989f
C1006 vnt.t3 vss 0.199425f
C1007 vnt.n3 vss 0.186871f
C1008 vnt.t4 vss 0.199425f
C1009 vnt.n4 vss 0.29828f
C1010 vnt.t2 vss 0.211375f
C1011 vnt.n5 vss 0.0938124f
C1012 vi.t1 vss 0.166655f
C1013 vi.t0 vss 0.225208f
C1014 vi.t4 vss 0.162116f
C1015 vi.n0 vss 0.211198f
C1016 vi.t3 vss 0.162285f
C1017 vi.n1 vss 0.0719475f
C1018 vi.t2 vss 0.173294f
C1019 vi.n2 vss 0.147101f
C1020 a_14928_1350.t1 vss 0.017186f
C1021 a_14928_1350.t3 vss 0.0108296f
C1022 a_14928_1350.t2 vss 0.010844f
C1023 a_14928_1350.n0 vss 0.0164567f
C1024 a_14928_1350.n1 vss 0.0212336f
C1025 a_14928_1350.t0 vss 0.0067849f
C1026 a_14928_1350.n2 vss 0.0101729f
C1027 a_15612_1350.t1 vss 0.00530447f
C1028 a_15612_1350.t3 vss 0.00336139f
C1029 a_15612_1350.t2 vss 0.00336575f
C1030 a_15612_1350.n0 vss 0.00503011f
C1031 a_15612_1350.n1 vss 0.00649026f
C1032 a_15612_1350.t0 vss 0.00212506f
C1033 a_15612_1350.n2 vss 0.00310943f
C1034 a_16296_1350.t2 vss 0.00204838f
C1035 a_16296_1350.n0 vss 0.00302343f
C1036 a_16296_1350.t1 vss 0.00329119f
C1037 a_16296_1350.t0 vss 0.00329562f
C1038 a_16296_1350.n1 vss 0.00489085f
C1039 a_16296_1350.n2 vss 0.00631064f
C1040 a_16296_1350.t3 vss 0.00513981f
C1041 a_16980_1350.t1 vss 0.00507585f
C1042 a_16980_1350.t3 vss 0.00331675f
C1043 a_16980_1350.t2 vss 0.00332122f
C1044 a_16980_1350.n0 vss 0.00492938f
C1045 a_16980_1350.n1 vss 0.00636029f
C1046 a_16980_1350.t0 vss 0.00196039f
C1047 a_16980_1350.n2 vss 0.00304723f
C1048 a_17664_1350.t1 vss 0.0116245f
C1049 a_17664_1350.t3 vss 0.00756616f
C1050 a_17664_1350.t2 vss 0.00757611f
C1051 a_17664_1350.n0 vss 0.0109997f
C1052 a_17664_1350.n1 vss 0.0141929f
C1053 a_17664_1350.t0 vss 0.00467211f
C1054 a_17664_1350.n2 vss 0.00679967f
C1055 r2.t2 vss 0.036363f
C1056 r2.n0 vss 0.0740822f
C1057 r2.n1 vss 0.102617f
C1058 r2.n2 vss 0.0619698f
C1059 r2.n3 vss 0.048712f
C1060 r2.n4 vss 0.0661621f
C1061 r2.t0 vss 0.0204854f
C1062 r2.t1 vss 0.0205316f
C1063 r2.n5 vss 0.0288383f
C1064 r2.t3 vss 0.0364034f
C1065 r1.t0 vss 0.029958f
C1066 r1.n0 vss 0.0682567f
C1067 r1.n1 vss 0.0945662f
C1068 r1.n2 vss 0.0571727f
C1069 r1.n3 vss 0.0428676f
C1070 r1.n4 vss 0.0619603f
C1071 r1.t1 vss 0.0167241f
C1072 r1.t2 vss 0.0167593f
C1073 r1.n5 vss 0.0249038f
C1074 r1.t3 vss 0.0299907f
C1075 r3.t2 vss 0.0322068f
C1076 r3.n0 vss 0.0648515f
C1077 r3.n1 vss 0.0939649f
C1078 r3.n2 vss 0.054286f
C1079 r3.n3 vss 0.0448787f
C1080 r3.n4 vss 0.0609393f
C1081 r3.t1 vss 0.0180971f
C1082 r3.t0 vss 0.0181359f
C1083 r3.n5 vss 0.0270433f
C1084 r3.t3 vss 0.0321731f
C1085 r5.t0 vss 0.0411585f
C1086 r5.n0 vss 0.0782953f
C1087 r5.n1 vss 0.109148f
C1088 r5.n2 vss 0.065541f
C1089 r5.n3 vss 0.0541821f
C1090 r5.n4 vss 0.0747666f
C1091 r5.n5 vss 0.0585047f
C1092 r5.n6 vss 0.0577213f
C1093 r5.n7 vss 0.0723955f
C1094 r5.n8 vss 0.0466002f
C1095 r5.t2 vss 0.0232564f
C1096 r5.t3 vss 0.0233123f
C1097 r5.n9 vss 0.0326499f
C1098 r5.t1 vss 0.0411096f
C1099 r4.t2 vss 0.0315517f
C1100 r4.n0 vss 0.0650313f
C1101 r4.n1 vss 0.0914405f
C1102 r4.n2 vss 0.0543979f
C1103 r4.n3 vss 0.0427599f
C1104 r4.n4 vss 0.0594361f
C1105 r4.t1 vss 0.0177316f
C1106 r4.t0 vss 0.0177698f
C1107 r4.n5 vss 0.0253131f
C1108 r4.t3 vss 0.0315161f
C1109 nb.t5 vss 0.0252978f
C1110 nb.n0 vss 0.0709394f
C1111 nb.t2 vss 0.0253407f
C1112 nb.t1 vss 0.0253835f
C1113 nb.n1 vss 0.0462114f
C1114 nb.t3 vss 0.0252748f
C1115 nb.t0 vss 0.0253176f
C1116 nb.n2 vss 0.0398507f
C1117 nb.n3 vss 0.100533f
C1118 nb.n4 vss 0.0617524f
C1119 nb.n5 vss 0.0556915f
C1120 nb.n6 vss 0.0608235f
C1121 nb.n7 vss 0.0751557f
C1122 nb.n8 vss 0.0878178f
C1123 nb.n9 vss 0.0899193f
C1124 nb.t4 vss 0.0252517f
C1125 dqb.t0 vss 0.0948489f
C1126 dqb.n0 vss 0.113176f
C1127 dqb.n1 vss 0.0645929f
C1128 dqb.n2 vss 0.0484305f
C1129 dqb.n3 vss 0.0638902f
C1130 dqb.t1 vss 0.0424989f
C1131 vco_out.t0 vss 0.0310811f
C1132 vco_out.n0 vss 0.0674541f
C1133 vco_out.n1 vss 0.0995675f
C1134 vco_out.t4 vss 0.0310893f
C1135 vco_out.t2 vss 0.031122f
C1136 vco_out.n2 vss 0.0875512f
C1137 vco_out.n3 vss 0.0865408f
C1138 vco_out.n4 vss 0.109214f
C1139 vco_out.n5 vss 0.024501f
C1140 vco_out.n6 vss 0.152562f
C1141 vco_out.t3 vss 0.0310893f
C1142 vco_out.t5 vss 0.031122f
C1143 vco_out.n7 vss 0.06783f
C1144 vco_out.t1 vss 0.0310512f
C1145 dqn.t0 vss 0.0892545f
C1146 dqn.n0 vss 0.115798f
C1147 dqn.n1 vss 0.12932f
C1148 dqn.t1 vss 0.114636f
C1149 dqn.n2 vss 0.0853273f
C1150 dqn.n3 vss 0.118619f
C1151 dqn.n4 vss 0.0329159f
C1152 dqn.t2 vss 0.027487f
C1153 dy.t0 vss 0.0852462f
C1154 dy.n0 vss 0.111308f
C1155 dy.n1 vss 0.109412f
C1156 dy.t1 vss 0.0732357f
C1157 dx.t0 vss 0.116978f
C1158 dx.t1 vss 0.0502194f
C1159 dx.n0 vss 0.115726f
C1160 a_14932_0.t0 vss 0.0302875f
C1161 a_14932_0.n0 vss 0.0286161f
C1162 a_14932_0.t1 vss 0.044693f
C1163 a_14932_0.t2 vss 0.0238193f
C1164 a_14932_0.n1 vss 0.020825f
C1165 a_14932_0.n2 vss 0.104129f
C1166 a_14932_0.t3 vss 0.0303849f
C1167 a_15616_0.t0 vss 0.0390187f
C1168 a_15616_0.t1 vss 0.0205896f
C1169 a_15616_0.n0 vss 0.0183886f
C1170 a_15616_0.t2 vss 0.0255389f
C1171 a_15616_0.t3 vss 0.0256197f
C1172 a_15616_0.n1 vss 0.0252653f
C1173 a_15616_0.n2 vss 0.091943f
C1174 a_16300_0.t0 vss 0.0256558f
C1175 a_16300_0.n0 vss 0.0251189f
C1176 a_16300_0.t1 vss 0.0385539f
C1177 a_16300_0.t2 vss 0.0202337f
C1178 a_16300_0.n1 vss 0.0182796f
C1179 a_16300_0.n2 vss 0.0914044f
C1180 a_16300_0.t3 vss 0.0255746f
C1181 a_16984_0.t0 vss 0.0257996f
C1182 a_16984_0.n0 vss 0.0252382f
C1183 a_16984_0.t3 vss 0.0374805f
C1184 a_16984_0.t1 vss 0.0190761f
C1185 a_16984_0.n1 vss 0.0183697f
C1186 a_16984_0.n2 vss 0.0918453f
C1187 a_16984_0.t2 vss 0.0258816f
C1188 a_17668_0.t0 vss 0.0301299f
C1189 a_17668_0.n0 vss 0.0253906f
C1190 a_17668_0.t2 vss 0.0416876f
C1191 a_17668_0.t3 vss 0.0231576f
C1192 a_17668_0.n1 vss 0.0184799f
C1193 a_17668_0.n2 vss 0.0923995f
C1194 a_17668_0.t1 vss 0.0300337f
C1195 a_18352_n100.t2 vss 0.028703f
C1196 a_18352_n100.n0 vss 0.0253096f
C1197 a_18352_n100.t0 vss 0.059475f
C1198 a_18352_n100.n1 vss 0.0808111f
C1199 a_18352_n100.t1 vss 0.0325739f
C1200 a_18352_n100.n2 vss 0.0275531f
C1201 a_18352_n100.t3 vss 0.0287698f
C1202 a_21350_n100.t0 vss 0.0628193f
C1203 a_22044_n100.t0 vss 0.0452351f
C1204 a_22044_n100.n0 vss 0.0620275f
C1205 a_22044_n100.t1 vss 0.094197f
C1206 vss.t29 vss 0.11221p
C1207 vss.t173 vss 25.2625f
C1208 vss.t88 vss 0.21135f
C1209 vss.t64 vss 0.31087f
C1210 vss.t154 vss 0.31087f
C1211 vss.t48 vss 0.21135f
C1212 vss.t136 vss 0.25439f
C1213 vss.t18 vss 0.24672f
C1214 vss.t130 vss 0.24672f
C1215 vss.t123 vss 0.24672f
C1216 vss.t141 vss 0.24672f
C1217 vss.t110 vss 0.24672f
C1218 vss.t80 vss 0.19389f
C1219 vss.t143 vss 0.19389f
C1220 vss.t78 vss 0.39809f
C1221 vss.t125 vss 0.07921f
C1222 vss.t53 vss 0.0789f
C1223 vss.t90 vss 0.0789f
C1224 vss.t117 vss 0.10028f
C1225 vss.t14 vss 0.09148f
C1226 vss.t99 vss 0.65663f
C1227 vss.t119 vss 0.73277f
C1228 vss.t157 vss 0.73277f
C1229 vss.t138 vss 0.73277f
C1230 vss.t145 vss 0.73277f
C1231 vss.t150 vss 0.65663f
C1232 vss.t86 vss 0.72678f
C1233 vss.t67 vss 0.1302f
C1234 vss.t168 vss 0.09017f
C1235 vss.t160 vss 0.70367f
C1236 vss.t71 vss 0.6707f
C1237 vss.t76 vss 0.66776f
C1238 vss.t74 vss 0.66776f
C1239 vss.t92 vss 0.67506f
C1240 vss.t83 vss 0.02671f
C1241 vss.t133 vss 0.0266f
C1242 vss.t121 vss 0.03475f
C1243 vss.t102 vss 0.0474f
C1244 vss.t10 vss 0.05269f
C1245 vss.t181 vss 0.03475f
C1246 vss.t12 vss 0.05421f
C1247 vss.t69 vss 0.05409f
C1248 vss.t166 vss 0.04253f
C1249 vss.t164 vss 0.0424f
C1250 vss.t5 vss 0.06043f
C1251 vss.t50 vss 0.06018f
C1252 vss.t107 vss 0.06043f
C1253 vss.t20 vss 0.06018f
C1254 vss.t22 vss 0.06043f
C1255 vss.t170 vss 0.06018f
C1256 vss.t172 vss 0.06043f
C1257 vss.t113 vss 0.06018f
C1258 vss.t115 vss 0.06043f
C1259 vss.t62 vss 0.06018f
C1260 vdd.t7 vss 1.2554f
C1261 vdd.n0 vss 1.54917f
C1262 vdd.t20 vss 1.30173f
C1263 vdd.n1 vss 0.0591837f
C1264 vdd.t47 vss 1.30173f
C1265 vdd.n2 vss 0.0601453f
C1266 vdd.n3 vss 0.171727f
C1267 vdd.t70 vss 1.2554f
C1268 vdd.n4 vss 0.0499937f
C1269 vdd.t43 vss 0.843965f
C1270 vdd.n5 vss 0.13149f
C1271 vdd.t61 vss 0.824269f
C1272 vdd.n6 vss 0.13246f
C1273 vdd.n7 vss 0.171727f
C1274 vdd.t94 vss 0.824269f
C1275 vdd.n8 vss 0.1223f
C1276 vdd.t55 vss 0.824269f
C1277 vdd.n9 vss 0.13149f
C1278 vdd.t92 vss 0.824269f
C1279 vdd.n10 vss 0.13246f
C1280 vdd.n11 vss 0.171727f
C1281 vdd.t37 vss 0.824269f
C1282 vdd.n12 vss 0.1223f
C1283 vdd.t104 vss 0.574789f
C1284 vdd.n13 vss 0.13149f
C1285 vdd.t63 vss 0.824269f
C1286 vdd.n14 vss 0.116366f
C1287 vdd.n15 vss 0.170757f
C1288 vdd.t51 vss 0.824269f
C1289 vdd.n16 vss 0.1223f
C1290 vdd.t27 vss 0.824269f
C1291 vdd.n17 vss 0.13149f
C1292 vdd.t90 vss 0.824269f
C1293 vdd.n18 vss 0.13246f
C1294 vdd.n19 vss 0.171727f
C1295 vdd.t5 vss 0.824269f
C1296 vdd.n20 vss 0.1223f
C1297 vdd.t14 vss 0.824269f
C1298 vdd.n21 vss 0.13149f
C1299 vdd.t88 vss 0.843965f
C1300 vdd.n22 vss 1.63546f
C1301 vdd.n23 vss 1.68218f
C1302 vdd.n24 vss 1.68218f
C1303 vdd.n25 vss 1.68218f
C1304 vdd.n26 vss 1.68218f
C1305 vdd.n27 vss 1.68218f
C1306 vdd.t4 vss 1.88914f
C1307 vdd.t6 vss 2.19214f
C1308 vdd.t13 vss 2.16589f
C1309 vdd.t19 vss 2.16589f
C1310 vdd.t26 vss 2.16589f
C1311 vdd.t36 vss 1.88914f
C1312 vdd.t42 vss 2.16589f
C1313 vdd.t46 vss 1.88914f
C1314 vdd.t50 vss 1.88914f
C1315 vdd.t54 vss 2.16589f
C1316 vdd.t60 vss 1.88914f
C1317 vdd.t62 vss 1.88914f
C1318 vdd.t69 vss 1.88914f
C1319 vdd.t87 vss 2.19847f
C1320 vdd.t89 vss 1.88914f
C1321 vdd.t91 vss 1.88914f
C1322 vdd.t93 vss 1.88914f
C1323 vdd.t103 vss 2.16589f
C1324 vdd.n28 vss 0.332569f
C1325 vdd.n29 vss 0.645835f
C1326 vdd.n30 vss 0.112023f
C1327 vdd.t41 vss 0.41866f
C1328 vdd.n31 vss 0.0447287f
C1329 vdd.t57 vss 0.49613f
C1330 vdd.n32 vss 0.0539187f
C1331 vdd.t100 vss 0.49613f
C1332 vdd.n33 vss 0.0548803f
C1333 vdd.n34 vss 0.0711482f
C1334 vdd.t65 vss 0.41866f
C1335 vdd.n35 vss 0.0447287f
C1336 vdd.t31 vss 0.125548f
C1337 vdd.n36 vss 0.0568271f
C1338 vdd.t10 vss 0.128716f
C1339 vdd.n37 vss 0.0442715f
C1340 vdd.t77 vss 0.0803382f
C1341 vdd.n38 vss 0.0549591f
C1342 vdd.t81 vss 0.0775087f
C1343 vdd.n39 vss 0.0594596f
C1344 vdd.n40 vss 0.0650004f
C1345 vdd.t83 vss 0.0993253f
C1346 vdd.n41 vss 0.047637f
C1347 vdd.t18 vss 1.0876f
C1348 vdd.n42 vss 0.0563857f
C1349 vdd.n43 vss 0.116673f
C1350 vdd.t29 vss 0.205224f
C1351 vdd.n44 vss 0.0569217f
C1352 vdd.t3 vss 0.221752f
C1353 vdd.n45 vss 0.0392903f
C1354 vdd.t1 vss 0.221752f
C1355 vdd.n46 vss 0.0402598f
C1356 vdd.n47 vss 0.0657886f
C1357 vdd.t72 vss 0.205224f
C1358 vdd.n48 vss 0.0354677f
C1359 vdd.t79 vss 0.097276f
C1360 vdd.n49 vss 0.475488f
C1361 vdd.n50 vss 0.379946f
C1362 vdd.n51 vss 0.410873f
C1363 vdd.n52 vss 0.441809f
C1364 vdd.n53 vss 0.335406f
C1365 vdd.n54 vss 0.642856f
C1366 vdd.n55 vss 0.34901f
C1367 vdd.t0 vss 0.346425f
C1368 vdd.t2 vss 0.371173f
C1369 vdd.t8 vss 0.346425f
C1370 vdd.t9 vss 0.343958f
C1371 vdd.t17 vss 0.927314f
C1372 vdd.t24 vss 0.433037f
C1373 vdd.t25 vss 0.433037f
C1374 vdd.t28 vss 0.371173f
C1375 vdd.t30 vss 0.397159f
C1376 vdd.t32 vss 0.371173f
C1377 vdd.t35 vss 0.433037f
C1378 vdd.t40 vss 0.485616f
C1379 vdd.t44 vss 0.433037f
C1380 vdd.t56 vss 0.556764f
C1381 vdd.t64 vss 0.432414f
C1382 vdd.t71 vss 0.339623f
C1383 vdd.t76 vss 0.343958f
C1384 vdd.t80 vss 0.326011f
C1385 vdd.t82 vss 0.626667f
C1386 vdd.t78 vss 0.356434f
C1387 vdd.t95 vss 0.418188f
C1388 vdd.t96 vss 0.392824f
C1389 vdd.t97 vss 0.392824f
C1390 vdd.t98 vss 0.392824f
C1391 vdd.t99 vss 0.485616f
C1392 vdd.n56 vss 0.178261f
C1393 vdd.n57 vss 0.0973864f
C1394 vdd.n58 vss 2.73767f
C1395 vdd.n59 vss 0.0248195f
C1396 vdd.n60 vss 0.0248195f
C1397 vdd.n61 vss 0.022455f
C1398 vdd.n62 vss 0.0355465f
C1399 vdd.n63 vss 0.02385f
C1400 vdd.t21 vss 5.09967f
C1401 vdd.t15 vss 3.44451f
C1402 vdd.t74 vss 1.56122f
C1403 vdd.t11 vss 0.559175f
C1404 vdd.t86 vss 0.170938f
C1405 vdd.n64 vss 0.0644408f
C1406 vdd.t85 vss 0.171167f
C1407 vdd.n65 vss 0.0578438f
C1408 vdd.t59 vss 0.170938f
C1409 vdd.n66 vss 0.0574734f
C1410 vdd.t58 vss 0.171167f
C1411 vdd.n67 vss 0.0455641f
C1412 vdd.t67 vss 0.170938f
C1413 vdd.n68 vss 0.0578438f
C1414 vdd.t66 vss 0.171167f
C1415 vdd.n69 vss 0.0578438f
C1416 vdd.t49 vss 0.170938f
C1417 vdd.n70 vss 0.0578438f
C1418 vdd.t48 vss 0.171167f
C1419 vdd.n71 vss 0.0578438f
C1420 vdd.t23 vss 0.170938f
C1421 vdd.n72 vss 0.0453513f
C1422 vdd.t22 vss 0.171167f
C1423 vdd.n73 vss 0.0576862f
C1424 vdd.t38 vss 0.0727324f
C1425 vdd.n74 vss 0.0818121f
C1426 vdd.t34 vss 0.0728427f
C1427 vdd.n75 vss 0.0818121f
C1428 vdd.t84 vss 0.0725275f
C1429 vdd.n76 vss 0.0802515f
C1430 vdd.t73 vss 0.0726299f
C1431 vdd.n77 vss 0.0730634f
C1432 vdd.t33 vss 0.0976543f
C1433 vdd.n78 vss 0.0775402f
C1434 vdd.t53 vss 0.0977489f
C1435 vdd.n79 vss 0.0775402f
C1436 vdd.t52 vss 0.0976543f
C1437 vdd.n80 vss 0.0775402f
C1438 vdd.t16 vss 0.0977489f
C1439 vdd.n81 vss 0.0775402f
C1440 vdd.t68 vss 0.0780998f
C1441 vdd.n82 vss 0.0752151f
C1442 vdd.t12 vss 0.0872032f
C1443 vdd.n83 vss 0.0972051f
C1444 vdd.t75 vss 0.040977f
C1445 vdd.n84 vss 0.0993962f
C1446 vdd.t101 vss 0.0777451f
C1447 vdd.n85 vss 0.0776821f
C1448 vdd.t102 vss 0.0780998f
C1449 vdd.n86 vss 0.089213f
C1450 vdd.t45 vss 0.0886534f
C1451 vdd.n87 vss 0.163561f
C1452 vdd.t39 vss 0.0937608f
C1453 vdd.n88 vss 0.00993883f
C1454 vdd.n89 vss 0.713807f
C1455 vctrl.n0 vss 0.224645f
C1456 vctrl.n1 vss 0.125336f
C1457 vctrl.n2 vss 0.410475f
C1458 vctrl.t0 vss 0.427716f
C1459 vctrl.n3 vss 0.0419277f
C1460 vctrl.n4 vss 0.256437f
C1461 vctrl.t1 vss 0.322544f
C1462 vctrl.n5 vss 2.73279f
C1463 vctrl.t2 vss 0.12242f
C1464 vctrl.n6 vss 0.442722f
C1465 vctrl.n7 vss 0.26308f
C1466 vctrl.n8 vss 0.446062f
C1467 vctrl.n9 vss 0.364252f
C1468 vctrl.n10 vss 0.310114f
C1469 pfd_dn.n0 vss 1.38886f
C1470 pfd_dn.n1 vss 1.37372f
C1471 cp_trim0.n0 vss 1.40116f
C1472 cp_trim1.n0 vss 1.57636f
C1473 pfd_up.n0 vss 0.976997f
C1474 pfd_up.n1 vss 1.96189f
C1475 pll_en.n0 vss 0.320004f
C1476 pll_en.n1 vss 0.0665493f
C1477 pll_en.n2 vss 0.0691076f
C1478 pll_en.n3 vss 0.0797782f
C1479 pll_en.n4 vss 0.297947f
C1480 pll_en.n5 vss 0.459535f
C1481 pll_en.n6 vss 0.491821f
C1482 pll_en.n7 vss 0.723488f
C1483 pll_en.n8 vss 2.2041f
C1484 pll_en.n9 vss 0.6449f
C1485 pll_en.n10 vss 0.685731f
C1486 bias_ref.t1 vss 0.035598f
C1487 bias_ref.t0 vss 0.0182822f
C1488 bias_ref.n0 vss 0.536173f
C1489 vco_div2.t2 vss 0.0307117f
C1490 vco_div2.t1 vss 0.0307451f
C1491 vco_div2.n0 vss 0.0649055f
C1492 vco_div2.t3 vss 0.0172844f
C1493 vco_div2.t0 vss 0.0173252f
C1494 vco_div2.n1 vss 0.0236806f
C1495 vco_div2.n2 vss 0.103714f
.ends
