* NGSPICE file created from pll_analog.ext - technology: gf180mcuD

.subckt pll_analog vco_div2 pfd_up pfd_dn pll_en cp_trim0 cp_trim1 vctrl bias_ref
+ vdd vss
X0 va.t0 vbp.t11 vdd.t32 vdd.t31 pfet_03v3 ad=2.6p pd=9.3u as=2.6p ps=9.3u w=4u l=2u
X1 a_7800_17156 a_7200_11024 vss.t148 ppolyf_u r_width=1u r_length=30u
X2 a_16296_1350.t1 r3.t6 r4.t3 vdd.t43 pfet_03v3 ad=1.95p pd=7.3u as=0.78p ps=3.52u w=3u l=0.28u
X3 vnt.t5 vref.t8 vss.t143 vss.t142 nfet_03v3 ad=1.22p pd=5.22u as=1.22p ps=5.22u w=2u l=2u
X4 vcl.t0 vref.t14 vss.t10 vss.t9 nfet_03v3 ad=7.625p pd=26.22u as=7.625p ps=26.22u w=12.5u l=1u
X5 t2.t0 vbp.t9 vdd.t7 vdd.t6 pfet_03v3 ad=2.6p pd=9.3u as=2.6p ps=9.3u w=4u l=2u
X6 vdd.t58 nb.t10 vco_out.t0 vdd.t43 pfet_03v3 ad=1.95p pd=7.3u as=0.78p ps=3.52u w=3u l=0.28u
X7 vctrl.t11 vss.t55 cap_nmos_03v3_b c_width=43u c_length=12u
X8 r4.t0 r3.t7 a_16296_1350.t0 vdd.t43 pfet_03v3 ad=0.78p pd=3.52u as=1.95p ps=7.3u w=3u l=0.28u
X9 vcl.t4 vref.t11 vss.t158 vss.t157 nfet_03v3 ad=7.625p pd=26.22u as=7.625p ps=26.22u w=12.5u l=1u
X10 vss.t126 nb.t6 vco_out.t2 vss.t125 nfet_03v3 ad=1.83p pd=7.22u as=0.78p ps=3.52u w=3u l=0.28u
X11 vbh.t5 vbh.t4 vdd.t93 vdd.t92 pfet_03v3 ad=2.6p pd=9.3u as=2.6p ps=9.3u w=4u l=2u
X12 vbp.t2 vst.t4 vss.t174 vss.t173 nfet_03v3 ad=0.305p pd=2.22u as=0.305p ps=2.22u w=0.5u l=4u
X13 vcp_n.t2 vbp.t16 vdd.t34 vdd.t33 pfet_03v3 ad=2.6p pd=9.3u as=2.6p ps=9.3u w=4u l=2u
X14 dn_b.t0 pfd_dn.t1 vss.t133 vss.t132 nfet_03v3 ad=0.61p pd=3.22u as=0.61p ps=3.22u w=1u l=0.28u
X15 a_13200_18476 a_13800_11024 vss.t162 ppolyf_u r_width=1u r_length=36.6u
X16 vbp.t1 va.t3 vref.t1 vss.t149 nfet_03v3 ad=2.44p pd=9.22u as=2.44p ps=9.22u w=4u l=1u
X17 vfilt vss.t83 cap_nmos_03v3_b c_width=35u c_length=12u
X18 vcl.t3 a_4200_11024 vss.t36 ppolyf_u r_width=1u r_length=21.5u
X19 vref.t2 en_b.t3 vss.t153 vss.t152 nfet_03v3 ad=0.61p pd=3.22u as=0.61p ps=3.22u w=1u l=0.28u
X20 vss.t54 vbn_vco.t5 a_17668_0.t1 vss.t53 nfet_03v3 ad=1.22p pd=5.22u as=0.52p ps=2.52u w=2u l=0.5u
X21 vfilt vss.t65 cap_nmos_03v3_b c_width=35u c_length=12u
X22 vcp_n.t7 vcp_n.t6 vss.t48 vss.t47 nfet_03v3 ad=6.1p pd=21.22u as=6.1p ps=21.22u w=10u l=2u
X23 vcp_n.t10 cp_trim0.t1 t1a.t1 vss.t144 nfet_03v3 ad=1.22p pd=5.22u as=1.22p ps=5.22u w=2u l=0.28u
X24 dx.t0 dqn.t4 vss.t151 vss.t150 nfet_03v3 ad=0.61p pd=3.22u as=0.61p ps=3.22u w=1u l=0.28u
X25 vfilt a_2000_11024 vss.t177 ppolyf_u r_width=2u r_length=37.5u
X26 vdd.t74 vbp_vco.t9 a_16980_1350.t2 vdd.t24 pfet_03v3 ad=3.25p pd=11.3u as=1.3p ps=5.52u w=5u l=0.5u
X27 a_10800_18476 a_10200_11024 vss.t118 ppolyf_u r_width=1u r_length=36.6u
X28 vfilt vss.t75 cap_nmos_03v3_b c_width=35u c_length=12u
X29 t1c.t1 cp_trim0.t0 t1b.t1 vss.t145 nfet_03v3 ad=1.22p pd=5.22u as=1.22p ps=5.22u w=2u l=0.28u
X30 vbl.t5 vctrl.t10 vbt.t6 vdd.t47 pfet_03v3 ad=3.25p pd=11.3u as=3.25p ps=11.3u w=5u l=1u
X31 vbl.t7 vctrl.t7 vbt.t9 vdd.t50 pfet_03v3 ad=3.25p pd=11.3u as=3.25p ps=11.3u w=5u l=1u
X32 dqn.t0 pll_en.t2 vdd.t22 vdd.t21 pfet_03v3 ad=0.325p pd=2.3u as=0.325p ps=2.3u w=0.5u l=0.28u
X33 vbh.t1 vctrl.t5 vnt.t2 vss.t58 nfet_03v3 ad=3.05p pd=11.22u as=3.05p ps=11.22u w=5u l=1u
X34 a_16296_1350.t3 vbp_vco.t12 vdd.t103 vdd.t24 pfet_03v3 ad=1.3p pd=5.52u as=3.25p ps=11.3u w=5u l=0.5u
X35 vfilt vss.t71 cap_nmos_03v3_b c_width=35u c_length=12u
X36 a_18352_n100.t2 r5.t4 nb.t2 vss.t92 nfet_03v3 ad=1.22p pd=5.22u as=0.52p ps=2.52u w=2u l=0.28u
X37 r5.t0 r4.t5 a_17668_0.t3 vss.t91 nfet_03v3 ad=0.39p pd=2.02u as=0.915p ps=4.22u w=1.5u l=0.28u
X38 vdump.t0 vbl.t9 vss.t147 vss.t146 nfet_03v3 ad=1.22p pd=5.22u as=1.22p ps=5.22u w=2u l=2u
X39 vbp_vco.t0 pll_en.t6 vi.t0 vss.t13 nfet_03v3 ad=3.05p pd=11.22u as=3.05p ps=11.22u w=5u l=0.28u
X40 vbl.t1 vbl.t0 vss.t62 vss.t61 nfet_03v3 ad=1.22p pd=5.22u as=1.22p ps=5.22u w=2u l=2u
X41 a_6600_17156 a_6000_11024 vss.t25 ppolyf_u r_width=1u r_length=30u
X42 vss.t52 a_15000_11024 vss.t51 ppolyf_u r_width=1u r_length=36.6u
X43 vdump.t11 vdump.t10 vbt.t2 vdd.t86 pfet_03v3 ad=3.25p pd=11.3u as=3.25p ps=11.3u w=5u l=1u
X44 up_b.t1 pfd_up.t1 vdd.t45 vdd.t44 pfet_03v3 ad=1.3p pd=5.3u as=1.3p ps=5.3u w=2u l=0.28u
X45 vfilt vss.t81 cap_nmos_03v3_b c_width=35u c_length=12u
X46 vcp_n.t3 vbp.t8 vdd.t36 vdd.t35 pfet_03v3 ad=2.6p pd=9.3u as=2.6p ps=9.3u w=4u l=2u
X47 vcl.t1 vref.t13 vss.t24 vss.t23 nfet_03v3 ad=7.625p pd=26.22u as=7.625p ps=26.22u w=12.5u l=1u
X48 vbn_vco.t2 vbp_vco.t17 vdd.t61 vdd.t60 pfet_03v3 ad=3.25p pd=11.3u as=3.25p ps=11.3u w=5u l=0.5u
X49 vco_div2.t3 dqb.t3 vss.t181 vss.t180 nfet_03v3 ad=0.39p pd=2.02u as=0.915p ps=4.22u w=1.5u l=0.28u
X50 vdd.t25 vbp_vco.t7 a_17664_1350.t0 vdd.t24 pfet_03v3 ad=3.25p pd=11.3u as=1.3p ps=5.52u w=5u l=0.5u
X51 a_12000_18476 a_12600_11024 vss.t30 ppolyf_u r_width=1u r_length=36.6u
X52 vco_div2.t2 dqb.t5 vdd.t101 vdd.t43 pfet_03v3 ad=0.78p pd=3.52u as=1.95p ps=7.3u w=3u l=0.28u
X53 dqb.t0 dqn.t3 vss.t179 vss.t178 nfet_03v3 ad=0.61p pd=3.22u as=0.61p ps=3.22u w=1u l=0.28u
X54 vco_out.t1 nb.t11 vdd.t59 vdd.t43 pfet_03v3 ad=0.78p pd=3.52u as=1.95p ps=7.3u w=3u l=0.28u
X55 vctrl.t1 pfd_dn.t2 dn_s.t3 vss.t131 nfet_03v3 ad=1.22p pd=5.22u as=1.22p ps=5.22u w=2u l=0.5u
X56 vco_out.t3 nb.t7 vss.t128 vss.t127 nfet_03v3 ad=0.78p pd=3.52u as=1.83p ps=7.22u w=3u l=0.28u
X57 a_7800_17156 a_8400_11024 vss.t7 ppolyf_u r_width=1u r_length=30u
X58 dx.t1 vco_out.t9 a_20918_1350.t0 vdd.t11 pfet_03v3 ad=1.3p pd=5.3u as=1.3p ps=5.3u w=2u l=0.28u
X59 a_17664_1350.t3 r4.t6 r5.t3 vdd.t43 pfet_03v3 ad=1.95p pd=7.3u as=0.78p ps=3.52u w=3u l=0.28u
X60 vbl.t4 vctrl.t9 vbt.t7 vdd.t48 pfet_03v3 ad=3.25p pd=11.3u as=3.25p ps=11.3u w=5u l=1u
X61 r3.t0 r2.t5 a_14932_0.t0 vss.t34 nfet_03v3 ad=0.39p pd=2.02u as=0.915p ps=4.22u w=1.5u l=0.28u
X62 vdump.t15 dn_b.t2 dn_s.t1 vss.t110 nfet_03v3 ad=1.22p pd=5.22u as=1.22p ps=5.22u w=2u l=0.5u
X63 vctrl.t2 up_b.t2 up_s.t3 vdd.t89 pfet_03v3 ad=2.6p pd=9.3u as=2.6p ps=9.3u w=4u l=0.5u
X64 vcp_p.t5 vcp_n.t15 vss.t137 vss.t136 nfet_03v3 ad=6.1p pd=21.22u as=6.1p ps=21.22u w=10u l=2u
X65 a_14928_1350.t1 r2.t6 r3.t1 vdd.t43 pfet_03v3 ad=1.95p pd=7.3u as=0.78p ps=3.52u w=3u l=0.28u
X66 a_14400_18476 a_13800_11024 vss.t135 ppolyf_u r_width=1u r_length=36.6u
X67 a_16984_0.t3 vbn_vco.t8 vss.t124 vss.t123 nfet_03v3 ad=0.52p pd=2.52u as=1.22p ps=5.22u w=2u l=0.5u
X68 a_15616_0.t3 r1.t4 r2.t2 vss.t129 nfet_03v3 ad=0.915p pd=4.22u as=0.39p ps=2.02u w=1.5u l=0.28u
X69 vdump.t13 vdump.t12 vbt.t0 vdd.t10 pfet_03v3 ad=3.25p pd=11.3u as=3.25p ps=11.3u w=5u l=1u
X70 a_20918_1350 dqn.t6 vdd.t88 vdd.t11 pfet_03v3 ad=1.3p pd=5.3u as=1.3p ps=5.3u w=2u l=0.28u
X71 vss.t18 pll_en.t0 a_18352_n100.t1 vss.t17 nfet_03v3 ad=1.22p pd=5.22u as=0.52p ps=2.52u w=2u l=0.28u
X72 vnt.t3 vref.t5 vss.t88 vss.t87 nfet_03v3 ad=1.22p pd=5.22u as=1.22p ps=5.22u w=2u l=2u
X73 vdd.t90 vbp_vco.t13 a_15612_1350.t2 vdd.t24 pfet_03v3 ad=3.25p pd=11.3u as=1.3p ps=5.52u w=5u l=0.5u
X74 vnt.t7 vref.t9 vss.t164 vss.t163 nfet_03v3 ad=1.22p pd=5.22u as=1.22p ps=5.22u w=2u l=2u
X75 en_b.t0 pll_en.t11 vss.t12 vss.t11 nfet_03v3 ad=0.61p pd=3.22u as=0.61p ps=3.22u w=1u l=0.28u
X76 r2.t1 r1.t5 a_15616_0.t0 vss.t31 nfet_03v3 ad=0.39p pd=2.02u as=0.915p ps=4.22u w=1.5u l=0.28u
X77 a_21350_n100 vco_out.t7 vss.t100 vss.t99 nfet_03v3 ad=1.22p pd=5.22u as=1.22p ps=5.22u w=2u l=0.28u
X78 vi.t4 vref.t10 vss.t166 vss.t165 nfet_03v3 ad=1.22p pd=5.22u as=1.22p ps=5.22u w=2u l=2u
X79 vdd.t23 pll_en.t3 nb.t1 vdd.t11 pfet_03v3 ad=1.3p pd=5.3u as=0.52p ps=2.52u w=2u l=0.28u
X80 a_17668_0.t0 vbn_vco.t6 vss.t28 vss.t27 nfet_03v3 ad=0.52p pd=2.52u as=1.22p ps=5.22u w=2u l=0.5u
X81 a_16980_1350.t1 r5.t10 r1.t2 vdd.t43 pfet_03v3 ad=1.95p pd=7.3u as=0.78p ps=3.52u w=3u l=0.28u
X82 dn_s.t0 vcp_n.t14 vss.t4 vss.t3 nfet_03v3 ad=6.1p pd=21.22u as=6.1p ps=21.22u w=10u l=2u
X83 a_10800_18476 a_11400_11024 vss.t22 ppolyf_u r_width=1u r_length=36.6u
X84 va.t2 en_b.t4 vss.t139 vss.t138 nfet_03v3 ad=0.61p pd=3.22u as=0.61p ps=3.22u w=1u l=0.28u
X85 vss.t42 vbn_vco.t9 a_16300_0.t0 vss.t41 nfet_03v3 ad=1.22p pd=5.22u as=0.52p ps=2.52u w=2u l=0.5u
X86 en_b.t1 pll_en.t8 vdd.t18 vdd.t17 pfet_03v3 ad=1.3p pd=5.3u as=1.3p ps=5.3u w=2u l=0.28u
X87 dqn.t2 dy.t3 vdd.t104 vdd.t11 pfet_03v3 ad=1.3p pd=5.3u as=1.3p ps=5.3u w=2u l=0.28u
X88 dn_s.t2 vcp_n.t13 vss.t104 vss.t103 nfet_03v3 ad=6.1p pd=21.22u as=6.1p ps=21.22u w=10u l=2u
X89 vcl.t2 vref.t12 vss.t33 vss.t32 nfet_03v3 ad=7.625p pd=26.22u as=7.625p ps=26.22u w=12.5u l=1u
X90 a_16300_0.t2 r3.t4 r4.t1 vss.t140 nfet_03v3 ad=0.915p pd=4.22u as=0.39p ps=2.02u w=1.5u l=0.28u
X91 r1.t3 r5.t11 a_16980_1350.t0 vdd.t43 pfet_03v3 ad=0.78p pd=3.52u as=1.95p ps=7.3u w=3u l=0.28u
X92 vi.t3 vctrl.t4 vs.t0 vss.t59 nfet_03v3 ad=3.05p pd=11.22u as=3.05p ps=11.22u w=5u l=1u
X93 a_15612_1350.t1 r1.t6 r2.t0 vdd.t43 pfet_03v3 ad=1.95p pd=7.3u as=0.78p ps=3.52u w=3u l=0.28u
X94 vst.t2 vref.t4 vss.t106 vss.t105 nfet_03v3 ad=3.05p pd=11.22u as=3.05p ps=11.22u w=5u l=1u
X95 r4.t2 r3.t5 a_16300_0.t3 vss.t141 nfet_03v3 ad=0.39p pd=2.02u as=0.915p ps=4.22u w=1.5u l=0.28u
X96 va.t1 vref.t7 vss.t168 vss.t167 nfet_03v3 ad=1.22p pd=5.22u as=1.22p ps=5.22u w=2u l=2u
X97 a_6600_17156 a_7200_11024 vss.t0 ppolyf_u r_width=1u r_length=30u
X98 vss.t170 vbn_vco.t13 a_14932_0.t2 vss.t169 nfet_03v3 ad=1.22p pd=5.22u as=0.52p ps=2.52u w=2u l=0.5u
X99 a_16984_0.t0 r5.t6 r1.t1 vss.t96 nfet_03v3 ad=0.915p pd=4.22u as=0.39p ps=2.02u w=1.5u l=0.28u
X100 vbp.t0 pll_en.t9 vdd.t16 vdd.t15 pfet_03v3 ad=0.65p pd=3.3u as=0.65p ps=3.3u w=1u l=0.28u
X101 vdd.t78 nb.t8 vco_out.t4 vdd.t43 pfet_03v3 ad=1.95p pd=7.3u as=0.78p ps=3.52u w=3u l=0.28u
X102 vdd.t80 r5.t8 nb.t4 vdd.t11 pfet_03v3 ad=1.3p pd=5.3u as=0.52p ps=2.52u w=2u l=0.28u
X103 vdd.t54 vbp_vco.t15 a_14928_1350.t2 vdd.t24 pfet_03v3 ad=3.25p pd=11.3u as=1.3p ps=5.52u w=5u l=0.5u
X104 vcp_n.t4 cp_trim1.t1 t2.t2 vss.t94 nfet_03v3 ad=1.22p pd=5.22u as=1.22p ps=5.22u w=2u l=0.28u
X105 vbl.t6 vctrl.t8 vbt.t8 vdd.t49 pfet_03v3 ad=3.25p pd=11.3u as=3.25p ps=11.3u w=5u l=1u
X106 vfilt vss.t69 cap_nmos_03v3_b c_width=35u c_length=12u
X107 a_15616_0.t2 vbn_vco.t12 vss.t40 vss.t39 nfet_03v3 ad=0.52p pd=2.52u as=1.22p ps=5.22u w=2u l=0.5u
X108 r1.t0 r5.t7 a_16984_0.t1 vss.t97 nfet_03v3 ad=0.39p pd=2.02u as=0.915p ps=4.22u w=1.5u l=0.28u
X109 vbn_vco.t1 vbn_vco.t0 vss.t109 vss.t108 nfet_03v3 ad=2.44p pd=9.22u as=2.44p ps=9.22u w=4u l=0.5u
X110 vst.t1 en_b.t6 vdd.t65 vdd.t64 pfet_03v3 ad=0.325p pd=2.3u as=0.325p ps=2.3u w=0.5u l=10u
X111 up_b.t0 pfd_up.t2 vss.t46 vss.t45 nfet_03v3 ad=0.61p pd=3.22u as=0.61p ps=3.22u w=1u l=0.28u
X112 vctrl.t0 a_400_11024 vss.t35 ppolyf_u r_width=2u r_length=37.5u
X113 a_13200_18476 a_12600_11024 vss.t134 ppolyf_u r_width=1u r_length=36.6u
X114 vs.t2 a_4200_11024 vss.t159 ppolyf_u r_width=1u r_length=21.5u
X115 vfilt vss.t79 cap_nmos_03v3_b c_width=35u c_length=12u
X116 a_16980_1350.t3 vbp_vco.t10 vdd.t75 vdd.t24 pfet_03v3 ad=1.3p pd=5.52u as=3.25p ps=11.3u w=5u l=0.5u
X117 vcp_n.t11 en_b.t7 vss.t155 vss.t154 nfet_03v3 ad=0.61p pd=3.22u as=0.61p ps=3.22u w=1u l=0.28u
X118 dqn.t1 vco_out.t6 a_22044_n100.t0 vss.t98 nfet_03v3 ad=1.22p pd=5.22u as=1.22p ps=5.22u w=2u l=0.28u
X119 r5.t2 r4.t7 a_17664_1350.t2 vdd.t43 pfet_03v3 ad=0.78p pd=3.52u as=1.95p ps=7.3u w=3u l=0.28u
X120 t1a.t0 vbp.t12 vdd.t38 vdd.t37 pfet_03v3 ad=2.6p pd=9.3u as=2.6p ps=9.3u w=4u l=2u
X121 vbn_vco.t3 vbp_vco.t18 vdd.t63 vdd.t62 pfet_03v3 ad=3.25p pd=11.3u as=3.25p ps=11.3u w=5u l=0.5u
X122 a_1200_18656 a_400_11024 vss.t156 ppolyf_u r_width=2u r_length=37.5u
X123 bias_ref.t0 a_10200_11024 vss.t2 ppolyf_u r_width=1u r_length=36.6u
X124 a_17668_0.t2 r4.t4 r5.t1 vss.t90 nfet_03v3 ad=0.915p pd=4.22u as=0.39p ps=2.02u w=1.5u l=0.28u
X125 dqb.t1 dqn.t5 vdd.t87 vdd.t11 pfet_03v3 ad=1.3p pd=5.3u as=1.3p ps=5.3u w=2u l=0.28u
X126 vfilt vss.t85 cap_nmos_03v3_b c_width=35u c_length=12u
X127 bias_ref.t1 a_8400_11024 vss.t89 ppolyf_u r_width=1u r_length=30u
X128 r3.t2 r2.t7 a_14928_1350.t0 vdd.t43 pfet_03v3 ad=0.78p pd=3.52u as=1.95p ps=7.3u w=3u l=0.28u
X129 vbp_vco.t2 pll_en.t7 vdd.t20 vdd.t19 pfet_03v3 ad=0.65p pd=3.3u as=0.65p ps=3.3u w=1u l=0.28u
X130 vbp_vco.t1 pll_en.t5 vi.t1 vss.t14 nfet_03v3 ad=3.05p pd=11.22u as=3.05p ps=11.22u w=5u l=0.28u
X131 dn_b.t1 pfd_dn.t0 vdd.t77 vdd.t76 pfet_03v3 ad=1.3p pd=5.3u as=1.3p ps=5.3u w=2u l=0.28u
X132 vfilt vss.t67 cap_nmos_03v3_b c_width=35u c_length=12u
X133 vdump.t9 vdump.t8 vbt.t1 vdd.t94 pfet_03v3 ad=3.25p pd=11.3u as=3.25p ps=11.3u w=5u l=1u
X134 vss.t112 dqb.t2 vco_div2.t0 vss.t111 nfet_03v3 ad=0.915p pd=4.22u as=0.39p ps=2.02u w=1.5u l=0.28u
X135 vbl.t3 vbl.t2 vss.t176 vss.t175 nfet_03v3 ad=1.22p pd=5.22u as=1.22p ps=5.22u w=2u l=2u
X136 vst.t0 vref.t3 vss.t50 vss.t49 nfet_03v3 ad=3.05p pd=11.22u as=3.05p ps=11.22u w=5u l=1u
X137 vref.t0 a_6000_11024 vss.t1 ppolyf_u r_width=1u r_length=30u
X138 a_14400_18476 a_15000_11024 vss.t8 ppolyf_u r_width=1u r_length=36.6u
X139 nb.t0 pll_en.t4 vdd.t12 vdd.t11 pfet_03v3 ad=0.52p pd=2.52u as=1.3p ps=5.3u w=2u l=0.28u
X140 a_17664_1350.t1 vbp_vco.t8 vdd.t26 vdd.t24 pfet_03v3 ad=1.3p pd=5.52u as=3.25p ps=11.3u w=5u l=0.5u
X141 vfilt vss.t77 cap_nmos_03v3_b c_width=35u c_length=12u
X142 nb.t3 r5.t5 a_18352_n100.t3 vss.t93 nfet_03v3 ad=0.52p pd=2.52u as=1.22p ps=5.22u w=2u l=0.28u
X143 vdump.t16 vbh.t7 vdd.t71 vdd.t70 pfet_03v3 ad=2.6p pd=9.3u as=2.6p ps=9.3u w=4u l=2u
X144 vss.t122 vbn_vco.t7 a_16984_0.t2 vss.t121 nfet_03v3 ad=1.22p pd=5.22u as=0.52p ps=2.52u w=2u l=0.5u
X145 vnt.t6 vref.t6 vss.t161 vss.t160 nfet_03v3 ad=1.22p pd=5.22u as=1.22p ps=5.22u w=2u l=2u
X146 dy.t0 dx.t2 a_21350_n100.t0 vss.t107 nfet_03v3 ad=1.22p pd=5.22u as=1.22p ps=5.22u w=2u l=0.28u
X147 up_s.t2 vcp_p.t8 vdd.t52 vdd.t51 pfet_03v3 ad=16.25p pd=51.3u as=16.25p ps=51.3u w=25u l=2u
X148 vbp_vco.t4 vbp_vco.t3 vdd.t3 vdd.t2 pfet_03v3 ad=3.25p pd=11.3u as=3.25p ps=11.3u w=5u l=0.5u
X149 vcp_p.t2 vcp_p.t1 vdd.t85 vdd.t84 pfet_03v3 ad=16.25p pd=51.3u as=16.25p ps=51.3u w=25u l=2u
X150 vbt.t4 vbp.t15 vdd.t28 vdd.t27 pfet_03v3 ad=2.6p pd=9.3u as=2.6p ps=9.3u w=4u l=2u
X151 vcp_p.t0 pll_en.t10 vdd.t14 vdd.t13 pfet_03v3 ad=0.65p pd=3.3u as=0.65p ps=3.3u w=1u l=0.28u
X152 a_14928_1350.t3 vbp_vco.t16 vdd.t55 vdd.t24 pfet_03v3 ad=1.3p pd=5.52u as=3.25p ps=11.3u w=5u l=0.5u
X153 vst.t3 en_b.t5 vss.t114 vss.t113 nfet_03v3 ad=0.61p pd=3.22u as=0.61p ps=3.22u w=1u l=0.28u
X154 vdump.t5 vdump.t4 vnt.t0 vss.t19 nfet_03v3 ad=3.05p pd=11.22u as=3.05p ps=11.22u w=5u l=1u
X155 a_12000_18476 a_11400_11024 vss.t26 ppolyf_u r_width=1u r_length=36.6u
X156 vbp_vco.t6 vbp_vco.t5 vdd.t57 vdd.t56 pfet_03v3 ad=3.25p pd=11.3u as=3.25p ps=11.3u w=5u l=0.5u
X157 r2.t3 r1.t7 a_15612_1350.t0 vdd.t43 pfet_03v3 ad=0.78p pd=3.52u as=1.95p ps=7.3u w=3u l=0.28u
X158 vbt.t11 vbp.t7 vdd.t83 vdd.t82 pfet_03v3 ad=2.6p pd=9.3u as=2.6p ps=9.3u w=4u l=2u
X159 a_1200_18656 a_2000_11024 vss.t29 ppolyf_u r_width=2u r_length=37.5u
X160 vdump.t3 vdump.t2 vbt.t3 vdd.t53 pfet_03v3 ad=3.25p pd=11.3u as=3.25p ps=11.3u w=5u l=1u
X161 vco_out.t5 nb.t9 vdd.t79 vdd.t43 pfet_03v3 ad=0.78p pd=3.52u as=1.95p ps=7.3u w=3u l=0.28u
X162 nb.t5 r5.t9 vdd.t81 vdd.t11 pfet_03v3 ad=0.52p pd=2.52u as=1.3p ps=5.3u w=2u l=0.28u
X163 up_s.t0 vcp_p.t7 vdd.t5 vdd.t4 pfet_03v3 ad=16.25p pd=51.3u as=16.25p ps=51.3u w=25u l=2u
X164 a_14932_0.t1 r2.t4 r3.t3 vss.t130 nfet_03v3 ad=0.915p pd=4.22u as=0.39p ps=2.02u w=1.5u l=0.28u
X165 vcp_p.t6 vcp_n.t12 vss.t21 vss.t20 nfet_03v3 ad=6.1p pd=21.22u as=6.1p ps=21.22u w=10u l=2u
X166 vcp_n.t0 vbp.t14 vdd.t9 vdd.t8 pfet_03v3 ad=2.6p pd=9.3u as=2.6p ps=9.3u w=4u l=2u
X167 a_16300_0.t1 vbn_vco.t10 vss.t44 vss.t43 nfet_03v3 ad=0.52p pd=2.52u as=1.22p ps=5.22u w=2u l=0.5u
X168 vcp_n.t1 vbp.t6 vdd.t30 vdd.t29 pfet_03v3 ad=2.6p pd=9.3u as=2.6p ps=9.3u w=4u l=2u
X169 vdump.t14 pfd_up.t0 up_s.t1 vdd.t46 pfet_03v3 ad=2.6p pd=9.3u as=2.6p ps=9.3u w=4u l=0.5u
X170 vdd.t102 vbp_vco.t11 a_16296_1350.t2 vdd.t24 pfet_03v3 ad=3.25p pd=11.3u as=1.3p ps=5.52u w=5u l=0.5u
X171 vdump.t1 vbl.t8 vss.t120 vss.t119 nfet_03v3 ad=1.22p pd=5.22u as=1.22p ps=5.22u w=2u l=2u
X172 vdump.t17 vbh.t6 vdd.t69 vdd.t68 pfet_03v3 ad=2.6p pd=9.3u as=2.6p ps=9.3u w=4u l=2u
X173 vbn_vco.t4 en_b.t2 vss.t116 vss.t115 nfet_03v3 ad=0.61p pd=3.22u as=0.61p ps=3.22u w=1u l=0.28u
X174 vfilt vss.t63 cap_nmos_03v3_b c_width=35u c_length=12u
X175 a_14932_0.t3 vbn_vco.t14 vss.t172 vss.t171 nfet_03v3 ad=0.52p pd=2.52u as=1.22p ps=5.22u w=2u l=0.5u
X176 vcp_p.t4 vcp_p.t3 vdd.t67 vdd.t66 pfet_03v3 ad=16.25p pd=51.3u as=16.25p ps=51.3u w=25u l=2u
X177 t2.t1 vbp.t13 vdd.t40 vdd.t39 pfet_03v3 ad=2.6p pd=9.3u as=2.6p ps=9.3u w=4u l=2u
X178 vbp.t4 vbp.t3 vdd.t99 vdd.t98 pfet_03v3 ad=2.6p pd=9.3u as=2.6p ps=9.3u w=4u l=2u
X179 a_15612_1350.t3 vbp_vco.t14 vdd.t91 vdd.t24 pfet_03v3 ad=1.3p pd=5.52u as=3.25p ps=11.3u w=5u l=0.5u
X180 vdump.t7 vdump.t6 vnt.t4 vss.t117 nfet_03v3 ad=3.05p pd=11.22u as=3.05p ps=11.22u w=5u l=1u
X181 vcp_n.t5 cp_trim1.t0 t1c.t0 vss.t95 nfet_03v3 ad=1.22p pd=5.22u as=1.22p ps=5.22u w=2u l=0.28u
X182 vss.t38 vbn_vco.t11 a_15616_0.t1 vss.t37 nfet_03v3 ad=1.22p pd=5.22u as=0.52p ps=2.52u w=2u l=0.5u
X183 vbh.t3 vbh.t2 vdd.t97 vdd.t96 pfet_03v3 ad=2.6p pd=9.3u as=2.6p ps=9.3u w=4u l=2u
X184 dy.t1 vco_out.t8 vdd.t95 vdd.t11 pfet_03v3 ad=1.3p pd=5.3u as=1.3p ps=5.3u w=2u l=0.28u
X185 t1b.t0 vbp.t10 vdd.t1 vdd.t0 pfet_03v3 ad=2.6p pd=9.3u as=2.6p ps=9.3u w=4u l=2u
X186 vbh.t0 vctrl.t6 vnt.t1 vss.t57 nfet_03v3 ad=3.05p pd=11.22u as=3.05p ps=11.22u w=5u l=1u
X187 a_22044_n100.t1 dy.t2 vss.t102 vss.t101 nfet_03v3 ad=1.22p pd=5.22u as=1.22p ps=5.22u w=2u l=0.28u
X188 vfilt vss.t73 cap_nmos_03v3_b c_width=35u c_length=12u
X189 vbt.t10 vbp.t5 vdd.t73 vdd.t72 pfet_03v3 ad=2.6p pd=9.3u as=2.6p ps=9.3u w=4u l=2u
X190 vcp_n.t9 vcp_n.t8 vss.t6 vss.t5 nfet_03v3 ad=6.1p pd=21.22u as=6.1p ps=21.22u w=10u l=2u
X191 vi.t2 vctrl.t3 vs.t1 vss.t60 nfet_03v3 ad=3.05p pd=11.22u as=3.05p ps=11.22u w=5u l=1u
X192 vdd.t100 dqb.t4 vco_div2.t1 vdd.t43 pfet_03v3 ad=1.95p pd=7.3u as=0.78p ps=3.52u w=3u l=0.28u
X193 vbt.t5 vbp.t17 vdd.t42 vdd.t41 pfet_03v3 ad=2.6p pd=9.3u as=2.6p ps=9.3u w=4u l=2u
X194 a_18352_n100.t0 pll_en.t1 vss.t16 vss.t15 nfet_03v3 ad=0.52p pd=2.52u as=1.22p ps=5.22u w=2u l=0.28u
R0 vco_div2 vco_div2.n2 9.7235
R1 vco_div2.n2 vco_div2.n1 8.19066
R2 vco_div2.n1 vco_div2.t3 1.0925
R3 vco_div2.n1 vco_div2.t0 1.0925
R4 vco_div2.n2 vco_div2.n0 7.10634
R5 vco_div2.n0 vco_div2.t2 0.607167
R6 vco_div2.n0 vco_div2.t1 0.607167
R7 bias_ref bias_ref.n0 37.1795
R8 bias_ref.n0 bias_ref.t0 20.1588
R9 bias_ref.n0 bias_ref.t1 22.9937
R10 pll_en pll_en.n0 7.4675
R11 pll_en.n4 pll_en.n3 4.5005
R12 pll_en.n4 pll_en.n10 10.184
R13 pll_en.n0 pll_en.n4 4.6145
R14 pll_en.n8 pll_en.n7 4.5005
R15 pll_en.n10 pll_en.n8 3.6275
R16 pll_en.n10 pll_en.n9 8.4965
R17 pll_en.n9 pll_en.t5 95.5714
R18 pll_en.n9 pll_en.t6 94.4689
R19 pll_en.n6 pll_en.n5 1.121
R20 pll_en.n7 pll_en.n6 5.531
R21 pll_en.n7 pll_en.t7 46.2098
R22 pll_en.n6 pll_en.t8 56.073
R23 pll_en.n5 pll_en.t9 43.2623
R24 pll_en.n5 pll_en.t10 43.8878
R25 pll_en.n8 pll_en.t11 72.5818
R26 pll_en.n3 pll_en.n2 5.53503
R27 pll_en.n2 pll_en.t0 45.7328
R28 pll_en.n2 pll_en.t1 45.5434
R29 pll_en.n3 pll_en.n1 4.94576
R30 pll_en.n1 pll_en.t3 45.7328
R31 pll_en.n1 pll_en.t4 45.5434
R32 pll_en.n0 pll_en.t2 35.435
R33 pfd_up.n0 pfd_up.n1 7.5875
R34 pfd_up pfd_up.n0 11.138
R35 pfd_up.n1 pfd_up.t2 71.1643
R36 pfd_up.n0 pfd_up.t0 55.5402
R37 pfd_up.n1 pfd_up.t1 57.2205
R38 cp_trim1 cp_trim1.n0 20.5475
R39 cp_trim1.n0 cp_trim1.t0 58.8043
R40 cp_trim1.n0 cp_trim1.t1 60.0193
R41 cp_trim0 cp_trim0.n0 21.155
R42 cp_trim0.n0 cp_trim0.t0 58.2643
R43 cp_trim0.n0 cp_trim0.t1 59.4793
R44 pfd_dn.n0 pfd_dn.n1 25.3692
R45 pfd_dn pfd_dn.n0 18.167
R46 pfd_dn.n1 pfd_dn.t1 45.7011
R47 pfd_dn.n1 pfd_dn.t2 47.76
R48 pfd_dn.n0 pfd_dn.t0 56.973
R49 vctrl.n4 vctrl.n3 4.5005
R50 vctrl.n10 vctrl.n9 4.5005
R51 vctrl vctrl.n10 18.2075
R52 vctrl.n10 vctrl.n4 3.6275
R53 vctrl.n4 vctrl.n6 10.823
R54 vctrl.n6 vctrl.n5 5.16875
R55 vctrl.n9 vctrl.n7 3.686
R56 vctrl.n9 vctrl.n8 16.8395
R57 vctrl.n8 vctrl.t3 40.7877
R58 vctrl.n8 vctrl.t4 40.0182
R59 vctrl.n7 vctrl.t5 40.0182
R60 vctrl.n7 vctrl.t6 42.3267
R61 vctrl.n6 vctrl.t0 24.3534
R62 vctrl.n5 vctrl.t1 20.8016
R63 vctrl.n5 vctrl.t11 61.6502
R64 vctrl.n1 vctrl.n0 1.283
R65 vctrl.n3 vctrl.n1 2.336
R66 vctrl.n3 vctrl.n2 0.0275
R67 vctrl.n2 vctrl.t2 24.6622
R68 vctrl.n2 vctrl.t7 40.1274
R69 vctrl.n1 vctrl.t8 40.1274
R70 vctrl.n0 vctrl.t9 40.1274
R71 vctrl.n0 vctrl.t10 42.4899
R72 vdd.n89 vdd.n88 4.5005
R73 vdd vdd.n89 21.2945
R74 vdd.n89 vdd.n28 28.6183
R75 vdd.n30 vdd.n29 3.6455
R76 vdd.n31 vdd.n30 0.43475
R77 vdd.n32 vdd.n31 1.013
R78 vdd.n33 vdd.n32 1.013
R79 vdd.n34 vdd.n33 1.07375
R80 vdd.n35 vdd.n34 0.43475
R81 vdd.n36 vdd.n35 1.013
R82 vdd.n37 vdd.n36 0.626
R83 vdd.n88 vdd.n37 0.22325
R84 vdd.n88 vdd.n38 0.40325
R85 vdd.n38 vdd.n39 0.626
R86 vdd.n39 vdd.n40 0.68675
R87 vdd.n40 vdd.n41 0.43475
R88 vdd.n41 vdd.n42 0.626
R89 vdd.n42 vdd.n56 0.28625
R90 vdd.n56 vdd.n43 2.588
R91 vdd.n43 vdd.n44 1.78475
R92 vdd.n44 vdd.n45 0.6755
R93 vdd.n45 vdd.n46 0.6755
R94 vdd.n46 vdd.n47 0.73625
R95 vdd.n47 vdd.n48 0.43475
R96 vdd.n48 vdd.n49 0.6755
R97 vdd.n56 vdd.n57 23.9203
R98 vdd.n57 vdd.n64 0.344
R99 vdd.n64 vdd.n65 0.3545
R100 vdd.n65 vdd.n66 0.1595
R101 vdd.n66 vdd.n59 0.344
R102 vdd.n59 vdd.n67 0.011
R103 vdd.n67 vdd.n68 0.1595
R104 vdd.n68 vdd.n69 0.3545
R105 vdd.n69 vdd.n70 0.1595
R106 vdd.n70 vdd.n71 0.3545
R107 vdd.n71 vdd.n72 0.1595
R108 vdd.n72 vdd.n60 0.005
R109 vdd.n60 vdd.n73 0.35
R110 vdd.n73 vdd.n74 0.1595
R111 vdd.n74 vdd.n75 0.2885
R112 vdd.n75 vdd.n76 0.1595
R113 vdd.n76 vdd.n61 0.245
R114 vdd.n61 vdd.n77 0.044
R115 vdd.n77 vdd.n78 0.1595
R116 vdd.n78 vdd.n79 0.2885
R117 vdd.n79 vdd.n80 0.1595
R118 vdd.n80 vdd.n81 0.2885
R119 vdd.n81 vdd.n82 0.1595
R120 vdd.n82 vdd.n62 0.104
R121 vdd.n62 vdd.n83 0.551
R122 vdd.n83 vdd.n84 0.3275
R123 vdd.n84 vdd.n63 0.323
R124 vdd.n63 vdd.n85 0.005
R125 vdd.n85 vdd.n86 0.3275
R126 vdd.n86 vdd.n87 0.3275
R127 vdd.n87 vdd.t100 4.86639
R128 vdd.n87 vdd.t101 4.57839
R129 vdd.n86 vdd.t87 5.88015
R130 vdd.n85 vdd.t104 5.88015
R131 vdd.n84 vdd.t22 13.9344
R132 vdd.n83 vdd.t95 5.88015
R133 vdd.n82 vdd.t88 5.88015
R134 vdd.n81 vdd.t78 4.57839
R135 vdd.n80 vdd.t79 4.57839
R136 vdd.n79 vdd.t58 4.57839
R137 vdd.n78 vdd.t59 4.57839
R138 vdd.n77 vdd.t23 5.88015
R139 vdd.n76 vdd.t12 5.88015
R140 vdd.n75 vdd.t80 5.88015
R141 vdd.n74 vdd.t81 5.88015
R142 vdd.n73 vdd.t25 2.01891
R143 vdd.n72 vdd.t26 2.01891
R144 vdd.n71 vdd.t74 2.01891
R145 vdd.n70 vdd.t75 2.01891
R146 vdd.n69 vdd.t102 2.01891
R147 vdd.n68 vdd.t103 2.01891
R148 vdd.n67 vdd.t90 2.01891
R149 vdd.n66 vdd.t91 2.01891
R150 vdd.n65 vdd.t54 2.01891
R151 vdd.n64 vdd.t55 2.01891
R152 vdd.n57 vdd.n58 12.6005
R153 vdd.n58 vdd.n59 12.6005
R154 vdd.n58 vdd.n60 12.6005
R155 vdd.n58 vdd.n61 12.6005
R156 vdd.n58 vdd.n62 12.6005
R157 vdd.n58 vdd.n63 12.6005
R158 vdd.t11 vdd.t21 14.9885
R159 vdd.t43 vdd.t11 9.99251
R160 vdd.t24 vdd.t43 143.886
R161 vdd.n58 vdd.t24 83.9334
R162 vdd.n29 vdd.t47 438.584
R163 vdd.t47 vdd.t10 505.781
R164 vdd.t10 vdd.t94 505.781
R165 vdd.t48 vdd.t94 505.781
R166 vdd.n50 vdd.t48 411.851
R167 vdd.n50 vdd.t49 411.851
R168 vdd.t49 vdd.t86 505.781
R169 vdd.t86 vdd.t53 505.781
R170 vdd.t50 vdd.t53 505.781
R171 vdd.n51 vdd.t50 411.851
R172 vdd.n51 vdd.t96 484.104
R173 vdd.t96 vdd.t70 650.289
R174 vdd.t68 vdd.t70 650.289
R175 vdd.n52 vdd.t68 484.104
R176 vdd.n52 vdd.t92 484.104
R177 vdd.t92 vdd.t44 526.013
R178 vdd.t44 vdd.t76 401.735
R179 vdd.t13 vdd.t76 401.735
R180 vdd.t15 vdd.t13 401.735
R181 vdd.n53 vdd.t15 359.827
R182 vdd.n53 vdd.t17 359.827
R183 vdd.t17 vdd.t64 1104.05
R184 vdd.n54 vdd.t64 1062.14
R185 vdd.n54 vdd.t89 375.724
R186 vdd.t89 vdd.t46 433.526
R187 vdd.t46 vdd.t2 433.526
R188 vdd.t2 vdd.t62 433.526
R189 vdd.t60 vdd.t62 433.526
R190 vdd.n55 vdd.t60 375.724
R191 vdd.n55 vdd.t56 375.724
R192 vdd.t56 vdd.t19 417.63
R193 vdd.n49 vdd.t19 383.603
R194 vdd.n47 vdd.n55 23.09
R195 vdd.n43 vdd.n54 23.09
R196 vdd.n40 vdd.n53 23.09
R197 vdd.n34 vdd.n52 23.09
R198 vdd.n30 vdd.n51 23.09
R199 vdd.n29 vdd.n50 23.09
R200 vdd.n49 vdd.t20 18.6345
R201 vdd.n48 vdd.t57 11.2274
R202 vdd.n46 vdd.t61 11.2274
R203 vdd.n45 vdd.t63 11.2274
R204 vdd.n44 vdd.t3 11.2274
R205 vdd.n42 vdd.t65 21.6308
R206 vdd.n41 vdd.t18 13.5844
R207 vdd.n39 vdd.t16 18.6345
R208 vdd.n38 vdd.t14 18.6345
R209 vdd.n37 vdd.t77 13.5844
R210 vdd.n36 vdd.t45 13.5844
R211 vdd.n35 vdd.t93 11.646
R212 vdd.n33 vdd.t69 11.646
R213 vdd.n32 vdd.t71 11.646
R214 vdd.n31 vdd.t97 11.646
R215 vdd.n1 vdd.n0 1.013
R216 vdd.n2 vdd.n1 1.013
R217 vdd.n3 vdd.n2 1.07375
R218 vdd.n4 vdd.n3 0.43475
R219 vdd.n5 vdd.n4 1.013
R220 vdd.n6 vdd.n5 1.013
R221 vdd.n7 vdd.n6 1.07375
R222 vdd.n8 vdd.n7 0.43475
R223 vdd.n9 vdd.n8 1.013
R224 vdd.n10 vdd.n9 1.013
R225 vdd.n11 vdd.n10 1.07375
R226 vdd.n12 vdd.n11 0.43475
R227 vdd.n13 vdd.n12 1.013
R228 vdd.n14 vdd.n13 1.013
R229 vdd.n28 vdd.n14 0.06125
R230 vdd.n28 vdd.n15 1.013
R231 vdd.n15 vdd.n16 0.43475
R232 vdd.n16 vdd.n17 1.013
R233 vdd.n17 vdd.n18 1.013
R234 vdd.n18 vdd.n19 1.07375
R235 vdd.n19 vdd.n20 0.43475
R236 vdd.n20 vdd.n21 1.013
R237 vdd.n21 vdd.n22 1.013
R238 vdd.n0 vdd.t84 152.468
R239 vdd.t84 vdd.t51 167.162
R240 vdd.t4 vdd.t51 167.162
R241 vdd.n23 vdd.t4 124.444
R242 vdd.n23 vdd.t66 124.444
R243 vdd.t66 vdd.t41 167.162
R244 vdd.t33 vdd.t41 167.162
R245 vdd.n24 vdd.t33 124.444
R246 vdd.n24 vdd.t27 124.444
R247 vdd.t27 vdd.t8 167.162
R248 vdd.t39 vdd.t8 167.162
R249 vdd.n25 vdd.t39 124.444
R250 vdd.n25 vdd.t37 124.444
R251 vdd.t37 vdd.t98 167.162
R252 vdd.t31 vdd.t98 167.162
R253 vdd.n26 vdd.t31 124.444
R254 vdd.n26 vdd.t0 124.444
R255 vdd.t0 vdd.t6 167.162
R256 vdd.t6 vdd.t35 167.162
R257 vdd.n27 vdd.t35 124.444
R258 vdd.n27 vdd.t82 124.444
R259 vdd.t82 vdd.t29 167.162
R260 vdd.t29 vdd.t72 167.162
R261 vdd.n22 vdd.t72 153.107
R262 vdd.n19 vdd.n27 27.59
R263 vdd.n15 vdd.n26 27.59
R264 vdd.n11 vdd.n25 27.59
R265 vdd.n7 vdd.n24 27.59
R266 vdd.n3 vdd.n23 27.59
R267 vdd.n22 vdd.t73 16.146
R268 vdd.n21 vdd.t30 16.146
R269 vdd.n20 vdd.t83 16.146
R270 vdd.n18 vdd.t36 16.146
R271 vdd.n17 vdd.t7 16.146
R272 vdd.n16 vdd.t1 16.146
R273 vdd.n14 vdd.t32 16.146
R274 vdd.n13 vdd.t99 16.146
R275 vdd.n12 vdd.t38 16.146
R276 vdd.n10 vdd.t40 16.146
R277 vdd.n9 vdd.t9 16.146
R278 vdd.n8 vdd.t28 16.146
R279 vdd.n6 vdd.t34 16.146
R280 vdd.n5 vdd.t42 16.146
R281 vdd.n4 vdd.t67 12.6482
R282 vdd.n2 vdd.t5 12.6482
R283 vdd.n1 vdd.t52 12.6482
R284 vdd.n0 vdd.t85 12.6482
R285 vss.n72 vss.n71 4.5005
R286 vss.n74 vss.n73 4.5005
R287 vss.n76 vss.n75 4.5005
R288 vss.n188 vss.n187 4.5005
R289 vss vss.n188 17.6675
R290 vss.n188 vss.n76 14.81
R291 vss.n76 vss.n74 4.62875
R292 vss.n74 vss.n72 18.7059
R293 vss.n72 vss.n32 15.6189
R294 vss.n78 vss.n77 0.43025
R295 vss.n79 vss.n78 0.995
R296 vss.n80 vss.n79 0.995
R297 vss.n81 vss.n80 1.06025
R298 vss.n82 vss.n81 0.43025
R299 vss.n83 vss.n82 0.995
R300 vss.n84 vss.n83 0.995
R301 vss.n85 vss.n84 1.06025
R302 vss.n86 vss.n85 0.43025
R303 vss.n87 vss.n86 0.995
R304 vss.n187 vss.n87 0.08375
R305 vss.n187 vss.n88 0.91175
R306 vss.n88 vss.n89 1.06025
R307 vss.n89 vss.n90 0.43025
R308 vss.n90 vss.n102 1.55975
R309 vss.n102 vss.n91 0.20525
R310 vss.n91 vss.n92 0.77
R311 vss.n92 vss.n93 0.83525
R312 vss.n93 vss.n94 0.43025
R313 vss.n94 vss.n95 1.445
R314 vss.n95 vss.n96 0.608
R315 vss.n96 vss.n97 0.608
R316 vss.n97 vss.n98 0.67325
R317 vss.n98 vss.n99 0.43025
R318 vss.n99 vss.n100 0.6575
R319 vss.n100 vss.n101 2.81975
R320 vss.n104 vss.n103 10.4005
R321 vss.n106 vss.n105 10.4005
R322 vss.n108 vss.n107 10.4005
R323 vss.n110 vss.n109 10.4005
R324 vss.n112 vss.n111 10.4005
R325 vss.n167 vss.n166 10.4005
R326 vss.n102 vss.n104 26.252
R327 vss.n104 vss.n186 0.344
R328 vss.n186 vss.n185 0.3485
R329 vss.n185 vss.n184 0.1655
R330 vss.n184 vss.n106 0.344
R331 vss.n106 vss.n183 0.005
R332 vss.n183 vss.n182 0.1655
R333 vss.n182 vss.n181 0.3485
R334 vss.n181 vss.n180 0.1655
R335 vss.n180 vss.n179 0.3485
R336 vss.n179 vss.n178 0.1655
R337 vss.n178 vss.n108 0.005
R338 vss.n108 vss.n177 0.344
R339 vss.n177 vss.n176 0.6125
R340 vss.n176 vss.n110 0.245
R341 vss.n110 vss.n175 0.038
R342 vss.n175 vss.n174 0.1655
R343 vss.n174 vss.n173 0.2825
R344 vss.n173 vss.n172 0.6125
R345 vss.n172 vss.n112 0.104
R346 vss.n112 vss.n171 0.224
R347 vss.n171 vss.n167 0.977
R348 vss.n167 vss.n170 0.005
R349 vss.n170 vss.n169 0.3275
R350 vss.n169 vss.n168 0.3275
R351 vss.n186 vss.t172 3.85787
R352 vss.n185 vss.t170 3.85787
R353 vss.n184 vss.t40 3.85787
R354 vss.n183 vss.t38 3.85787
R355 vss.n182 vss.t44 3.85787
R356 vss.n181 vss.t42 3.85787
R357 vss.n180 vss.t124 3.85787
R358 vss.n179 vss.t122 3.85787
R359 vss.n178 vss.t28 3.85787
R360 vss.n177 vss.t54 3.85787
R361 vss.n176 vss.t16 4.97103
R362 vss.n175 vss.t18 4.97103
R363 vss.n174 vss.t128 3.59261
R364 vss.n173 vss.t126 3.59261
R365 vss.n172 vss.t151 10.5494
R366 vss.n171 vss.t100 4.97103
R367 vss.n170 vss.t102 4.97103
R368 vss.n169 vss.t179 10.5494
R369 vss.n168 vss.t181 6.50024
R370 vss.n168 vss.t112 6.78224
R371 vss.n103 vss.n161 370.06
R372 vss.n103 vss.t34 616.043
R373 vss.t34 vss.t171 23.9456
R374 vss.t171 vss.t130 150.202
R375 vss.t130 vss.t169 71.8357
R376 vss.t169 vss.t31 498.493
R377 vss.t39 vss.t31 23.9456
R378 vss.t129 vss.t39 150.202
R379 vss.t37 vss.t129 71.8357
R380 vss.n105 vss.t37 134.964
R381 vss.n105 vss.t141 363.531
R382 vss.t141 vss.t43 23.9456
R383 vss.t43 vss.t140 150.202
R384 vss.t140 vss.t41 71.8357
R385 vss.t41 vss.t97 498.493
R386 vss.t123 vss.t97 23.9456
R387 vss.t96 vss.t123 150.202
R388 vss.t121 vss.t96 71.8357
R389 vss.n107 vss.t121 387.476
R390 vss.n107 vss.t91 111.019
R391 vss.t91 vss.t27 23.9456
R392 vss.t27 vss.t90 150.202
R393 vss.t90 vss.t53 71.8357
R394 vss.t53 vss.t93 498.493
R395 vss.t93 vss.t92 174.147
R396 vss.t15 vss.t92 474.548
R397 vss.t17 vss.t15 174.147
R398 vss.n109 vss.t17 63.1284
R399 vss.n109 vss.t127 411.421
R400 vss.t127 vss.t125 174.147
R401 vss.t125 vss.t150 1123.24
R402 vss.n111 vss.t150 32.6529
R403 vss.n111 vss.t99 441.897
R404 vss.t99 vss.t107 474.548
R405 vss.t98 vss.t107 474.548
R406 vss.n166 vss.t98 350.469
R407 vss.n166 vss.t101 124.079
R408 vss.t101 vss.t178 474.548
R409 vss.t178 vss.t180 474.548
R410 vss.t180 vss.t111 174.147
R411 vss.n77 vss.t57 219.07
R412 vss.t57 vss.t19 236.893
R413 vss.t19 vss.t117 236.893
R414 vss.t58 vss.t117 236.893
R415 vss.n162 vss.t58 194.641
R416 vss.n162 vss.t61 229.274
R417 vss.t61 vss.t146 306.159
R418 vss.t119 vss.t146 306.159
R419 vss.n163 vss.t119 229.274
R420 vss.n163 vss.t175 229.274
R421 vss.t175 vss.t165 306.159
R422 vss.t163 vss.t165 306.159
R423 vss.n164 vss.t163 229.274
R424 vss.n164 vss.t142 229.274
R425 vss.t142 vss.t167 306.159
R426 vss.t167 vss.t160 306.159
R427 vss.n165 vss.t160 229.274
R428 vss.n165 vss.t87 229.274
R429 vss.t87 vss.t149 271.526
R430 vss.n161 vss.t149 61.648
R431 vss.n89 vss.n165 20.8562
R432 vss.n85 vss.n164 20.8562
R433 vss.n81 vss.n163 20.8562
R434 vss.n77 vss.n162 20.8562
R435 vss.n161 vss.t105 481.693
R436 vss.t105 vss.t49 651.143
R437 vss.n113 vss.t49 535.004
R438 vss.n113 vss.t173 820.592
R439 vss.t173 vss.t113 868.191
R440 vss.t138 vss.t113 514.061
R441 vss.t152 vss.t138 514.061
R442 vss.n114 vss.t152 466.462
R443 vss.n114 vss.t108 487.406
R444 vss.t108 vss.t115 535.004
R445 vss.t115 vss.t59 582.601
R446 vss.t59 vss.t60 651.143
R447 vss.t13 vss.t60 582.601
R448 vss.n115 vss.t13 466.462
R449 vss.n115 vss.n160 396.017
R450 vss.n160 vss.t14 70.4457
R451 vss.t14 vss.n101 488.421
R452 vss.n124 vss.n116 22.5437
R453 vss.n128 vss.n117 22.5437
R454 vss.n129 vss.n118 22.5437
R455 vss.n135 vss.n119 22.5437
R456 vss.n139 vss.t35 3.46717
R457 vss.n140 vss.t156 3.46717
R458 vss.n141 vss.t29 3.46717
R459 vss.n142 vss.t177 3.46717
R460 vss.n143 vss.t159 10.4005
R461 vss.n144 vss.t36 10.4005
R462 vss.n145 vss.t1 10.4005
R463 vss.n146 vss.t25 10.4005
R464 vss.n147 vss.t0 10.4005
R465 vss.n148 vss.t148 10.4005
R466 vss.n149 vss.t7 10.4005
R467 vss.n150 vss.t89 10.4005
R468 vss.n151 vss.t2 10.4005
R469 vss.n152 vss.t118 10.4005
R470 vss.n153 vss.t22 10.4005
R471 vss.n154 vss.t26 10.4005
R472 vss.n155 vss.t30 10.4005
R473 vss.t134 vss.n156 10.4005
R474 vss.n157 vss.t162 10.4005
R475 vss.n158 vss.t135 10.4005
R476 vss.n159 vss.t8 10.4005
R477 vss.n121 vss.t35 124.195
R478 vss.t35 vss.t47 32.7961
R479 vss.t47 vss.t156 129.159
R480 vss.t156 vss.t136 49.8012
R481 vss.t136 vss.t29 112.153
R482 vss.t29 vss.t3 66.8063
R483 vss.t3 vss.t177 95.1481
R484 vss.t177 vss.n116 38.8693
R485 vss.n116 vss.t103 134.017
R486 vss.t159 vss.t103 90.2895
R487 vss.t159 vss.t20 88.67
R488 vss.t36 vss.t20 32.7961
R489 vss.t36 vss.t5 146.163
R490 vss.t1 vss.t5 96.7677
R491 vss.t1 vss.t131 51.8256
R492 vss.t131 vss.t25 69.6405
R493 vss.t25 vss.n117 34.0107
R494 vss.n117 vss.t0 87.4553
R495 vss.t0 vss.t110 16.1958
R496 vss.t110 vss.t148 105.27
R497 vss.t148 vss.t144 8.50305
R498 vss.t144 vss.t94 109.32
R499 vss.t7 vss.t94 3.64445
R500 vss.t7 vss.t145 105.675
R501 vss.t89 vss.t145 15.791
R502 vss.t89 vss.t95 93.5286
R503 vss.n118 vss.t95 99.197
R504 vss.n118 vss.t2 50.2061
R505 vss.t2 vss.t45 48.9914
R506 vss.t45 vss.t118 72.4747
R507 vss.t118 vss.t132 36.8449
R508 vss.t132 vss.t22 84.6212
R509 vss.t22 vss.t154 24.6984
R510 vss.t154 vss.t26 96.7677
R511 vss.t26 vss.t11 12.5519
R512 vss.t11 vss.t30 108.915
R513 vss.t30 vss.t9 14.9812
R514 vss.t9 vss.t134 106.484
R515 vss.n119 vss.t134 7.2884
R516 vss.n119 vss.t23 113.772
R517 vss.t162 vss.t23 0.405384
R518 vss.t162 vss.t135 121.466
R519 vss.t135 vss.t32 16.6007
R520 vss.t32 vss.t8 104.865
R521 vss.t8 vss.t157 33.6058
R522 vss.t157 vss.t51 87.8602
R523 vss.n120 vss.t51 25.913
R524 vss.n120 vss.n160 3680.59
R525 vss.n139 vss.n140 0.947868
R526 vss.n140 vss.n141 0.947868
R527 vss.n141 vss.n142 0.947868
R528 vss.n142 vss.n143 1.53997
R529 vss.n143 vss.n144 0.711026
R530 vss.n144 vss.n145 1.42155
R531 vss.n145 vss.n146 0.711026
R532 vss.n146 vss.n147 0.711026
R533 vss.n147 vss.n148 0.711026
R534 vss.n148 vss.n149 0.711026
R535 vss.n149 vss.n150 0.711026
R536 vss.n150 vss.n151 1.42155
R537 vss.n151 vss.n152 0.711026
R538 vss.n152 vss.n153 0.711026
R539 vss.n153 vss.n154 0.711026
R540 vss.n154 vss.n155 0.711026
R541 vss.n155 vss.n156 0.711026
R542 vss.n156 vss.n157 0.711026
R543 vss.n157 vss.n158 0.711026
R544 vss.n158 vss.n159 0.711026
R545 vss.n159 vss.t51 11.111
R546 vss.n75 vss.n139 30.7502
R547 vss.n75 vss.t52 25.4912
R548 vss.n138 vss.n120 23.3785
R549 vss.n122 vss.n121 0.995
R550 vss.n123 vss.n122 0.995
R551 vss.n124 vss.n123 1.06025
R552 vss.n125 vss.n124 0.43025
R553 vss.n126 vss.n125 0.995
R554 vss.n127 vss.n126 0.995
R555 vss.n128 vss.n127 1.71725
R556 vss.n129 vss.n128 3.5825
R557 vss.n130 vss.n129 0.43025
R558 vss.n73 vss.n130 0.41225
R559 vss.n73 vss.n131 0.19625
R560 vss.n131 vss.n132 0.608
R561 vss.n132 vss.n133 0.608
R562 vss.n133 vss.n134 0.608
R563 vss.n134 vss.n135 0.83525
R564 vss.n135 vss.n136 0.43025
R565 vss.n136 vss.n137 0.77
R566 vss.n137 vss.n138 0.77
R567 vss.n138 vss.t158 11.3706
R568 vss.n137 vss.t33 11.3706
R569 vss.n136 vss.t24 11.3706
R570 vss.n134 vss.t10 11.3706
R571 vss.n133 vss.t12 20.9683
R572 vss.n132 vss.t155 20.9683
R573 vss.n131 vss.t133 20.9683
R574 vss.n130 vss.t46 20.9683
R575 vss.n127 vss.t6 11.7501
R576 vss.n126 vss.t21 11.7501
R577 vss.n125 vss.t104 11.7501
R578 vss.n123 vss.t4 11.7501
R579 vss.n122 vss.t137 11.7501
R580 vss.n121 vss.t48 11.7501
R581 vss.n101 vss.n115 20.8562
R582 vss.n98 vss.n114 20.8562
R583 vss.n93 vss.n113 20.8562
R584 vss.n100 vss.t116 19.2808
R585 vss.n99 vss.t109 11.6644
R586 vss.n97 vss.t153 19.2808
R587 vss.n96 vss.t139 19.2808
R588 vss.n95 vss.t114 19.2808
R589 vss.n94 vss.t174 21.857
R590 vss.n92 vss.t50 11.2319
R591 vss.n91 vss.t106 11.2319
R592 vss.n90 vss.t88 13.7073
R593 vss.n88 vss.t161 13.7073
R594 vss.n87 vss.t168 13.7073
R595 vss.n86 vss.t143 13.7073
R596 vss.n84 vss.t164 13.7073
R597 vss.n83 vss.t166 13.7073
R598 vss.n82 vss.t176 13.7073
R599 vss.n80 vss.t120 13.7073
R600 vss.n79 vss.t147 13.7073
R601 vss.n78 vss.t62 13.7073
R602 vss.n34 vss.n33 3.3485
R603 vss.n35 vss.n34 3.3485
R604 vss.n71 vss.n35 2.13575
R605 vss.n71 vss.n36 1.21325
R606 vss.n36 vss.n37 3.3485
R607 vss.n39 vss.n38 0.0868014
R608 vss.n40 vss.n39 0.0868014
R609 vss.n37 vss.n40 14.3926
R610 vss.n40 vss.n70 4.57882
R611 vss.t85 vss.n70 0.0473
R612 vss.n42 vss.n41 0.0868014
R613 vss.n44 vss.n43 0.0868014
R614 vss.n46 vss.n45 0.0868014
R615 vss.n47 vss.n46 0.0868014
R616 vss.n49 vss.n48 0.0868014
R617 vss.n51 vss.n50 0.0868014
R618 vss.n52 vss.n51 0.0868014
R619 vss.n54 vss.n53 0.0868014
R620 vss.n56 vss.n55 0.0868014
R621 vss.n57 vss.n56 0.0868014
R622 vss.n59 vss.n58 0.0868014
R623 vss.n61 vss.n60 0.0868014
R624 vss.n62 vss.n61 0.0868014
R625 vss.n64 vss.n63 0.0868014
R626 vss.n66 vss.n65 0.0868014
R627 vss.n67 vss.n66 0.0868014
R628 vss.n69 vss.n68 0.0868014
R629 vss.n41 vss.n43 353.161
R630 vss.n43 vss.n45 66.5544
R631 vss.n45 vss.n48 353.075
R632 vss.n48 vss.n50 66.5544
R633 vss.n50 vss.n53 353.075
R634 vss.n53 vss.n55 66.5544
R635 vss.n55 vss.n58 353.075
R636 vss.n58 vss.n60 66.5544
R637 vss.n60 vss.n63 353.075
R638 vss.n63 vss.n65 66.5544
R639 vss.n65 vss.n68 353.075
R640 vss.n68 vss.n38 66.5544
R641 vss.n38 vss.n70 353.161
R642 vss.n69 vss.n67 4.57882
R643 vss.n37 vss.n67 11.0446
R644 vss.t83 vss.n69 0.0473
R645 vss.n66 vss.t83 0.0473
R646 vss.n64 vss.n62 4.57882
R647 vss.n36 vss.n62 11.0446
R648 vss.t81 vss.n64 0.0473
R649 vss.n61 vss.t81 0.0473
R650 vss.n59 vss.n57 4.57882
R651 vss.n35 vss.n57 11.0446
R652 vss.t79 vss.n59 0.0473
R653 vss.n56 vss.t79 0.0473
R654 vss.n54 vss.n52 4.57882
R655 vss.n34 vss.n52 11.0446
R656 vss.t77 vss.n54 0.0473
R657 vss.n51 vss.t77 0.0473
R658 vss.n49 vss.n47 4.57882
R659 vss.n33 vss.n47 11.0446
R660 vss.t75 vss.n49 0.0473
R661 vss.n46 vss.t75 0.0473
R662 vss.n44 vss.n42 4.57882
R663 vss.n33 vss.n42 14.3926
R664 vss.t73 vss.n44 0.0473
R665 vss.n41 vss.t73 0.0473
R666 vss.n39 vss.t85 0.0473
R667 vss.n1 vss.n0 3.3485
R668 vss.n2 vss.n1 3.3485
R669 vss.n32 vss.n2 2.13575
R670 vss.n32 vss.n3 1.21325
R671 vss.n5 vss.n4 0.0697308
R672 vss.n6 vss.n5 0.0697308
R673 vss.n3 vss.n6 14.7418
R674 vss.n6 vss.n31 5.26015
R675 vss.t55 vss.n31 0.038593
R676 vss.n8 vss.n7 0.0868014
R677 vss.n10 vss.n9 0.0868014
R678 vss.n12 vss.n11 0.0868014
R679 vss.n13 vss.n12 0.0868014
R680 vss.n15 vss.n14 0.0868014
R681 vss.n17 vss.n16 0.0868014
R682 vss.n18 vss.n17 0.0868014
R683 vss.n20 vss.n19 0.0868014
R684 vss.n22 vss.n21 0.0868014
R685 vss.n23 vss.n22 0.0868014
R686 vss.n25 vss.n24 0.0868014
R687 vss.n27 vss.n26 0.0868014
R688 vss.n28 vss.n27 0.0868014
R689 vss.n30 vss.n29 0.0868014
R690 vss.n7 vss.n9 288.168
R691 vss.n9 vss.n11 54.3033
R692 vss.n11 vss.n14 288.082
R693 vss.n14 vss.n16 54.3033
R694 vss.n16 vss.n19 288.082
R695 vss.n19 vss.n21 54.3033
R696 vss.n21 vss.n24 288.082
R697 vss.n24 vss.n26 54.3033
R698 vss.n26 vss.n29 288.082
R699 vss.n29 vss.n4 54.3033
R700 vss.n4 vss.n31 288.151
R701 vss.n30 vss.n28 4.57882
R702 vss.n3 vss.n28 12.8446
R703 vss.t71 vss.n30 0.0473
R704 vss.n27 vss.t71 0.0473
R705 vss.n25 vss.n23 4.57882
R706 vss.n2 vss.n23 12.8446
R707 vss.t69 vss.n25 0.0473
R708 vss.n22 vss.t69 0.0473
R709 vss.n20 vss.n18 4.57882
R710 vss.n1 vss.n18 12.8446
R711 vss.t67 vss.n20 0.0473
R712 vss.n17 vss.t67 0.0473
R713 vss.n15 vss.n13 4.57882
R714 vss.n0 vss.n13 12.8446
R715 vss.t65 vss.n15 0.0473
R716 vss.n12 vss.t65 0.0473
R717 vss.n10 vss.n8 4.57882
R718 vss.n0 vss.n8 16.1926
R719 vss.t63 vss.n10 0.0473
R720 vss.n7 vss.t63 0.0473
R721 vss.n5 vss.t55 0.038593
R722 a_22044_n100 a_22044_n100.n0 0.662
R723 a_22044_n100.n0 a_22044_n100.t0 1.2605
R724 a_22044_n100.n0 a_22044_n100.t1 15.6061
R725 a_21350_n100 a_21350_n100.t0 16.3801
R726 a_18352_n100.n0 a_18352_n100.t0 0.8195
R727 a_18352_n100.n0 a_18352_n100.t1 0.8195
R728 a_18352_n100.n1 a_18352_n100.n0 7.26555
R729 a_18352_n100.n2 a_18352_n100.n1 7.22955
R730 a_18352_n100 a_18352_n100.n2 0.662
R731 a_18352_n100.n2 a_18352_n100.t3 1.2605
R732 a_18352_n100.n1 a_18352_n100.t2 8.06655
R733 a_17668_0.t0 a_17668_0.n0 0.8195
R734 a_17668_0.n0 a_17668_0.t1 0.8195
R735 a_17668_0.n2 a_17668_0.n0 7.36905
R736 a_17668_0.n1 a_17668_0.n2 8.17078
R737 a_17668_0 a_17668_0.n1 0.8825
R738 a_17668_0.n1 a_17668_0.t3 1.6805
R739 a_17668_0.n2 a_17668_0.t2 9.75178
R740 a_16984_0.t0 a_16984_0.n2 9.75178
R741 a_16984_0.n2 a_16984_0.n1 7.36905
R742 a_16984_0.n1 a_16984_0.t3 0.8195
R743 a_16984_0.n1 a_16984_0.t2 0.8195
R744 a_16984_0.n0 a_16984_0.n2 8.17078
R745 a_16984_0 a_16984_0.n0 0.8825
R746 a_16984_0.n0 a_16984_0.t1 1.6805
R747 a_16300_0.n0 a_16300_0.t1 0.8195
R748 a_16300_0.n0 a_16300_0.t0 0.8195
R749 a_16300_0.n2 a_16300_0.n0 7.36905
R750 a_16300_0.n1 a_16300_0.n2 8.17078
R751 a_16300_0 a_16300_0.n1 0.8825
R752 a_16300_0.n1 a_16300_0.t3 1.6805
R753 a_16300_0.n2 a_16300_0.t2 9.75178
R754 a_15616_0 a_15616_0.n0 0.8825
R755 a_15616_0.n0 a_15616_0.t0 1.6805
R756 a_15616_0.n0 a_15616_0.n2 8.17078
R757 a_15616_0.n2 a_15616_0.n1 7.36905
R758 a_15616_0.n1 a_15616_0.t2 0.8195
R759 a_15616_0.n1 a_15616_0.t1 0.8195
R760 a_15616_0.n2 a_15616_0.t3 9.75178
R761 a_14932_0 a_14932_0.n0 0.8825
R762 a_14932_0.n0 a_14932_0.t0 1.6805
R763 a_14932_0.n0 a_14932_0.n2 8.17078
R764 a_14932_0.n2 a_14932_0.n1 7.36905
R765 a_14932_0.n1 a_14932_0.t3 0.8195
R766 a_14932_0.n1 a_14932_0.t2 0.8195
R767 a_14932_0.n2 a_14932_0.t1 9.75178
R768 dx.t1 dx.n0 13.6519
R769 dx.n0 dx.t2 55.1459
R770 dx dx.n0 0.1595
R771 dx dx.t0 18.7857
R772 a_20918_1350 a_20918_1350.t0 16.7328
R773 dy.t0 dy.n0 8.45955
R774 dy.n0 dy.t1 9.15189
R775 dy dy.n0 4.9775
R776 dy dy.n1 4.9775
R777 dy.n1 dy.t2 50.3579
R778 dy.n1 dy.t3 51.2086
R779 dqn.t1 dqn.n0 8.69955
R780 dqn.n4 dqn.n0 4.5005
R781 dqn.n0 dqn.t0 16.6027
R782 dqn.n4 dqn.n2 0.6365
R783 dqn.n2 dqn.n3 4.7885
R784 dqn.n3 dqn.t3 37.5622
R785 dqn.n3 dqn.t5 50.9686
R786 dqn.n2 dqn.t2 13.4119
R787 dqn dqn.n4 0.6365
R788 dqn dqn.n1 6.1205
R789 dqn.n1 dqn.t4 37.5622
R790 dqn.n1 dqn.t6 50.9686
R791 vco_out.n0 vco_out.t1 0.607167
R792 vco_out.n0 vco_out.t0 0.607167
R793 vco_out.n1 vco_out.n0 6.62634
R794 vco_out.n1 vco_out.n7 6.95734
R795 vco_out.n7 vco_out.t3 0.5465
R796 vco_out.n7 vco_out.t2 0.5465
R797 vco_out.n3 vco_out.n1 5.3705
R798 vco_out vco_out.n3 0.8195
R799 vco_out.n5 vco_out.n4 4.5005
R800 vco_out vco_out.n5 0.4115
R801 vco_out.n5 vco_out.n6 0.6245
R802 vco_out.n6 vco_out.t6 55.9619
R803 vco_out.n6 vco_out.t8 55.2286
R804 vco_out.n4 vco_out.t7 50.8379
R805 vco_out.n4 vco_out.t9 50.7286
R806 vco_out.n3 vco_out.n2 11.1263
R807 vco_out.n2 vco_out.t5 0.607167
R808 vco_out.n2 vco_out.t4 0.607167
R809 dqb.t1 dqb.n0 9.15189
R810 dqb.n0 dqb.t0 13.8088
R811 dqb dqb.n0 4.6505
R812 dqb dqb.n3 4.6505
R813 dqb.n3 dqb.n2 4.81503
R814 dqb.n2 dqb.t2 39.215
R815 dqb.n2 dqb.t3 39.0255
R816 dqb.n3 dqb.n1 5.66576
R817 dqb.n1 dqb.t4 58.7685
R818 dqb.n1 dqb.t5 58.5791
R819 nb.n0 nb.t0 0.9105
R820 nb.n0 nb.t1 0.9105
R821 nb.n9 nb.n0 12.1819
R822 nb nb.n9 0.2855
R823 nb.n7 nb.n6 4.5005
R824 nb nb.n7 0.2915
R825 nb.n7 nb.n8 11.0298
R826 nb.n8 nb.t8 58.7685
R827 nb.n8 nb.t9 58.5791
R828 nb.n6 nb.n5 4.81503
R829 nb.n5 nb.t6 58.7685
R830 nb.n5 nb.t7 58.5791
R831 nb.n6 nb.n4 5.66576
R832 nb.n4 nb.t10 58.7685
R833 nb.n4 nb.t11 58.5791
R834 nb.n9 nb.n3 5.3705
R835 nb.n3 nb.n2 7.19955
R836 nb.n2 nb.t3 0.8195
R837 nb.n2 nb.t2 0.8195
R838 nb.n3 nb.n1 7.68189
R839 nb.n1 nb.t5 0.9105
R840 nb.n1 nb.t4 0.9105
R841 r4.t0 r4.n0 0.607167
R842 r4.n0 r4.t3 0.607167
R843 r4.n1 r4.n0 6.86634
R844 r4.n1 r4.n5 8.43066
R845 r4.n5 r4.t2 1.0925
R846 r4.n5 r4.t1 1.0925
R847 r4 r4.n1 5.3705
R848 r4 r4.n4 5.3705
R849 r4.n4 r4.n3 5.05503
R850 r4.n3 r4.t4 39.215
R851 r4.n3 r4.t5 39.0255
R852 r4.n4 r4.n2 5.42576
R853 r4.n2 r4.t6 58.7685
R854 r4.n2 r4.t7 58.5791
R855 r5.t2 r5.n0 0.607167
R856 r5.n0 r5.t3 0.607167
R857 r5.n1 r5.n0 6.62634
R858 r5.n8 r5.n1 4.5005
R859 r5.n1 r5.n9 8.67066
R860 r5.n9 r5.t0 1.0925
R861 r5.n9 r5.t1 1.0925
R862 r5.n8 r5.n7 5.2145
R863 r5.n7 r5.n6 5.29503
R864 r5.n6 r5.t4 45.7328
R865 r5.n6 r5.t5 45.5434
R866 r5.n7 r5.n5 5.18576
R867 r5.n5 r5.t8 45.7328
R868 r5.n5 r5.t9 45.5434
R869 r5 r5.n8 0.2675
R870 r5 r5.n4 5.5115
R871 r5.n4 r5.n3 5.29503
R872 r5.n3 r5.t6 39.215
R873 r5.n3 r5.t7 39.0255
R874 r5.n4 r5.n2 5.18576
R875 r5.n2 r5.t11 58.5791
R876 r5.n2 r5.t10 58.7685
R877 r3.n0 r3.t2 0.607167
R878 r3.n0 r3.t1 0.607167
R879 r3.n1 r3.n0 6.62634
R880 r3.n1 r3.n5 8.67066
R881 r3.n5 r3.t0 1.0925
R882 r3.n5 r3.t3 1.0925
R883 r3 r3.n1 5.3705
R884 r3 r3.n4 5.3705
R885 r3.n4 r3.n3 5.29503
R886 r3.n3 r3.t4 39.215
R887 r3.n3 r3.t5 39.0255
R888 r3.n4 r3.n2 5.18576
R889 r3.n2 r3.t6 58.7685
R890 r3.n2 r3.t7 58.5791
R891 r1.n0 r1.t3 0.607167
R892 r1.n0 r1.t2 0.607167
R893 r1.n1 r1.n0 7.10634
R894 r1.n1 r1.n5 8.19066
R895 r1.n5 r1.t0 1.0925
R896 r1.n5 r1.t1 1.0925
R897 r1 r1.n1 5.6495
R898 r1 r1.n4 5.6555
R899 r1.n4 r1.n3 4.81503
R900 r1.n3 r1.t4 39.215
R901 r1.n3 r1.t5 39.0255
R902 r1.n4 r1.n2 5.66576
R903 r1.n2 r1.t7 58.5791
R904 r1.n2 r1.t6 58.7685
R905 r2.n0 r2.t3 0.607167
R906 r2.n0 r2.t0 0.607167
R907 r2.n1 r2.n0 6.86634
R908 r2.n1 r2.n5 8.43066
R909 r2.n5 r2.t1 1.0925
R910 r2.n5 r2.t2 1.0925
R911 r2 r2.n1 5.1365
R912 r2 r2.n4 5.1425
R913 r2.n4 r2.n3 5.05503
R914 r2.n3 r2.t4 39.215
R915 r2.n3 r2.t5 39.0255
R916 r2.n4 r2.n2 5.42576
R917 r2.n2 r2.t7 58.5791
R918 r2.n2 r2.t6 58.7685
R919 a_17664_1350 a_17664_1350.n0 0.537167
R920 a_17664_1350.n0 a_17664_1350.t2 0.9805
R921 a_17664_1350.n0 a_17664_1350.n2 6.24309
R922 a_17664_1350.n2 a_17664_1350.t3 7.12409
R923 a_17664_1350.n2 a_17664_1350.n1 6.20245
R924 a_17664_1350.n1 a_17664_1350.t1 0.3645
R925 a_17664_1350.n1 a_17664_1350.t0 0.3645
R926 a_16980_1350.t1 a_16980_1350.n1 7.12409
R927 a_16980_1350.n2 a_16980_1350.n1 6.24309
R928 a_16980_1350 a_16980_1350.n2 0.537167
R929 a_16980_1350.n2 a_16980_1350.t0 0.9805
R930 a_16980_1350.n1 a_16980_1350.n0 6.20245
R931 a_16980_1350.n0 a_16980_1350.t3 0.3645
R932 a_16980_1350.n0 a_16980_1350.t2 0.3645
R933 a_16296_1350.t1 a_16296_1350.n1 7.12409
R934 a_16296_1350.n2 a_16296_1350.n1 6.24309
R935 a_16296_1350 a_16296_1350.n2 0.537167
R936 a_16296_1350.n2 a_16296_1350.t0 0.9805
R937 a_16296_1350.n1 a_16296_1350.n0 6.20245
R938 a_16296_1350.n0 a_16296_1350.t3 0.3645
R939 a_16296_1350.n0 a_16296_1350.t2 0.3645
R940 a_15612_1350.t1 a_15612_1350.n1 7.12409
R941 a_15612_1350.n2 a_15612_1350.n1 6.24309
R942 a_15612_1350 a_15612_1350.n2 0.537167
R943 a_15612_1350.n2 a_15612_1350.t0 0.9805
R944 a_15612_1350.n1 a_15612_1350.n0 6.20245
R945 a_15612_1350.n0 a_15612_1350.t3 0.3645
R946 a_15612_1350.n0 a_15612_1350.t2 0.3645
R947 a_14928_1350.t1 a_14928_1350.n1 7.12409
R948 a_14928_1350.n2 a_14928_1350.n1 6.24309
R949 a_14928_1350 a_14928_1350.n2 0.537167
R950 a_14928_1350.n2 a_14928_1350.t0 0.9805
R951 a_14928_1350.n1 a_14928_1350.n0 6.20245
R952 a_14928_1350.n0 a_14928_1350.t3 0.3645
R953 a_14928_1350.n0 a_14928_1350.t2 0.3645
R954 vi.n2 vi.t0 11.9519
R955 vi vi.n0 6.16325
R956 vi.n0 vi.n1 0.77
R957 vi.n1 vi.n2 0.365
R958 vi.n2 vi.t1 13.0544
R959 vi.n1 vi.t2 11.9519
R960 vi.n0 vi.t3 11.9519
R961 vi vi.t4 22.8266
R962 vnt.n5 vnt.t0 11.4119
R963 vnt.n0 vnt.n5 0.77
R964 vnt.n1 vnt.n0 0.77
R965 vnt vnt.n1 5.01125
R966 vnt vnt.n2 2.35175
R967 vnt.n2 vnt.n3 1.49
R968 vnt.n3 vnt.n4 1.9895
R969 vnt.n4 vnt.t3 15.3768
R970 vnt.n4 vnt.t6 13.8873
R971 vnt.n3 vnt.t5 13.8873
R972 vnt.n2 vnt.t7 13.8873
R973 vnt.n1 vnt.t2 11.4119
R974 vnt.n0 vnt.t4 11.4119
R975 vnt.n5 vnt.t1 12.1814
R976 vbn_vco.t2 vbn_vco.n12 11.7674
R977 vbn_vco.n11 vbn_vco.n12 12.0042
R978 vbn_vco vbn_vco.n3 20.3461
R979 vbn_vco vbn_vco.n1 2.48338
R980 vbn_vco.n1 vbn_vco.n11 0.00725
R981 vbn_vco.n3 vbn_vco.n5 0.9965
R982 vbn_vco.n5 vbn_vco.n7 0.9965
R983 vbn_vco.n7 vbn_vco.n9 0.9965
R984 vbn_vco.n9 vbn_vco.n10 10.4541
R985 vbn_vco.n10 vbn_vco.t5 29.8501
R986 vbn_vco.n10 vbn_vco.t6 29.6085
R987 vbn_vco.n9 vbn_vco.n8 9.45808
R988 vbn_vco.n8 vbn_vco.t7 29.8501
R989 vbn_vco.n8 vbn_vco.t8 29.6085
R990 vbn_vco.n7 vbn_vco.n6 9.45808
R991 vbn_vco.n6 vbn_vco.t9 29.8501
R992 vbn_vco.n6 vbn_vco.t10 29.6085
R993 vbn_vco.n5 vbn_vco.n4 9.45808
R994 vbn_vco.n4 vbn_vco.t11 29.8501
R995 vbn_vco.n4 vbn_vco.t12 29.6085
R996 vbn_vco.n3 vbn_vco.n2 9.45808
R997 vbn_vco.n2 vbn_vco.t13 29.8501
R998 vbn_vco.n2 vbn_vco.t14 29.6085
R999 vbn_vco.n11 vbn_vco.t4 21.1415
R1000 vbn_vco.n1 vbn_vco.n0 11.0368
R1001 vbn_vco.n0 vbn_vco.t1 1.88813
R1002 vbn_vco.n0 vbn_vco.t0 44.5424
R1003 vbn_vco.n12 vbn_vco.t3 12.4424
R1004 vst.t0 vst.n2 11.4119
R1005 vst vst.n2 0.88925
R1006 vst vst.n1 0.0725
R1007 vst.n1 vst.n0 1.148
R1008 vst.n1 vst.t1 36.9645
R1009 vst.n0 vst.t3 19.8995
R1010 vst.n0 vst.t4 13.747
R1011 vst.n2 vst.t2 12.1814
R1012 vbh.t1 vbh.n5 11.5919
R1013 vbh vbh.n5 2.03338
R1014 vbh vbh.n4 16.7889
R1015 vbh.n4 vbh.n1 0.0275
R1016 vbh.n1 vbh.n2 1.013
R1017 vbh.n2 vbh.n3 11.3292
R1018 vbh.n3 vbh.t5 1.83599
R1019 vbh.n3 vbh.t4 12.2744
R1020 vbh.n2 vbh.t6 22.039
R1021 vbh.n1 vbh.t7 22.039
R1022 vbh.n4 vbh.n0 11.1447
R1023 vbh.n0 vbh.t3 1.83599
R1024 vbh.n0 vbh.t2 12.2744
R1025 vbh.n5 vbh.t0 13.9004
R1026 vbl.t4 vbl.n7 11.5874
R1027 vbl.n0 vbl.n7 1.283
R1028 vbl.n1 vbl.n0 1.24475
R1029 vbl.n6 vbl.n1 12.0875
R1030 vbl.n3 vbl.n6 0.059
R1031 vbl vbl.n3 0.5765
R1032 vbl vbl.n4 0.419
R1033 vbl.n4 vbl.n5 12.452
R1034 vbl.n5 vbl.t3 3.47655
R1035 vbl.n5 vbl.t2 8.58548
R1036 vbl.n4 vbl.t8 19.4863
R1037 vbl.n3 vbl.t9 19.4863
R1038 vbl.n6 vbl.n2 12.236
R1039 vbl.n2 vbl.t1 3.47655
R1040 vbl.n2 vbl.t0 8.58548
R1041 vbl.n1 vbl.t7 12.7057
R1042 vbl.n0 vbl.t6 11.5874
R1043 vbl.n7 vbl.t5 13.9499
R1044 vbp_vco.t1 vbp_vco.n0 13.7744
R1045 vbp_vco vbp_vco.n16 19.1311
R1046 vbp_vco vbp_vco.n1 1.85562
R1047 vbp_vco.n1 vbp_vco.n0 1.66775
R1048 vbp_vco.n16 vbp_vco.n10 0.7775
R1049 vbp_vco.n10 vbp_vco.n12 0.9965
R1050 vbp_vco.n12 vbp_vco.n14 0.9965
R1051 vbp_vco.n14 vbp_vco.n15 10.4558
R1052 vbp_vco.n15 vbp_vco.t7 51.8961
R1053 vbp_vco.n15 vbp_vco.t8 51.6545
R1054 vbp_vco.n14 vbp_vco.n13 9.45982
R1055 vbp_vco.n13 vbp_vco.t9 51.8961
R1056 vbp_vco.n13 vbp_vco.t10 51.6545
R1057 vbp_vco.n12 vbp_vco.n11 9.45982
R1058 vbp_vco.n11 vbp_vco.t11 51.8961
R1059 vbp_vco.n11 vbp_vco.t12 51.6545
R1060 vbp_vco.n10 vbp_vco.n9 9.45982
R1061 vbp_vco.n9 vbp_vco.t13 51.8961
R1062 vbp_vco.n9 vbp_vco.t14 51.6545
R1063 vbp_vco.n16 vbp_vco.n8 9.64882
R1064 vbp_vco.n8 vbp_vco.t15 51.8961
R1065 vbp_vco.n8 vbp_vco.t16 51.6545
R1066 vbp_vco.n1 vbp_vco.n7 11.5475
R1067 vbp_vco.n4 vbp_vco.n3 0.6755
R1068 vbp_vco.n6 vbp_vco.n4 1.00175
R1069 vbp_vco.n7 vbp_vco.n6 0.00725
R1070 vbp_vco.n7 vbp_vco.t2 19.6132
R1071 vbp_vco.n6 vbp_vco.n5 9.94325
R1072 vbp_vco.n5 vbp_vco.t6 1.6447
R1073 vbp_vco.n5 vbp_vco.t5 51.9932
R1074 vbp_vco.n4 vbp_vco.t17 61.7152
R1075 vbp_vco.n3 vbp_vco.t18 61.7152
R1076 vbp_vco.n3 vbp_vco.n2 10.787
R1077 vbp_vco.n2 vbp_vco.t4 1.6447
R1078 vbp_vco.n2 vbp_vco.t3 51.9932
R1079 vbp_vco.n0 vbp_vco.t0 12.6719
R1080 vs vs.t1 12.0093
R1081 vs.n0 vs.t2 66.4435
R1082 vs vs.n0 0.352625
R1083 vs.n0 vs.t0 11.5919
R1084 vcl.t0 vcl.n2 13.0873
R1085 vcl.n2 vcl.n0 0.08825
R1086 vcl.n0 vcl.n1 0.77
R1087 vcl vcl.n2 18.5675
R1088 vcl vcl.t3 29.215
R1089 vcl.n1 vcl.t4 12.6801
R1090 vcl.n1 vcl.t2 11.9106
R1091 vcl.n0 vcl.t1 11.9106
R1092 up_b.t1 up_b.n0 14.3606
R1093 up_b up_b.n0 3.15838
R1094 up_b.n0 up_b.t0 47.2077
R1095 up_b up_b.t2 58.2143
R1096 en_b.t1 en_b.n0 17.4656
R1097 en_b.n5 en_b.n0 6.1385
R1098 en_b.n4 en_b.n5 7.9475
R1099 en_b.n2 en_b.n4 0.563
R1100 en_b.n3 en_b.n2 0.608
R1101 en_b en_b.n3 0.27275
R1102 en_b en_b.t2 45.6133
R1103 en_b.n3 en_b.t3 44.126
R1104 en_b.n2 en_b.t4 44.126
R1105 en_b.n4 en_b.t5 44.1711
R1106 en_b.n5 en_b.n1 26.2175
R1107 en_b.n1 en_b.t0 21.3282
R1108 en_b.n1 en_b.t7 45.5323
R1109 en_b.n0 en_b.t6 13.6789
R1110 t1c t1c.t0 17.1971
R1111 t1c t1c.t1 17.1971
R1112 vdump.t7 vdump.n0 1.68292
R1113 vdump.n0 vdump.t6 30.1453
R1114 vdump.n15 vdump.n0 10.2695
R1115 vdump vdump.n15 1.73975
R1116 vdump vdump.n2 1.51475
R1117 vdump.n2 vdump.n3 0.47075
R1118 vdump.n14 vdump.n13 4.5005
R1119 vdump.n3 vdump.n14 8.1275
R1120 vdump.n8 vdump.n6 2.858
R1121 vdump.n10 vdump.n8 0.788
R1122 vdump.n13 vdump.n10 0.02975
R1123 vdump.n13 vdump.n11 3.27875
R1124 vdump.n11 vdump.n12 1.013
R1125 vdump.n12 vdump.t14 22.1535
R1126 vdump.n12 vdump.t17 12.366
R1127 vdump.n11 vdump.t16 12.366
R1128 vdump.n10 vdump.n9 10.3032
R1129 vdump.n9 vdump.t3 1.6447
R1130 vdump.n9 vdump.t2 30.2254
R1131 vdump.n8 vdump.n7 10.3032
R1132 vdump.n7 vdump.t11 1.6447
R1133 vdump.n7 vdump.t10 30.2254
R1134 vdump.n6 vdump.n5 10.3032
R1135 vdump.n5 vdump.t9 1.6447
R1136 vdump.n5 vdump.t8 30.2254
R1137 vdump.n6 vdump.n4 11.0908
R1138 vdump.n4 vdump.t13 1.6447
R1139 vdump.n4 vdump.t12 30.2254
R1140 vdump.n14 vdump.t15 37.9443
R1141 vdump.n3 vdump.t1 14.9516
R1142 vdump.n2 vdump.t0 14.4273
R1143 vdump.n15 vdump.n1 11.039
R1144 vdump.n1 vdump.t5 1.68292
R1145 vdump.n1 vdump.t4 30.1453
R1146 dn_b.t1 dn_b 14.139
R1147 dn_b dn_b.n0 25.5459
R1148 dn_b.n0 dn_b.t0 21.587
R1149 dn_b.n0 dn_b.t2 46.068
R1150 dn_s.t0 dn_s.n0 13.7796
R1151 dn_s dn_s.n0 1.0085
R1152 dn_s dn_s.n1 1.346
R1153 dn_s.n1 dn_s.t1 17.0868
R1154 dn_s.n1 dn_s.t3 15.9348
R1155 dn_s.n0 dn_s.t2 12.2901
R1156 vref.n12 vref.t1 12.5644
R1157 vref.n1 vref.n0 1.49
R1158 vref.n2 vref.n1 0.995
R1159 vref.n3 vref.n2 0.995
R1160 vref vref.n3 1.45963
R1161 vref vref.n4 0.030875
R1162 vref.n4 vref.n7 0.041
R1163 vref.n7 vref.n12 0.15575
R1164 vref.n12 vref.n5 1.34375
R1165 vref.n5 vref.n6 0.77
R1166 vref.n7 vref.n11 19.31
R1167 vref.n11 vref.n10 9.12875
R1168 vref.n11 vref.t0 35.3913
R1169 vref.n10 vref.n8 0.617
R1170 vref.n8 vref.n9 0.77
R1171 vref.n9 vref.t11 68.5227
R1172 vref.n9 vref.t12 67.7532
R1173 vref.n8 vref.t13 67.7532
R1174 vref.n10 vref.t14 68.4012
R1175 vref.n6 vref.t2 23.774
R1176 vref.n6 vref.t3 40.3782
R1177 vref.n5 vref.t4 40.3782
R1178 vref.n4 vref.t5 19.4863
R1179 vref.n3 vref.t6 19.4863
R1180 vref.n2 vref.t7 19.4863
R1181 vref.n1 vref.t8 19.4863
R1182 vref.n0 vref.t9 19.4863
R1183 vref.n0 vref.t10 20.4808
R1184 t1b t1b.t1 19.6057
R1185 t1b t1b.t0 37.5581
R1186 va.t0 va.n1 56.8125
R1187 va.n0 va.n1 0.1895
R1188 va va.n0 0.55175
R1189 va va.t2 23.6143
R1190 va.n0 va.t3 36.4132
R1191 va.n1 va.t1 17.3006
R1192 t1a t1a.t1 17.2432
R1193 t1a t1a.t0 36.7481
R1194 t2 t2.t2 16.9394
R1195 t2 t2.n0 17.5921
R1196 t2.n0 t2.t0 23.0242
R1197 t2.n0 t2.t1 17.1202
R1198 vcp_n.t9 vcp_n.n0 1.64987
R1199 vcp_n.n0 vcp_n.t8 23.1665
R1200 vcp_n.n13 vcp_n.n0 10.2807
R1201 vcp_n.n3 vcp_n.n2 0.995
R1202 vcp_n.n4 vcp_n.n3 1.49
R1203 vcp_n.n5 vcp_n.n4 0.995
R1204 vcp_n.n13 vcp_n.n5 0.82625
R1205 vcp_n vcp_n.n13 0.545
R1206 vcp_n vcp_n.n6 1.8725
R1207 vcp_n.n6 vcp_n.n9 0.03425
R1208 vcp_n.n9 vcp_n.n7 0.57425
R1209 vcp_n.n7 vcp_n.n8 1.2155
R1210 vcp_n.n9 vcp_n.n12 17.8475
R1211 vcp_n.n12 vcp_n.n10 0.17375
R1212 vcp_n.n10 vcp_n.n11 8.078
R1213 vcp_n.n11 vcp_n.t1 19.386
R1214 vcp_n.n11 vcp_n.t3 16.866
R1215 vcp_n.n10 vcp_n.t0 16.866
R1216 vcp_n.n12 vcp_n.t2 19.2127
R1217 vcp_n.n8 vcp_n.t11 23.4658
R1218 vcp_n.n8 vcp_n.t5 15.5748
R1219 vcp_n.n7 vcp_n.t4 15.5748
R1220 vcp_n.n6 vcp_n.t10 15.5748
R1221 vcp_n.n5 vcp_n.t12 33.2538
R1222 vcp_n.n4 vcp_n.t13 33.2538
R1223 vcp_n.n3 vcp_n.t14 33.2538
R1224 vcp_n.n2 vcp_n.t15 33.2538
R1225 vcp_n.n2 vcp_n.n1 11.444
R1226 vcp_n.n1 vcp_n.t7 1.64987
R1227 vcp_n.n1 vcp_n.t6 23.1665
R1228 vbt.n9 vbt.t3 11.4074
R1229 vbt.n1 vbt.n0 0.788
R1230 vbt.n2 vbt.n1 0.788
R1231 vbt vbt.n2 0.64175
R1232 vbt vbt.n3 0.64175
R1233 vbt.n3 vbt.n4 0.788
R1234 vbt.n4 vbt.n5 0.69125
R1235 vbt.n5 vbt.n9 0.09725
R1236 vbt.n5 vbt.n6 33.179
R1237 vbt.n6 vbt.n7 2.5205
R1238 vbt.n7 vbt.n8 10.598
R1239 vbt.n8 vbt.t10 18.351
R1240 vbt.n8 vbt.t11 16.326
R1241 vbt.n7 vbt.t4 16.326
R1242 vbt.n6 vbt.t5 16.326
R1243 vbt.n9 vbt.t9 12.1949
R1244 vbt.n4 vbt.t2 11.4074
R1245 vbt.n3 vbt.t8 11.4074
R1246 vbt.n2 vbt.t7 11.4074
R1247 vbt.n1 vbt.t1 11.4074
R1248 vbt.n0 vbt.t0 11.4074
R1249 vbt.n0 vbt.t6 12.1949
R1250 vbp.t1 vbp.n15 12.7444
R1251 vbp.n15 vbp.n0 9.40775
R1252 vbp vbp.n15 1.00962
R1253 vbp.n0 vbp.n14 28.2582
R1254 vbp.n2 vbp.n1 1.508
R1255 vbp.n3 vbp.n2 1.013
R1256 vbp.n4 vbp.n3 1.013
R1257 vbp.n5 vbp.n4 1.508
R1258 vbp.n7 vbp.n5 0.84425
R1259 vbp.n8 vbp.n7 1.18175
R1260 vbp.n14 vbp.n8 0.5135
R1261 vbp.n14 vbp.n9 0.995
R1262 vbp.n9 vbp.n10 1.013
R1263 vbp.n10 vbp.n11 1.013
R1264 vbp.n11 vbp.n12 1.508
R1265 vbp.n12 vbp.n13 1.013
R1266 vbp.n13 vbp.t5 27.9115
R1267 vbp.n13 vbp.t6 26.899
R1268 vbp.n12 vbp.t7 26.899
R1269 vbp.n11 vbp.t8 26.899
R1270 vbp.n10 vbp.t9 26.899
R1271 vbp.n9 vbp.t10 26.899
R1272 vbp.n8 vbp.t11 26.899
R1273 vbp.n7 vbp.n6 14.8505
R1274 vbp.n6 vbp.t4 1.83599
R1275 vbp.n6 vbp.t3 12.2744
R1276 vbp.n5 vbp.t12 26.899
R1277 vbp.n4 vbp.t13 26.899
R1278 vbp.n3 vbp.t14 26.899
R1279 vbp.n2 vbp.t15 26.899
R1280 vbp.n1 vbp.t16 26.899
R1281 vbp.n1 vbp.t17 27.9115
R1282 vbp.n0 vbp.t0 24.0548
R1283 vbp vbp.t2 25.4064
R1284 up_s.t0 up_s.n1 13.0082
R1285 up_s.n0 up_s.n1 48.1775
R1286 up_s up_s.n0 0.29975
R1287 up_s up_s.t1 13.4235
R1288 up_s.n0 up_s.t3 13.1242
R1289 up_s.n1 up_s.t2 14.0207
R1290 vcp_p.t4 vcp_p.n0 3.11042
R1291 vcp_p.n0 vcp_p.t3 50.5496
R1292 vcp_p.n3 vcp_p.n0 11.057
R1293 vcp_p.n4 vcp_p.n2 0.9635
R1294 vcp_p.n4 vcp_p.n3 0.05
R1295 vcp_p.n6 vcp_p.n5 4.5005
R1296 vcp_p.n6 vcp_p.n4 12.6275
R1297 vcp_p vcp_p.n6 25.0486
R1298 vcp_p vcp_p.t0 24.8119
R1299 vcp_p.n5 vcp_p.t6 14.4254
R1300 vcp_p.n5 vcp_p.t5 13.2734
R1301 vcp_p.n3 vcp_p.t7 60.139
R1302 vcp_p.n2 vcp_p.t8 60.139
R1303 vcp_p.n2 vcp_p.n1 10.8995
R1304 vcp_p.n1 vcp_p.t2 3.11042
R1305 vcp_p.n1 vcp_p.t1 50.5496
C0 vdd a_22044_n100 0.00404f
C1 pfd_up vbp 0.0647f
C2 vref vi 2.95099f
C3 bias_ref a_10200_11024 0.01361f
C4 a_2000_11024 vbl 0
C5 en_b cp_trim1 0
C6 pfd_up vst 0.1208f
C7 pll_en vbh 0
C8 pll_en vbn_vco 0.43835f
C9 pfd_up vnt 0
C10 pll_en r4 0.00532f
C11 vdd a_21350_n100 0.00228f
C12 vref t2 0.00612f
C13 vref bias_ref 0.13459f
C14 a_4200_11024 vbl 0
C15 t1a vfilt 0.03621f
C16 up_s vctrl 0.40817f
C17 vdump cp_trim0 0
C18 vco_out a_22044_n100 0.05502f
C19 vref vbt 0.00547f
C20 pll_en vs 0.34971f
C21 pll_en va 0.14123f
C22 up_b vdump 0.05754f
C23 vref a_12000_18476 0.00106f
C24 en_b cp_trim0 0.38101f
C25 a_11400_11024 a_10200_11024 0.00585f
C26 a_15612_1350 vbn_vco 0.01256f
C27 pll_en vcp_p 0.33323f
C28 nb dx 0.00442f
C29 vdump a_400_11024 0
C30 en_b up_b 0.1339f
C31 a_15612_1350 r4 0.00202f
C32 pll_en vi 0.40577f
C33 vcl t1a 0
C34 pll_en vco_div2 0.09649f
C35 up_s vbn_vco 0
C36 dqn nb 0.02794f
C37 vco_out a_21350_n100 0.01534f
C38 a_15616_0 a_15612_1350 0.00266f
C39 vfilt pfd_dn 0.09283f
C40 vcp_n vfilt 0.59808f
C41 up_s a_15000_11024 0.00107f
C42 up_s vs 0.07346f
C43 up_s va 0.08493f
C44 nb a_20918_1350 0.00624f
C45 vbp vfilt 0.21533f
C46 vcp_p up_s 2.4573f
C47 dn_s vref 0.01204f
C48 dn_b t1b 0.03197f
C49 a_16984_0 a_18352_n100 0
C50 vref vbp_vco 0.08834f
C51 vdd cp_trim1 0.20013f
C52 up_s vi 0
C53 vcl pfd_dn 0.0332f
C54 nb a_18352_n100 0.19005f
C55 vcl vcp_n 0.04242f
C56 vref a_10800_18476 0.00106f
C57 a_13200_18476 vbp 0.00418f
C58 r3 a_16296_1350 0.09961f
C59 a_16296_1350 r2 0.00202f
C60 vcl vbp 0.15457f
C61 a_14932_0 vdd 0.00238f
C62 a_16300_0 a_18352_n100 0
C63 a_16984_0 a_17668_0 0.05369f
C64 vdd t1c 0.02974f
C65 vdd cp_trim0 0.06563f
C66 up_s t2 0.12594f
C67 pfd_up t1b 0.00277f
C68 a_12600_11024 pfd_dn 0
C69 nb a_17668_0 0.0032f
C70 up_s vbt 2.54586f
C71 up_b vdd 3.59927f
C72 a_12600_11024 vbp 0.01436f
C73 dn_b pfd_up 0.14217f
C74 a_14932_0 r1 0
C75 pll_en vbp_vco 1.84455f
C76 vdd dqb 0.58284f
C77 vdd r3 0.41614f
C78 vdd r2 0.38146f
C79 vco_div2 a_22044_n100 0
C80 r3 a_16980_1350 0
C81 t1a vdump 0.04835f
C82 a_15612_1350 vbp_vco 0.38827f
C83 dn_s up_s 0
C84 r3 r5 0.02161f
C85 r3 r1 0.2114f
C86 r2 r1 0.42709f
C87 dqb vco_out 0
C88 up_s vbp_vco 0.01462f
C89 t1b vfilt 0.02295f
C90 pfd_dn vdump 0.24647f
C91 pll_en vref 0.45443f
C92 vcp_n vdump 0.66237f
C93 vbp vdump 0.11635f
C94 en_b pfd_dn 0.90025f
C95 up_b vctrl 1.59591f
C96 dn_b vfilt 0.04545f
C97 en_b vcp_n 0.6197f
C98 cp_trim1 vs 0.00101f
C99 a_14932_0 vbn_vco 0.31195f
C100 vcl t1b 0
C101 en_b vbp 0.16919f
C102 va cp_trim1 0.06961f
C103 vctrl a_400_11024 0.00176f
C104 vst vdump 0.09224f
C105 vdump vnt 0.94882f
C106 dqn dx 0.21614f
C107 a_14932_0 a_15616_0 0.05369f
C108 up_b vbh 0.01113f
C109 en_b vst 1.08808f
C110 up_b vbn_vco 0
C111 dn_b vcl 0.03675f
C112 vref up_s 0.00227f
C113 t1c vs 0
C114 cp_trim0 vs 0.00101f
C115 va cp_trim0 0.05063f
C116 t1a vdd 1.37505f
C117 a_20918_1350 dx 0.06711f
C118 a_2000_11024 vdump 0.00395f
C119 up_b a_13800_11024 0
C120 up_b a_15000_11024 0
C121 up_b vs 0.037f
C122 dqn a_20918_1350 0.01517f
C123 up_b va 0.05067f
C124 r3 vbn_vco 0.06692f
C125 vbn_vco r2 0.15313f
C126 t2 cp_trim1 0.2775f
C127 a_4200_11024 vdump 0
C128 bias_ref cp_trim1 0
C129 r3 r4 0.30134f
C130 r4 r2 0.01867f
C131 vst a_16296_1350 0
C132 up_b vcp_p 0.08716f
C133 vbt cp_trim1 0.00826f
C134 vcl pfd_up 0.03031f
C135 a_15616_0 r3 0.00275f
C136 a_15616_0 r2 0.11441f
C137 up_b vi 0
C138 vcp_p a_400_11024 0.00113f
C139 vdd pfd_dn 0.66477f
C140 pll_en dy 0.1287f
C141 t2 t1c 0.10629f
C142 t1c bias_ref 0.00215f
C143 bias_ref cp_trim0 0
C144 t2 cp_trim0 0.5452f
C145 vcp_n vdd 4.44971f
C146 a_16300_0 a_16296_1350 0.00266f
C147 pll_en up_s 0.14607f
C148 vbt cp_trim0 0
C149 vco_div2 dqb 0.33611f
C150 vbp vdd 26.9393f
C151 pfd_up a_12600_11024 0.00557f
C152 up_b bias_ref 0.00175f
C153 nb a_17664_1350 0.00237f
C154 vbp a_16980_1350 0.00118f
C155 vst vdd 0.62575f
C156 vdd a_16984_0 0.00238f
C157 up_b a_12000_18476 0
C158 vdd vnt 0.08573f
C159 vdd nb 1.20287f
C160 a_7200_11024 a_8400_11024 0.00585f
C161 a_16984_0 a_16980_1350 0.00266f
C162 nb a_16980_1350 0
C163 vdd a_16300_0 0.00238f
C164 up_b a_11400_11024 0.0096f
C165 en_b t1b 0
C166 a_17668_0 a_18352_n100 0.0416f
C167 r5 a_16984_0 0.07245f
C168 a_16984_0 r1 0.12076f
C169 dn_b vdump 0.67541f
C170 vcl vfilt 0.09853f
C171 r5 nb 0.31295f
C172 nb r1 0.00205f
C173 a_14928_1350 vdd 0.60244f
C174 pll_en a_22044_n100 0
C175 nb vco_out 0.66809f
C176 vdump vbl 2.10419f
C177 dn_b en_b 0
C178 up_b vbp_vco 0.00984f
C179 r5 a_16300_0 0
C180 a_16300_0 r1 0.01603f
C181 vctrl a_7800_17156 0
C182 vctrl pfd_dn 0.80268f
C183 vcl a_13200_18476 0.00173f
C184 t1a vs 0
C185 up_b a_10800_18476 0.00344f
C186 pll_en a_21350_n100 0
C187 vcp_n vctrl 0.3489f
C188 pfd_up vdump 0.40291f
C189 a_14928_1350 r1 0
C190 dy a_22044_n100 0.08834f
C191 vbp vctrl 0.43053f
C192 r3 vbp_vco 0.0616f
C193 vbp_vco r2 0.03427f
C194 vref cp_trim1 0.28609f
C195 en_b pfd_up 0.11699f
C196 a_8400_11024 vdump 0
C197 vbh pfd_dn 0
C198 vst vctrl 0.15852f
C199 vctrl vnt 0.71316f
C200 pfd_dn vbn_vco 0.05603f
C201 dy a_21350_n100 0.06414f
C202 vbp vbn_vco 0.51175f
C203 pfd_dn a_13800_11024 0
C204 vref t1c 0.01204f
C205 a_15000_11024 pfd_dn 0
C206 t1b vdd 1.66469f
C207 pfd_dn vs 0.10049f
C208 vref cp_trim0 0.75806f
C209 vcp_n vs 0.01665f
C210 va pfd_dn 0.05058f
C211 t2 t1a 0.36991f
C212 vcp_n va 0.11263f
C213 a_2000_11024 vctrl 0
C214 up_b vref 0.09654f
C215 vbh vnt 1.98218f
C216 vbp vs 0.05935f
C217 vst vbn_vco 0.11539f
C218 a_16984_0 vbn_vco 0.28019f
C219 vbn_vco vnt 0
C220 t1a vbt 0.08486f
C221 va vbp 1.95094f
C222 vcp_p pfd_dn 0.32379f
C223 a_16984_0 r4 0.00733f
C224 vcp_p vcp_n 2.08698f
C225 dn_b vdd 0.63261f
C226 vi pfd_dn 0
C227 vctrl a_6600_17156 0.00648f
C228 a_4200_11024 vctrl 0
C229 r4 nb 0.00273f
C230 vdd vbl 1.02105f
C231 vcp_p vbp 0.07181f
C232 pll_en cp_trim1 0
C233 va vst 0.67084f
C234 va vnt 0.49737f
C235 vbp vi 0.09054f
C236 vcp_n a_1200_18656 0.00174f
C237 a_16300_0 vbn_vco 0.28232f
C238 vfilt vdump 0.15825f
C239 a_16300_0 r4 0.11476f
C240 bias_ref a_7800_17156 0.00948f
C241 vi vst 0.05622f
C242 pfd_dn bias_ref 0.00199f
C243 t2 pfd_dn 0.2255f
C244 a_14928_1350 vbn_vco 0.04947f
C245 vi vnt 0.03911f
C246 vcp_n t2 2.00796f
C247 a_15616_0 a_16300_0 0.05369f
C248 vcp_n bias_ref 0
C249 pfd_up vdd 1.12703f
C250 pll_en cp_trim0 0.06917f
C251 vbt pfd_dn 0.0023f
C252 a_21350_n100 a_22044_n100 0.01236f
C253 vcp_n vbt 0.4473f
C254 t2 vbp 2.72289f
C255 up_b pll_en 1.05529f
C256 vbp vbt 5.28987f
C257 up_s cp_trim1 0.07199f
C258 vcp_p a_2000_11024 0.02136f
C259 vcl vdump 0.07901f
C260 vbp a_12000_18476 0.00764f
C261 bias_ref vnt 0.10244f
C262 vdd dx 0.12354f
C263 vcp_p a_4200_11024 0.0049f
C264 en_b vcl 0.69337f
C265 dqn vdd 0.75291f
C266 pll_en dqb 0.11437f
C267 pfd_dn a_11400_11024 0
C268 up_s cp_trim0 0.06681f
C269 a_12600_11024 vdump 0
C270 vbp a_11400_11024 0.00244f
C271 a_7200_11024 vdump 0
C272 up_b up_s 0.24478f
C273 vdd a_20918_1350 0.33527f
C274 dn_s pfd_dn 0.16656f
C275 dn_b vctrl 0.0624f
C276 dn_s vcp_n 1.59539f
C277 pfd_dn vbp_vco 0.11709f
C278 vco_out dx 0.31621f
C279 vctrl vbl 2.93372f
C280 r3 a_15612_1350 0.0142f
C281 a_15612_1350 r2 0.24421f
C282 dn_s vbp 0.00596f
C283 dy dqb 0.00547f
C284 dqn vco_out 0.52411f
C285 vbt a_4200_11024 0.00785f
C286 vbp vbp_vco 0.04316f
C287 pfd_dn a_10800_18476 0.01033f
C288 vdd a_18352_n100 0.00689f
C289 t1b vs 0
C290 vfilt vdd 0.64136f
C291 dn_b vbh 0.00796f
C292 t1b va 0.93846f
C293 vref t1a 0.00602f
C294 vst vbp_vco 0.17446f
C295 vbh vbl 0.19544f
C296 vco_out a_20918_1350 0.0543f
C297 a_17664_1350 a_17668_0 0.00266f
C298 vbp_vco vnt 0
C299 pfd_up vctrl 0.0472f
C300 pfd_dn a_10200_11024 0
C301 dn_b vs 0.04385f
C302 vdd a_17668_0 0.00238f
C303 dn_b va 0
C304 vcl vdd 0.04448f
C305 a_8400_11024 vctrl 0
C306 a_4200_11024 a_6000_11024 0.00234f
C307 vco_out a_18352_n100 0.0037f
C308 r5 a_18352_n100 0.08457f
C309 a_18352_n100 r1 0
C310 dn_b vcp_p 0.05729f
C311 pfd_up vbh 0.00826f
C312 pfd_up vbn_vco 0.00544f
C313 vcp_p vbl 0.00934f
C314 dn_b vi 0
C315 vref pfd_dn 0.10935f
C316 t1b t2 0.18883f
C317 vref vcp_n 0.02372f
C318 a_14928_1350 vbp_vco 0.413f
C319 vi vbl 0.01838f
C320 pfd_up a_13800_11024 0.00557f
C321 dqb a_22044_n100 0.00317f
C322 pfd_up a_15000_11024 0.00557f
C323 a_12600_11024 vdd 0.00153f
C324 t1b vbt 0.08426f
C325 vref vbp 2.20903f
C326 pfd_up vs 0.10183f
C327 vco_out a_17668_0 0
C328 r5 a_17668_0 0.1222f
C329 a_17668_0 r1 0.00191f
C330 pfd_up va 0.061f
C331 en_b vdump 1.02541f
C332 dn_b t2 0.03559f
C333 dn_b bias_ref 0.00244f
C334 pfd_up vcp_p 0.04833f
C335 vref vst 0.67466f
C336 vref vnt 1.62789f
C337 pfd_up vi 0
C338 dqb a_21350_n100 0
C339 vbt vbl 2.07198f
C340 vcp_p a_8400_11024 0.00353f
C341 vfilt vctrl 5.98429f
C342 up_s t1a 0.08486f
C343 pll_en pfd_dn 0.09331f
C344 pfd_up t2 0.00175f
C345 pll_en vcp_n 0.00414f
C346 pfd_up bias_ref 0.00295f
C347 dn_b a_11400_11024 0
C348 dqn vco_div2 0
C349 pll_en vbp 0.5663f
C350 vref a_6600_17156 0.00948f
C351 t1c cp_trim1 0.17179f
C352 cp_trim0 cp_trim1 0.83322f
C353 vcl vctrl 0.09988f
C354 r4 a_18352_n100 0.0018f
C355 a_6000_11024 vbl 0
C356 a_8400_11024 bias_ref 0.0018f
C357 up_b cp_trim1 0.01011f
C358 pll_en vst 0.10226f
C359 pll_en vnt 0
C360 dn_s dn_b 0.04766f
C361 a_13200_18476 a_14400_18476 0.00585f
C362 vfilt vs 0.71378f
C363 pll_en nb 0.56138f
C364 en_b a_17664_1350 0
C365 va vfilt 0.05613f
C366 vdd vdump 3.07226f
C367 up_s pfd_dn 0.08862f
C368 t1c cp_trim0 1.25298f
C369 up_s vcp_n 0.26351f
C370 vbn_vco a_17668_0 0.18888f
C371 pfd_up a_11400_11024 0.01173f
C372 a_12600_11024 vctrl 0
C373 dn_b a_10800_18476 0.01243f
C374 r4 a_17668_0 0.0725f
C375 vcp_p vfilt 0.07239f
C376 up_s vbp 3.11325f
C377 a_7200_11024 vctrl 0.00329f
C378 up_b cp_trim0 0.04536f
C379 en_b vdd 3.51609f
C380 a_13200_18476 vs 0.00168f
C381 vcl vs 2.03947f
C382 a_14932_0 r3 0.11452f
C383 a_14932_0 r2 0.0814f
C384 a_13200_18476 va 0.0036f
C385 vcl va 0.9198f
C386 vfilt a_1200_18656 0.00928f
C387 up_s vst 0.04556f
C388 pfd_up vbp_vco 0.03194f
C389 dn_b a_10200_11024 0.0025f
C390 vcl vcp_p 0.00659f
C391 t1b vref 0.00927f
C392 t2 vfilt 0.0745f
C393 pfd_up a_10800_18476 0.01304f
C394 vdd a_16296_1350 0.54024f
C395 a_12600_11024 a_13800_11024 0.00585f
C396 vbt vfilt 0.28746f
C397 a_16296_1350 a_16980_1350 0.08564f
C398 a_14928_1350 a_15612_1350 0.08564f
C399 dn_b vref 0.061f
C400 vref vbl 0.02239f
C401 r3 r2 0.57744f
C402 a_7200_11024 vcp_p 0.00353f
C403 pfd_up a_10200_11024 0
C404 vcl t2 0
C405 vcl bias_ref 0.00215f
C406 r5 a_16296_1350 0
C407 a_16296_1350 r1 0.00382f
C408 vdd a_17664_1350 0.6635f
C409 vcl vbt 0.16559f
C410 a_13200_18476 a_12000_18476 0.00585f
C411 vcl a_12000_18476 0.00132f
C412 a_8400_11024 a_10200_11024 0.00234f
C413 a_16980_1350 a_17664_1350 0.08564f
C414 vctrl vdump 5.72146f
C415 pll_en t1b 0
C416 pfd_up vref 0.10767f
C417 en_b vctrl 0.31515f
C418 dn_s vfilt 0.15862f
C419 vdd a_16980_1350 0.54226f
C420 vco_out a_17664_1350 0
C421 r5 a_17664_1350 0.2568f
C422 a_17664_1350 r1 0.00202f
C423 dn_b pll_en 0.0102f
C424 t1a cp_trim1 0.13592f
C425 vbh vdump 0.97487f
C426 nb a_21350_n100 0
C427 vdump vbn_vco 0.00112f
C428 vdd vco_out 0.98614f
C429 vdd r5 0.82475f
C430 vdd r1 0.36805f
C431 en_b vbn_vco 1.19135f
C432 dn_s vcl 0
C433 a_13800_11024 vdump 0
C434 t1b up_s 0.08426f
C435 a_15000_11024 vdump 0
C436 vdump vs 0.04935f
C437 a_16980_1350 r1 0.24402f
C438 r5 a_16980_1350 0.10979f
C439 a_12600_11024 a_11400_11024 0.00585f
C440 va vdump 0.05061f
C441 t1a t1c 0.06958f
C442 t1a cp_trim0 0.14684f
C443 en_b a_13800_11024 0
C444 en_b a_15000_11024 0
C445 en_b vs 0.3314f
C446 pfd_up pll_en 0.12181f
C447 vcp_p vdump 1.9844f
C448 vcl a_10800_18476 0.00132f
C449 a_7200_11024 a_6000_11024 0.00585f
C450 up_b t1a 0.02861f
C451 en_b va 0.55772f
C452 pfd_dn cp_trim1 0.24514f
C453 vi vdump 0
C454 r5 vco_out 0.00247f
C455 r5 r1 0.38587f
C456 vcp_n cp_trim1 1.25092f
C457 a_16296_1350 vbn_vco 0.00348f
C458 vbp cp_trim1 0.14849f
C459 a_16296_1350 r4 0.24896f
C460 en_b vi 0.38028f
C461 vref vfilt 0.111f
C462 pll_en dx 0.03766f
C463 pfd_dn t1c 0.08129f
C464 vdd vctrl 3.3102f
C465 vcp_n t1c 0.47648f
C466 pfd_dn cp_trim0 0.73576f
C467 pll_en dqn 0.29871f
C468 vdump bias_ref 0.06049f
C469 vcp_n cp_trim0 0.68257f
C470 pfd_up up_s 0.30919f
C471 vbp t1c 0
C472 vbt vdump 2.92596f
C473 vbp cp_trim0 0.06629f
C474 up_b pfd_dn 0.18418f
C475 up_b vcp_n 0.32157f
C476 a_13200_18476 vref 0.01727f
C477 vcl vref 4.35826f
C478 r4 a_17664_1350 0.09586f
C479 pll_en a_20918_1350 0.01284f
C480 up_b vbp 0.09944f
C481 vbh vdd 4.90095f
C482 vdd vbn_vco 1.58096f
C483 dy dx 0.09274f
C484 vdd r4 0.38676f
C485 dqn dy 0.50938f
C486 up_b vst 0.09999f
C487 a_11400_11024 vdump 0
C488 pll_en a_18352_n100 0.06257f
C489 vdd vs 0.22162f
C490 a_15616_0 vdd 0.00238f
C491 a_12600_11024 vref 0.00454f
C492 r4 a_16980_1350 0.00279f
C493 va vdd 2.25738f
C494 a_6000_11024 vdump 0.00304f
C495 dy a_20918_1350 0.00184f
C496 a_14932_0 a_14928_1350 0.00266f
C497 r3 a_16984_0 0
C498 vcp_p vdd 10.4695f
C499 r5 vbn_vco 0.02158f
C500 vbn_vco r1 0.10304f
C501 dn_s vdump 0.81366f
C502 vdd vco_div2 0.27243f
C503 vi vdd 0.13531f
C504 r5 r4 0.59901f
C505 r4 r1 0.26836f
C506 vdump vbp_vco 0.01437f
C507 pll_en a_17668_0 0
C508 a_2000_11024 a_400_11024 0.00585f
C509 vcl pll_en 0.21443f
C510 a_15616_0 r1 0.08366f
C511 en_b vbp_vco 0.15763f
C512 up_s vfilt 0.06736f
C513 r3 a_16300_0 0.06965f
C514 a_16300_0 r2 0.00191f
C515 vdd bias_ref 0.19297f
C516 t2 vdd 2.60432f
C517 dx a_22044_n100 0.00219f
C518 dqn a_22044_n100 0.1022f
C519 vbt vdd 9.68036f
C520 vco_div2 vco_out 0
C521 a_14928_1350 r3 0.25032f
C522 a_14928_1350 r2 0.10255f
C523 vdd a_12000_18476 0.00672f
C524 vdump a_10200_11024 0
C525 t1b cp_trim1 1.60789f
C526 a_16296_1350 vbp_vco 0.38352f
C527 vbh vctrl 2.66724f
C528 vctrl vbn_vco 0.13985f
C529 dx a_21350_n100 0.07283f
C530 dn_b cp_trim1 0.07889f
C531 dqn a_21350_n100 0.00189f
C532 vref vdump 0.10204f
C533 t1b t1c 0.7097f
C534 vctrl a_13800_11024 0
C535 t1b cp_trim0 0.05587f
C536 vdd a_11400_11024 0.01151f
C537 a_15000_11024 vctrl 0
C538 vctrl vs 0.68186f
C539 va vctrl 1.51072f
C540 t1a pfd_dn 0.05385f
C541 vcp_n t1a 1.13533f
C542 up_b t1b 0
C543 en_b vref 1.06825f
C544 vbp_vco a_17664_1350 0.28051f
C545 a_14400_18476 vs 0.00168f
C546 vcp_p vctrl 0.17471f
C547 t1a vbp 1.40087f
C548 r4 vbn_vco 0.03849f
C549 dn_b t1c 0.06526f
C550 va a_14400_18476 0.00672f
C551 dn_s vdd 0.02751f
C552 dn_b cp_trim0 0.69419f
C553 vi vctrl 3.65475f
C554 vdd vbp_vco 7.2047f
C555 vbn_vco vs 0.19054f
C556 pfd_up cp_trim1 0.1647f
C557 a_15616_0 vbn_vco 0.28811f
C558 dn_b up_b 0.42265f
C559 vctrl a_1200_18656 0.01597f
C560 va vbn_vco 0.03922f
C561 a_15616_0 r4 0.00191f
C562 vdd a_10800_18476 0
C563 vbp_vco a_16980_1350 0.37969f
C564 a_15000_11024 a_13800_11024 0.00585f
C565 vcp_p vbh 0.00561f
C566 va a_13800_11024 0.01435f
C567 va vs 0.06839f
C568 va a_15000_11024 0.00339f
C569 vcp_n pfd_dn 0.19733f
C570 vbl a_400_11024 0
C571 vctrl bias_ref 0.11158f
C572 vi vbh 0.09413f
C573 vi vbn_vco 0.13466f
C574 pll_en vdump 0.07952f
C575 pfd_up t1c 0
C576 pfd_up cp_trim0 0.10106f
C577 vbp pfd_dn 0.10089f
C578 vbt vctrl 1.11719f
C579 vcp_n vbp 7.47115f
C580 r5 vbp_vco 0.04056f
C581 vbp_vco r1 0.02785f
C582 vcp_p vs 0.01534f
C583 vcp_p va 0
C584 up_b pfd_up 3.72269f
C585 en_b pll_en 3.11945f
C586 vi vs 0.49788f
C587 va vi 0.05216f
C588 vst pfd_dn 0.10061f
C589 pfd_dn vnt 0
C590 vbh bias_ref 0.15735f
C591 vcp_p vi 0
C592 vbp vst 0.48214f
C593 vbt vbh 0
C594 vbp vnt 0.00258f
C595 vref vdd 0.67789f
C596 vcp_p a_1200_18656 0.00697f
C597 vctrl a_11400_11024 0
C598 t2 vs 0
C599 up_s vdump 0.33478f
C600 bias_ref vs 0.13938f
C601 t2 va 0.59898f
C602 vctrl a_6000_11024 0.01456f
C603 va bias_ref 0
C604 vbt vs 0.07378f
C605 vst vnt 0.00255f
C606 va vbt 0.0848f
C607 en_b up_s 0.85347f
C608 vfilt cp_trim1 0.00699f
C609 a_12000_18476 vs 0.00168f
C610 vcp_p bias_ref 0.06097f
C611 a_6600_17156 a_7800_17156 0.00585f
C612 dn_s vctrl 0.60046f
C613 vcp_p vbt 0.35248f
C614 vi bias_ref 0.05055f
C615 vctrl vbp_vco 0.05182f
C616 dqb dx 0
C617 dqn dqb 0.1844f
C618 a_16300_0 a_16984_0 0.05369f
C619 a_15612_1350 a_16296_1350 0.08564f
C620 pll_en a_17664_1350 0.01914f
C621 vfilt cp_trim0 0.01459f
C622 vcl cp_trim1 0.00301f
C623 t1b t1a 0.09526f
C624 pll_en vdd 5.82263f
C625 vbp_vco vbn_vco 3.05745f
C626 t2 vbt 0.12594f
C627 vcp_p a_11400_11024 0
C628 r4 vbp_vco 0.03122f
C629 dn_s vs 0
C630 vcp_p a_6000_11024 0.00353f
C631 vctrl a_10200_11024 0
C632 pll_en a_16980_1350 0.00255f
C633 dn_b t1a 1.04655f
C634 vbp_vco vs 0.61296f
C635 vcl t1c 0
C636 vcl cp_trim0 0.52184f
C637 va vbp_vco 0.04169f
C638 a_4200_11024 a_2000_11024 0.00234f
C639 dn_s vcp_p 0.69256f
C640 a_10800_18476 vs 0.00168f
C641 up_b vcl 0.02975f
C642 vdd a_15612_1350 0.54021f
C643 dy vdd 0.42004f
C644 pll_en vco_out 0.62478f
C645 pll_en r5 0.03735f
C646 vref vctrl 0.67157f
C647 t1b pfd_dn 0.03281f
C648 vi vbp_vco 0.92122f
C649 t1b vcp_n 0.17079f
C650 up_s vdd 4.05065f
C651 t1b vbp 1.907f
C652 pfd_up t1a 0.0048f
C653 vbt a_6000_11024 0
C654 up_b a_12600_11024 0
C655 dn_b pfd_dn 3.79335f
C656 dn_b vcp_n 0.19577f
C657 vref vbh 0.13429f
C658 vref vbn_vco 0.1597f
C659 a_15612_1350 r1 0.09617f
C660 dn_s vbt 0.08843f
C661 dn_b vbp 0.00407f
C662 dy vco_out 0.21633f
C663 vcp_p a_10200_11024 0.00353f
C664 vref a_13800_11024 0.00398f
C665 bias_ref a_10800_18476 0.00953f
C666 vref vs 0.12242f
C667 vref va 1.95654f
C668 vbl vnt 0.17164f
C669 pll_en vctrl 0.41216f
C670 a_12000_18476 a_10800_18476 0.00585f
C671 pfd_up pfd_dn 5.64889f
C672 vref vcp_p 0.00349f
C673 pfd_up vcp_n 0.06644f
C674 vco_div2 vss 0.210661f
C675 bias_ref vss 6.53433f
C676 pll_en vss 4.35949f
C677 pfd_up vss 1.63493f
C678 cp_trim1 vss 2.22997f
C679 cp_trim0 vss 1.40086f
C680 pfd_dn vss 1.38622f
C681 vctrl vss 20.6556f
C682 vdd vss 396.898f
C683 a_22044_n100 vss 0.255159f
C684 a_21350_n100 vss 0.186011f
C685 a_18352_n100 vss 0.310512f
C686 a_17668_0 vss 0.170323f
C687 a_16984_0 vss 0.118285f
C688 a_16300_0 vss 0.117082f
C689 a_15616_0 vss 0.117146f
C690 a_14932_0 vss 0.176969f
C691 dx vss 0.255925f
C692 a_20918_1350 vss 0.0397053f
C693 dy vss 0.224565f
C694 dqn vss 0.47126f
C695 vco_out vss 0.365574f
C696 dqb vss 0.372556f
C697 nb vss 0.431867f
C698 r4 vss 0.24306f
C699 r5 vss 0.504069f
C700 r3 vss 0.252913f
C701 r1 vss 0.269351f
C702 r2 vss 0.28926f
C703 a_17664_1350 vss 0.00370423f
C704 a_16980_1350 vss 0.00103879f
C705 a_16296_1350 vss 0.00103038f
C706 a_15612_1350 vss 0.00106774f
C707 a_14928_1350 vss 0.00696934f
C708 vi vss 0.92919f
C709 vnt vss 2.58891f
C710 vbn_vco vss 3.41156f
C711 vst vss 2.09077f
C712 vbh vss 0.939179f
C713 vbl vss 3.18514f
C714 vbp_vco vss 1.49309f
C715 a_15000_11024 vss 0.66425f
C716 a_14400_18476 vss 0.68276f
C717 a_13800_11024 vss 0.65668f
C718 a_13200_18476 vss 0.67329f
C719 a_12600_11024 vss 0.65668f
C720 a_12000_18476 vss 0.67329f
C721 a_11400_11024 vss 0.65668f
C722 a_10800_18476 vss 0.67854f
C723 a_10200_11024 vss 0.67606f
C724 a_8400_11024 vss 0.6626f
C725 a_7800_17156 vss 0.66004f
C726 a_7200_11024 vss 0.65668f
C727 a_6600_17156 vss 0.66004f
C728 a_6000_11024 vss 0.6626f
C729 a_4200_11024 vss 0.66852f
C730 vs vss 4.62873f
C731 a_2000_11024 vss 1.06033f
C732 a_1200_18656 vss 1.08054f
C733 a_400_11024 vss 1.07671f
C734 vcl vss 2.73178f
C735 up_b vss 0.507392f
C736 en_b vss 3.14929f
C737 t1c vss 0.558989f
C738 vdump vss 1.74945f
C739 dn_b vss 1.99834f
C740 dn_s vss 1.27478f
C741 vref vss 11.7164f
C742 t1b vss 0.897007f
C743 va vss 2.13155f
C744 t1a vss 1.0133f
C745 t2 vss 0.492926f
C746 vcp_n vss 6.41256f
C747 vbt vss 0.690943f
C748 vbp vss 1.51224f
C749 up_s vss 1.44561f
C750 vcp_p vss 4.59448f
C751 vcp_p.t4 vss 0.88487f
C752 vcp_p.n0 vss 0.380688f
C753 vcp_p.t2 vss 0.88487f
C754 vcp_p.n1 vss 0.379837f
C755 vcp_p.n2 vss 0.338768f
C756 vcp_p.n3 vss 0.326739f
C757 vcp_p.n4 vss 0.117713f
C758 vcp_p.t5 vss 0.532286f
C759 vcp_p.t6 vss 0.540364f
C760 vcp_p.n5 vss 0.194271f
C761 vcp_p.n6 vss 0.624944f
C762 vcp_p.t0 vss 0.104715f
C763 up_s.t0 vss 0.91501f
C764 up_s.t2 vss 0.920318f
C765 up_s.t3 vss 0.203391f
C766 up_s.t1 vss 0.191081f
C767 up_s.n0 vss 0.907057f
C768 up_s.n1 vss 1.10565f
C769 vbp.t1 vss 0.176461f
C770 vbp.t2 vss 0.123116f
C771 vbp.t0 vss 0.075964f
C772 vbp.n0 vss 0.804362f
C773 vbp.n1 vss 0.510183f
C774 vbp.n2 vss 0.275076f
C775 vbp.n3 vss 0.26421f
C776 vbp.n4 vss 0.275076f
C777 vbp.n5 vss 0.271372f
C778 vbp.t4 vss 0.148507f
C779 vbp.n6 vss 0.261656f
C780 vbp.n7 vss 0.174856f
C781 vbp.n8 vss 0.256948f
C782 vbp.n9 vss 0.263814f
C783 vbp.n10 vss 0.26421f
C784 vbp.n11 vss 0.275076f
C785 vbp.n12 vss 0.275076f
C786 vbp.n13 vss 0.499317f
C787 vbp.n14 vss 0.473254f
C788 vbp.n15 vss 0.166628f
C789 vbt.t3 vss 0.135422f
C790 vbt.t6 vss 0.111732f
C791 vbt.t0 vss 0.135422f
C792 vbt.n0 vss 0.082182f
C793 vbt.t1 vss 0.135422f
C794 vbt.n1 vss 0.0480551f
C795 vbt.t7 vss 0.108843f
C796 vbt.n2 vss 0.0456291f
C797 vbt.t8 vss 0.108843f
C798 vbt.n3 vss 0.0456291f
C799 vbt.t2 vss 0.135422f
C800 vbt.n4 vss 0.0464502f
C801 vbt.t9 vss 0.111199f
C802 vbt.n5 vss 0.415469f
C803 vbt.t5 vss 0.274096f
C804 vbt.n6 vss 0.553095f
C805 vbt.t4 vss 0.270652f
C806 vbt.n7 vss 0.3245f
C807 vbt.t11 vss 0.270652f
C808 vbt.n8 vss 0.442565f
C809 vbt.t10 vss 0.289759f
C810 vbt.n9 vss 0.0707213f
C811 vcp_n.t9 vss 0.510243f
C812 vcp_n.n0 vss 0.328661f
C813 vcp_n.t7 vss 0.510243f
C814 vcp_n.n1 vss 0.336373f
C815 vcp_n.n2 vss 0.328289f
C816 vcp_n.n3 vss 0.269565f
C817 vcp_n.n4 vss 0.269565f
C818 vcp_n.n5 vss 0.25037f
C819 vcp_n.t10 vss 0.172882f
C820 vcp_n.n6 vss 0.17389f
C821 vcp_n.t4 vss 0.165079f
C822 vcp_n.n7 vss 0.170509f
C823 vcp_n.t5 vss 0.161111f
C824 vcp_n.n8 vss 0.413238f
C825 vcp_n.t11 vss 0.141462f
C826 vcp_n.n9 vss 0.276029f
C827 vcp_n.t2 vss 0.669138f
C828 vcp_n.t0 vss 0.635763f
C829 vcp_n.n10 vss 0.441372f
C830 vcp_n.t3 vss 0.635763f
C831 vcp_n.n11 vss 0.751314f
C832 vcp_n.t1 vss 0.671932f
C833 vcp_n.n12 vss 0.571195f
C834 vcp_n.n13 vss 0.0792575f
C835 t2.t2 vss 0.103311f
C836 t2.t1 vss 0.283973f
C837 t2.t0 vss 0.343446f
C838 t2.n0 vss 0.551594f
C839 t1a.t1 vss 0.144695f
C840 t1a.t0 vss 0.647026f
C841 va.t0 vss 1.53336f
C842 va.t1 vss 0.224095f
C843 va.n0 vss 0.134778f
C844 va.t2 vss 0.12507f
C845 va.n1 vss 1.71936f
C846 t1b.t1 vss 0.153883f
C847 t1b.t0 vss 0.550531f
C848 vref.t1 vss 0.42021f
C849 vref.n0 vss 0.488049f
C850 vref.n1 vss 0.279447f
C851 vref.n2 vss 0.258157f
C852 vref.n3 vss 0.278138f
C853 vref.n4 vss 0.175646f
C854 vref.n5 vss 0.262095f
C855 vref.n6 vss 0.626806f
C856 vref.t2 vss 0.186399f
C857 vref.n7 vss 0.499962f
C858 vref.n8 vss 0.321483f
C859 vref.n9 vss 0.62354f
C860 vref.n10 vss 0.448123f
C861 vref.t0 vss 0.359995f
C862 vref.n11 vss 1.76848f
C863 vref.n12 vss 0.164096f
C864 dn_s.t0 vss 0.591946f
C865 dn_s.t2 vss 0.580895f
C866 dn_s.n0 vss 0.217361f
C867 dn_s.t3 vss 0.232869f
C868 dn_s.n1 vss 0.323389f
C869 dn_s.t1 vss 0.206643f
C870 dn_b.t1 vss 0.156824f
C871 dn_b.t0 vss 0.166675f
C872 dn_b.n0 vss 1.43899f
C873 vdump.t7 vss 0.134639f
C874 vdump.n0 vss 0.139682f
C875 vdump.t5 vss 0.134639f
C876 vdump.n1 vss 0.143266f
C877 vdump.t0 vss 0.149416f
C878 vdump.n2 vss 0.109801f
C879 vdump.t1 vss 0.152153f
C880 vdump.n3 vss 0.136783f
C881 vdump.t15 vss 0.418363f
C882 vdump.t13 vss 0.135675f
C883 vdump.n4 vss 0.149083f
C884 vdump.t9 vss 0.135675f
C885 vdump.n5 vss 0.145349f
C886 vdump.n6 vss 0.165531f
C887 vdump.t11 vss 0.135675f
C888 vdump.n7 vss 0.145349f
C889 vdump.n8 vss 0.116682f
C890 vdump.t3 vss 0.135675f
C891 vdump.n9 vss 0.145349f
C892 vdump.n10 vss 0.0511762f
C893 vdump.t16 vss 0.251536f
C894 vdump.n11 vss 0.149575f
C895 vdump.t17 vss 0.251536f
C896 vdump.n12 vss 0.45606f
C897 vdump.t14 vss 0.298555f
C898 vdump.n13 vss 0.0766073f
C899 vdump.n14 vss 0.792399f
C900 vdump.n15 vss 0.137386f
C901 t1c.t0 vss 0.179183f
C902 t1c.t1 vss 0.183045f
C903 en_b.t1 vss 0.220171f
C904 en_b.n0 vss 0.613147f
C905 en_b.t0 vss 0.38833f
C906 en_b.n1 vss 1.39792f
C907 en_b.n2 vss 0.256445f
C908 en_b.n3 vss 0.24412f
C909 en_b.n4 vss 0.30322f
C910 en_b.n5 vss 1.23997f
C911 up_b.t1 vss 0.0835504f
C912 up_b.n0 vss 0.732498f
C913 up_b.t0 vss 0.435069f
C914 vcl.t0 vss 0.573785f
C915 vcl.t1 vss 0.564993f
C916 vcl.n0 vss 0.0774066f
C917 vcl.t2 vss 0.564993f
C918 vcl.n1 vss 0.17009f
C919 vcl.t4 vss 0.570607f
C920 vcl.n2 vss 0.329279f
C921 vcl.t3 vss 0.164624f
C922 vs.t1 vss 0.2689f
C923 vs.t0 vss 0.265748f
C924 vs.n0 vss 1.83153f
C925 vs.t2 vss 1.2206f
C926 vbp_vco.t1 vss 0.225917f
C927 vbp_vco.t0 vss 0.216677f
C928 vbp_vco.n0 vss 0.251436f
C929 vbp_vco.n1 vss 0.172992f
C930 vbp_vco.t4 vss 0.125269f
C931 vbp_vco.n2 vss 0.151481f
C932 vbp_vco.n3 vss 0.173121f
C933 vbp_vco.n4 vss 0.126633f
C934 vbp_vco.t6 vss 0.125269f
C935 vbp_vco.n5 vss 0.14716f
C936 vbp_vco.n6 vss 0.0573177f
C937 vbp_vco.t2 vss 0.0781321f
C938 vbp_vco.n7 vss 0.190548f
C939 vbp_vco.n8 vss 0.0785473f
C940 vbp_vco.n9 vss 0.0782479f
C941 vbp_vco.n10 vss 0.0388937f
C942 vbp_vco.n11 vss 0.0782479f
C943 vbp_vco.n12 vss 0.0423536f
C944 vbp_vco.n13 vss 0.0782479f
C945 vbp_vco.n14 vss 0.0677199f
C946 vbp_vco.n15 vss 0.0809202f
C947 vbp_vco.n16 vss 0.259632f
C948 vbl.t4 vss 0.263279f
C949 vbl.t5 vss 0.290258f
C950 vbl.t6 vss 0.263279f
C951 vbl.n0 vss 0.151163f
C952 vbl.t7 vss 0.272248f
C953 vbl.n1 vss 0.299887f
C954 vbl.t1 vss 0.140386f
C955 vbl.n2 vss 0.233918f
C956 vbl.n3 vss 0.173608f
C957 vbl.n4 vss 0.336161f
C958 vbl.t3 vss 0.140386f
C959 vbl.n5 vss 0.236788f
C960 vbl.n6 vss 0.278228f
C961 vbl.n7 vss 0.316199f
C962 vbh.t1 vss 0.157536f
C963 vbh.t0 vss 0.173711f
C964 vbh.t3 vss 0.16103f
C965 vbh.n0 vss 0.173765f
C966 vbh.n1 vss 0.105459f
C967 vbh.n2 vss 0.189347f
C968 vbh.t5 vss 0.16103f
C969 vbh.n3 vss 0.175091f
C970 vbh.n4 vss 0.210964f
C971 vbh.n5 vss 0.214917f
C972 vst.t0 vss 0.316339f
C973 vst.t2 vss 0.321477f
C974 vst.n0 vss 0.281767f
C975 vst.t3 vss 0.101507f
C976 vst.n1 vss 0.472907f
C977 vst.t1 vss 0.816756f
C978 vst.n2 vss 0.188043f
C979 vbn_vco.t2 vss 0.324214f
C980 vbn_vco.t3 vss 0.329645f
C981 vbn_vco.t1 vss 0.13721f
C982 vbn_vco.n0 vss 0.228844f
C983 vbn_vco.n1 vss 0.186146f
C984 vbn_vco.t4 vss 0.13859f
C985 vbn_vco.n2 vss 0.0779306f
C986 vbn_vco.n3 vss 0.447729f
C987 vbn_vco.n4 vss 0.0779306f
C988 vbn_vco.n5 vss 0.0608667f
C989 vbn_vco.n6 vss 0.0779306f
C990 vbn_vco.n7 vss 0.0608667f
C991 vbn_vco.n8 vss 0.0779306f
C992 vbn_vco.n9 vss 0.097341f
C993 vbn_vco.n10 vss 0.0817696f
C994 vbn_vco.n11 vss 0.335977f
C995 vbn_vco.n12 vss 0.322398f
C996 vnt.t0 vss 0.299414f
C997 vnt.t1 vss 0.225543f
C998 vnt.t4 vss 0.299414f
C999 vnt.n0 vss 0.0929601f
C1000 vnt.t2 vss 0.219554f
C1001 vnt.n1 vss 0.233525f
C1002 vnt.t7 vss 0.210339f
C1003 vnt.n2 vss 0.197181f
C1004 vnt.t5 vss 0.210339f
C1005 vnt.n3 vss 0.185173f
C1006 vnt.t6 vss 0.210339f
C1007 vnt.n4 vss 0.29557f
C1008 vnt.t3 vss 0.222181f
C1009 vnt.n5 vss 0.158953f
C1010 vi.t0 vss 0.166067f
C1011 vi.t4 vss 0.230414f
C1012 vi.t3 vss 0.161781f
C1013 vi.n0 vss 0.210679f
C1014 vi.t2 vss 0.161953f
C1015 vi.n1 vss 0.0717709f
C1016 vi.t1 vss 0.172684f
C1017 vi.n2 vss 0.14674f
C1018 a_14928_1350.t1 vss 0.017186f
C1019 a_14928_1350.t3 vss 0.0108296f
C1020 a_14928_1350.t2 vss 0.010844f
C1021 a_14928_1350.n0 vss 0.0164567f
C1022 a_14928_1350.n1 vss 0.0212336f
C1023 a_14928_1350.t0 vss 0.0067849f
C1024 a_14928_1350.n2 vss 0.0101729f
C1025 a_15612_1350.t1 vss 0.00530447f
C1026 a_15612_1350.t3 vss 0.00336139f
C1027 a_15612_1350.t2 vss 0.00336575f
C1028 a_15612_1350.n0 vss 0.00503011f
C1029 a_15612_1350.n1 vss 0.00649026f
C1030 a_15612_1350.t0 vss 0.00212506f
C1031 a_15612_1350.n2 vss 0.00310943f
C1032 a_16296_1350.t1 vss 0.00513981f
C1033 a_16296_1350.t3 vss 0.00329119f
C1034 a_16296_1350.t2 vss 0.00329562f
C1035 a_16296_1350.n0 vss 0.00489085f
C1036 a_16296_1350.n1 vss 0.00631064f
C1037 a_16296_1350.t0 vss 0.00204838f
C1038 a_16296_1350.n2 vss 0.00302343f
C1039 a_16980_1350.t1 vss 0.00507585f
C1040 a_16980_1350.t3 vss 0.00331675f
C1041 a_16980_1350.t2 vss 0.00332122f
C1042 a_16980_1350.n0 vss 0.00492938f
C1043 a_16980_1350.n1 vss 0.00636029f
C1044 a_16980_1350.t0 vss 0.00196039f
C1045 a_16980_1350.n2 vss 0.00304723f
C1046 a_17664_1350.t2 vss 0.00467211f
C1047 a_17664_1350.n0 vss 0.00679967f
C1048 a_17664_1350.t1 vss 0.00756616f
C1049 a_17664_1350.t0 vss 0.00757611f
C1050 a_17664_1350.n1 vss 0.0109997f
C1051 a_17664_1350.n2 vss 0.0141929f
C1052 a_17664_1350.t3 vss 0.0116245f
C1053 r2.t0 vss 0.0364034f
C1054 r2.n0 vss 0.0740822f
C1055 r2.n1 vss 0.102617f
C1056 r2.n2 vss 0.0619698f
C1057 r2.n3 vss 0.048712f
C1058 r2.n4 vss 0.0661621f
C1059 r2.t1 vss 0.0204854f
C1060 r2.t2 vss 0.0205316f
C1061 r2.n5 vss 0.0288383f
C1062 r2.t3 vss 0.036363f
C1063 r1.t2 vss 0.0299907f
C1064 r1.n0 vss 0.0682567f
C1065 r1.n1 vss 0.0945662f
C1066 r1.n2 vss 0.0571727f
C1067 r1.n3 vss 0.0428676f
C1068 r1.n4 vss 0.0619603f
C1069 r1.t0 vss 0.0167241f
C1070 r1.t1 vss 0.0167593f
C1071 r1.n5 vss 0.0249038f
C1072 r1.t3 vss 0.029958f
C1073 r3.t1 vss 0.0322068f
C1074 r3.n0 vss 0.0648515f
C1075 r3.n1 vss 0.0939649f
C1076 r3.n2 vss 0.054286f
C1077 r3.n3 vss 0.0448787f
C1078 r3.n4 vss 0.0609393f
C1079 r3.t0 vss 0.0180971f
C1080 r3.t3 vss 0.0181359f
C1081 r3.n5 vss 0.0270433f
C1082 r3.t2 vss 0.0321731f
C1083 r5.t2 vss 0.0411096f
C1084 r5.n0 vss 0.0782953f
C1085 r5.n1 vss 0.109148f
C1086 r5.n2 vss 0.065541f
C1087 r5.n3 vss 0.0541821f
C1088 r5.n4 vss 0.0747666f
C1089 r5.n5 vss 0.0585047f
C1090 r5.n6 vss 0.0577213f
C1091 r5.n7 vss 0.0723955f
C1092 r5.n8 vss 0.0466002f
C1093 r5.t0 vss 0.0232564f
C1094 r5.t1 vss 0.0233123f
C1095 r5.n9 vss 0.0326499f
C1096 r5.t3 vss 0.0411585f
C1097 r4.t0 vss 0.0315161f
C1098 r4.n0 vss 0.0650313f
C1099 r4.n1 vss 0.0914405f
C1100 r4.n2 vss 0.0543979f
C1101 r4.n3 vss 0.0427599f
C1102 r4.n4 vss 0.0594361f
C1103 r4.t2 vss 0.0177316f
C1104 r4.t1 vss 0.0177698f
C1105 r4.n5 vss 0.0253131f
C1106 r4.t3 vss 0.0315517f
C1107 nb.t1 vss 0.0251586f
C1108 nb.n0 vss 0.0709554f
C1109 nb.t5 vss 0.0253464f
C1110 nb.t4 vss 0.0253892f
C1111 nb.n1 vss 0.0462218f
C1112 nb.t3 vss 0.0252805f
C1113 nb.t2 vss 0.0253233f
C1114 nb.n2 vss 0.0398597f
C1115 nb.n3 vss 0.100555f
C1116 nb.n4 vss 0.0617663f
C1117 nb.n5 vss 0.055704f
C1118 nb.n6 vss 0.0608372f
C1119 nb.n7 vss 0.0751726f
C1120 nb.n8 vss 0.0878376f
C1121 nb.n9 vss 0.0899396f
C1122 nb.t0 vss 0.0251157f
C1123 dqb.t1 vss 0.0948489f
C1124 dqb.n0 vss 0.113176f
C1125 dqb.n1 vss 0.0645929f
C1126 dqb.n2 vss 0.0484305f
C1127 dqb.n3 vss 0.0638902f
C1128 dqb.t0 vss 0.0424989f
C1129 vco_out.t0 vss 0.031122f
C1130 vco_out.n0 vss 0.06783f
C1131 vco_out.n1 vss 0.0995675f
C1132 vco_out.t5 vss 0.0310893f
C1133 vco_out.t4 vss 0.031122f
C1134 vco_out.n2 vss 0.0875512f
C1135 vco_out.n3 vss 0.0865408f
C1136 vco_out.n4 vss 0.109214f
C1137 vco_out.n5 vss 0.024501f
C1138 vco_out.n6 vss 0.152562f
C1139 vco_out.t3 vss 0.0310512f
C1140 vco_out.t2 vss 0.0310811f
C1141 vco_out.n7 vss 0.0674541f
C1142 vco_out.t1 vss 0.0310893f
C1143 dqn.t1 vss 0.0892633f
C1144 dqn.n0 vss 0.11581f
C1145 dqn.n1 vss 0.129332f
C1146 dqn.t2 vss 0.114647f
C1147 dqn.n2 vss 0.0853358f
C1148 dqn.n3 vss 0.11863f
C1149 dqn.n4 vss 0.0329191f
C1150 dqn.t0 vss 0.0273722f
C1151 dy.t0 vss 0.0732357f
C1152 dy.n0 vss 0.111308f
C1153 dy.n1 vss 0.109412f
C1154 dy.t1 vss 0.0852462f
C1155 a_20918_1350.t0 vss 0.0322821f
C1156 dx.t1 vss 0.116978f
C1157 dx.t0 vss 0.0502194f
C1158 dx.n0 vss 0.115726f
C1159 a_14932_0.t0 vss 0.0238193f
C1160 a_14932_0.n0 vss 0.020825f
C1161 a_14932_0.t1 vss 0.044693f
C1162 a_14932_0.t3 vss 0.0302875f
C1163 a_14932_0.t2 vss 0.0303849f
C1164 a_14932_0.n1 vss 0.0286161f
C1165 a_14932_0.n2 vss 0.104129f
C1166 a_15616_0.t0 vss 0.0205896f
C1167 a_15616_0.n0 vss 0.0183886f
C1168 a_15616_0.t3 vss 0.0390187f
C1169 a_15616_0.t2 vss 0.0255389f
C1170 a_15616_0.t1 vss 0.0256197f
C1171 a_15616_0.n1 vss 0.0252653f
C1172 a_15616_0.n2 vss 0.091943f
C1173 a_16300_0.t0 vss 0.0256558f
C1174 a_16300_0.n0 vss 0.0251189f
C1175 a_16300_0.t2 vss 0.0385539f
C1176 a_16300_0.t3 vss 0.0202337f
C1177 a_16300_0.n1 vss 0.0182796f
C1178 a_16300_0.n2 vss 0.0914044f
C1179 a_16300_0.t1 vss 0.0255746f
C1180 a_16984_0.t0 vss 0.0374805f
C1181 a_16984_0.t1 vss 0.0190761f
C1182 a_16984_0.n0 vss 0.0183697f
C1183 a_16984_0.t3 vss 0.0257996f
C1184 a_16984_0.t2 vss 0.0258816f
C1185 a_16984_0.n1 vss 0.0252382f
C1186 a_16984_0.n2 vss 0.0918453f
C1187 a_17668_0.t0 vss 0.0300337f
C1188 a_17668_0.n0 vss 0.0253906f
C1189 a_17668_0.t2 vss 0.0416876f
C1190 a_17668_0.t3 vss 0.0231576f
C1191 a_17668_0.n1 vss 0.0184799f
C1192 a_17668_0.n2 vss 0.0923995f
C1193 a_17668_0.t1 vss 0.0301299f
C1194 a_18352_n100.t1 vss 0.0285703f
C1195 a_18352_n100.n0 vss 0.0253285f
C1196 a_18352_n100.t2 vss 0.0595193f
C1197 a_18352_n100.n1 vss 0.0808712f
C1198 a_18352_n100.t3 vss 0.0325982f
C1199 a_18352_n100.n2 vss 0.0275736f
C1200 a_18352_n100.t0 vss 0.0285035f
C1201 a_21350_n100.t0 vss 0.0628193f
C1202 a_22044_n100.t0 vss 0.0452351f
C1203 a_22044_n100.n0 vss 0.0620275f
C1204 a_22044_n100.t1 vss 0.094197f
C1205 vss.t55 vss 25.3856f
C1206 vss.t83 vss 0.11229p
C1207 vss.t62 vss 0.21135f
C1208 vss.t147 vss 0.31087f
C1209 vss.t120 vss 0.31087f
C1210 vss.t176 vss 0.21135f
C1211 vss.t166 vss 0.286f
C1212 vss.t164 vss 0.27738f
C1213 vss.t143 vss 0.27738f
C1214 vss.t168 vss 0.27738f
C1215 vss.t161 vss 0.27738f
C1216 vss.t88 vss 0.27738f
C1217 vss.t106 vss 0.21798f
C1218 vss.t50 vss 0.21798f
C1219 vss.t174 vss 0.39809f
C1220 vss.t114 vss 0.0781f
C1221 vss.t139 vss 0.0778f
C1222 vss.t153 vss 0.0778f
C1223 vss.t109 vss 0.10028f
C1224 vss.t116 vss 0.09021f
C1225 vss.t48 vss 0.66495f
C1226 vss.t137 vss 0.75119f
C1227 vss.t4 vss 0.75119f
C1228 vss.t104 vss 0.75119f
C1229 vss.t21 vss 0.75119f
C1230 vss.t6 vss 0.66495f
C1231 vss.t46 vss 0.78259f
C1232 vss.t133 vss 0.14487f
C1233 vss.t155 vss 0.10047f
C1234 vss.t12 vss 0.7438f
C1235 vss.t10 vss 0.4408f
C1236 vss.t24 vss 0.43855f
C1237 vss.t33 vss 0.43855f
C1238 vss.t158 vss 0.44126f
C1239 vss.t112 vss 0.02671f
C1240 vss.t181 vss 0.0266f
C1241 vss.t179 vss 0.03475f
C1242 vss.t102 vss 0.0474f
C1243 vss.t100 vss 0.05269f
C1244 vss.t151 vss 0.03475f
C1245 vss.t126 vss 0.05421f
C1246 vss.t128 vss 0.05409f
C1247 vss.t18 vss 0.0421f
C1248 vss.t16 vss 0.04197f
C1249 vss.t54 vss 0.06043f
C1250 vss.t28 vss 0.06018f
C1251 vss.t122 vss 0.06043f
C1252 vss.t124 vss 0.06018f
C1253 vss.t42 vss 0.06043f
C1254 vss.t44 vss 0.06018f
C1255 vss.t38 vss 0.06043f
C1256 vss.t40 vss 0.06018f
C1257 vss.t170 vss 0.06043f
C1258 vss.t172 vss 0.06018f
C1259 vdd.t85 vss 1.25928f
C1260 vdd.n0 vss 1.5507f
C1261 vdd.t52 vss 1.30581f
C1262 vdd.n1 vss 0.0592428f
C1263 vdd.t5 vss 1.30581f
C1264 vdd.n2 vss 0.0602042f
C1265 vdd.n3 vss 0.171897f
C1266 vdd.t67 vss 1.25928f
C1267 vdd.n4 vss 0.0500388f
C1268 vdd.t42 vss 0.843071f
C1269 vdd.n5 vss 0.131622f
C1270 vdd.t34 vss 0.82341f
C1271 vdd.n6 vss 0.132591f
C1272 vdd.n7 vss 0.171897f
C1273 vdd.t28 vss 0.82341f
C1274 vdd.n8 vss 0.122426f
C1275 vdd.t9 vss 0.82341f
C1276 vdd.n9 vss 0.131622f
C1277 vdd.t40 vss 0.82341f
C1278 vdd.n10 vss 0.132591f
C1279 vdd.n11 vss 0.171897f
C1280 vdd.t38 vss 0.82341f
C1281 vdd.n12 vss 0.122426f
C1282 vdd.t99 vss 0.574296f
C1283 vdd.n13 vss 0.131622f
C1284 vdd.t32 vss 0.82341f
C1285 vdd.n14 vss 0.116484f
C1286 vdd.n15 vss 0.170928f
C1287 vdd.t1 vss 0.82341f
C1288 vdd.n16 vss 0.122426f
C1289 vdd.t7 vss 0.82341f
C1290 vdd.n17 vss 0.131622f
C1291 vdd.t36 vss 0.82341f
C1292 vdd.n18 vss 0.132591f
C1293 vdd.n19 vss 0.171897f
C1294 vdd.t83 vss 0.82341f
C1295 vdd.n20 vss 0.122426f
C1296 vdd.t30 vss 0.82341f
C1297 vdd.n21 vss 0.131622f
C1298 vdd.t73 vss 0.843071f
C1299 vdd.n22 vss 1.63707f
C1300 vdd.n23 vss 1.68383f
C1301 vdd.n24 vss 1.68383f
C1302 vdd.n25 vss 1.68383f
C1303 vdd.n26 vss 1.68383f
C1304 vdd.n27 vss 1.68383f
C1305 vdd.t0 vss 1.891f
C1306 vdd.t4 vss 1.891f
C1307 vdd.t6 vss 2.16803f
C1308 vdd.t8 vss 2.16803f
C1309 vdd.t27 vss 1.891f
C1310 vdd.t29 vss 2.16803f
C1311 vdd.t31 vss 1.891f
C1312 vdd.t33 vss 1.891f
C1313 vdd.t35 vss 1.891f
C1314 vdd.t37 vss 1.891f
C1315 vdd.t39 vss 1.891f
C1316 vdd.t41 vss 2.16803f
C1317 vdd.t51 vss 2.16803f
C1318 vdd.t66 vss 1.891f
C1319 vdd.t72 vss 2.20064f
C1320 vdd.t82 vss 1.891f
C1321 vdd.t84 vss 2.1943f
C1322 vdd.t98 vss 2.16803f
C1323 vdd.n28 vss 0.341619f
C1324 vdd.n29 vss 0.64647f
C1325 vdd.n30 vss 0.112134f
C1326 vdd.t97 vss 0.418671f
C1327 vdd.n31 vss 0.044767f
C1328 vdd.t71 vss 0.496125f
C1329 vdd.n32 vss 0.053971f
C1330 vdd.t69 vss 0.496125f
C1331 vdd.n33 vss 0.0549324f
C1332 vdd.n34 vss 0.0712206f
C1333 vdd.t93 vss 0.418671f
C1334 vdd.n35 vss 0.044767f
C1335 vdd.t45 vss 0.125396f
C1336 vdd.n36 vss 0.0568788f
C1337 vdd.t77 vss 0.128139f
C1338 vdd.n37 vss 0.0443178f
C1339 vdd.t14 vss 0.0798021f
C1340 vdd.n38 vss 0.0550112f
C1341 vdd.t16 vss 0.0770046f
C1342 vdd.n39 vss 0.0595186f
C1343 vdd.n40 vss 0.0650662f
C1344 vdd.t18 vss 0.0988089f
C1345 vdd.n41 vss 0.0476827f
C1346 vdd.t65 vss 1.07255f
C1347 vdd.n42 vss 0.0564454f
C1348 vdd.n43 vss 0.116783f
C1349 vdd.t3 vss 0.205293f
C1350 vdd.n44 vss 0.0569812f
C1351 vdd.t63 vss 0.221818f
C1352 vdd.n45 vss 0.0393297f
C1353 vdd.t61 vss 0.221818f
C1354 vdd.n46 vss 0.040299f
C1355 vdd.n47 vss 0.0658542f
C1356 vdd.t57 vss 0.205293f
C1357 vdd.n48 vss 0.0355f
C1358 vdd.t20 vss 0.0965631f
C1359 vdd.n49 vss 0.475952f
C1360 vdd.n50 vss 0.380319f
C1361 vdd.n51 vss 0.41128f
C1362 vdd.n52 vss 0.442241f
C1363 vdd.n53 vss 0.335733f
C1364 vdd.n54 vss 0.643491f
C1365 vdd.n55 vss 0.349358f
C1366 vdd.t2 vss 0.37154f
C1367 vdd.t10 vss 0.433462f
C1368 vdd.t13 vss 0.344291f
C1369 vdd.t15 vss 0.326332f
C1370 vdd.t17 vss 0.627282f
C1371 vdd.t19 vss 0.356789f
C1372 vdd.t44 vss 0.397545f
C1373 vdd.t46 vss 0.37154f
C1374 vdd.t47 vss 0.4186f
C1375 vdd.t48 vss 0.393211f
C1376 vdd.t49 vss 0.393211f
C1377 vdd.t50 vss 0.393211f
C1378 vdd.t53 vss 0.433462f
C1379 vdd.t56 vss 0.339957f
C1380 vdd.t60 vss 0.346773f
C1381 vdd.t62 vss 0.37154f
C1382 vdd.t64 vss 0.928232f
C1383 vdd.t68 vss 0.486094f
C1384 vdd.t70 vss 0.557306f
C1385 vdd.t76 vss 0.344291f
C1386 vdd.t86 vss 0.433462f
C1387 vdd.t89 vss 0.346773f
C1388 vdd.t92 vss 0.43284f
C1389 vdd.t94 vss 0.433462f
C1390 vdd.t96 vss 0.486094f
C1391 vdd.n56 vss 0.178438f
C1392 vdd.n57 vss 0.0974851f
C1393 vdd.n58 vss 2.74037f
C1394 vdd.n59 vss 0.0248382f
C1395 vdd.n60 vss 0.0248382f
C1396 vdd.n61 vss 0.022482f
C1397 vdd.n62 vss 0.0355788f
C1398 vdd.n63 vss 0.0238768f
C1399 vdd.t21 vss 1.56276f
C1400 vdd.t24 vss 5.10469f
C1401 vdd.t11 vss 0.559726f
C1402 vdd.t43 vss 3.4479f
C1403 vdd.t55 vss 0.170975f
C1404 vdd.n64 vss 0.0645067f
C1405 vdd.t54 vss 0.171204f
C1406 vdd.n65 vss 0.0579032f
C1407 vdd.t91 vss 0.170975f
C1408 vdd.n66 vss 0.0575249f
C1409 vdd.t90 vss 0.171204f
C1410 vdd.n67 vss 0.0456102f
C1411 vdd.t103 vss 0.170975f
C1412 vdd.n68 vss 0.0579032f
C1413 vdd.t102 vss 0.171204f
C1414 vdd.n69 vss 0.0579032f
C1415 vdd.t75 vss 0.170975f
C1416 vdd.n70 vss 0.0579032f
C1417 vdd.t74 vss 0.171204f
C1418 vdd.n71 vss 0.0579032f
C1419 vdd.t26 vss 0.170975f
C1420 vdd.n72 vss 0.0453974f
C1421 vdd.t25 vss 0.171204f
C1422 vdd.n73 vss 0.0577456f
C1423 vdd.t81 vss 0.0727651f
C1424 vdd.n74 vss 0.0818903f
C1425 vdd.t80 vss 0.0728754f
C1426 vdd.n75 vss 0.0818903f
C1427 vdd.t12 vss 0.0722135f
C1428 vdd.n76 vss 0.08033f
C1429 vdd.t23 vss 0.0723159f
C1430 vdd.n77 vss 0.0731355f
C1431 vdd.t59 vss 0.0977057f
C1432 vdd.n78 vss 0.0776193f
C1433 vdd.t58 vss 0.0977924f
C1434 vdd.n79 vss 0.0776193f
C1435 vdd.t79 vss 0.0977057f
C1436 vdd.n80 vss 0.0776193f
C1437 vdd.t78 vss 0.0977924f
C1438 vdd.n81 vss 0.0776193f
C1439 vdd.t88 vss 0.0781236f
C1440 vdd.n82 vss 0.0752867f
C1441 vdd.t95 vss 0.087233f
C1442 vdd.n83 vss 0.0972959f
C1443 vdd.t22 vss 0.040693f
C1444 vdd.n84 vss 0.0994945f
C1445 vdd.t104 vss 0.0777769f
C1446 vdd.n85 vss 0.0777532f
C1447 vdd.t87 vss 0.0781236f
C1448 vdd.n86 vss 0.0892976f
C1449 vdd.t101 vss 0.0886987f
C1450 vdd.n87 vss 0.163725f
C1451 vdd.t100 vss 0.0938129f
C1452 vdd.n88 vss 0.0099526f
C1453 vdd.n89 vss 0.723679f
C1454 vctrl.n0 vss 0.22521f
C1455 vctrl.n1 vss 0.125645f
C1456 vctrl.n2 vss 0.411502f
C1457 vctrl.t2 vss 0.426125f
C1458 vctrl.n3 vss 0.0420328f
C1459 vctrl.n4 vss 0.257079f
C1460 vctrl.t1 vss 0.348566f
C1461 vctrl.n5 vss 2.75914f
C1462 vctrl.t0 vss 0.12272f
C1463 vctrl.n6 vss 0.453837f
C1464 vctrl.n7 vss 0.263737f
C1465 vctrl.n8 vss 0.447179f
C1466 vctrl.n9 vss 0.365161f
C1467 vctrl.n10 vss 0.310893f
C1468 pfd_dn.n0 vss 1.42315f
C1469 pfd_dn.n1 vss 1.473f
C1470 cp_trim0.n0 vss 1.46411f
C1471 cp_trim1.n0 vss 1.65922f
C1472 pfd_up.n0 vss 0.984789f
C1473 pfd_up.n1 vss 2.04441f
C1474 pll_en.n0 vss 0.319467f
C1475 pll_en.n1 vss 0.0664358f
C1476 pll_en.n2 vss 0.0689913f
C1477 pll_en.n3 vss 0.0796421f
C1478 pll_en.n4 vss 0.297448f
C1479 pll_en.n5 vss 0.458761f
C1480 pll_en.n6 vss 0.490993f
C1481 pll_en.n7 vss 0.722274f
C1482 pll_en.n8 vss 2.2734f
C1483 pll_en.n9 vss 0.643819f
C1484 pll_en.n10 vss 0.684579f
C1485 bias_ref.t1 vss 0.035598f
C1486 bias_ref.t0 vss 0.0182822f
C1487 bias_ref.n0 vss 0.536173f
C1488 vco_div2.t2 vss 0.0307117f
C1489 vco_div2.t1 vss 0.0307451f
C1490 vco_div2.n0 vss 0.0649055f
C1491 vco_div2.t3 vss 0.0172844f
C1492 vco_div2.t0 vss 0.0173252f
C1493 vco_div2.n1 vss 0.0236806f
C1494 vco_div2.n2 vss 0.103714f
.ends
