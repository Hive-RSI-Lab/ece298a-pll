* NGSPICE file created from pll_analog.ext - technology: gf180mcuD

.subckt pll_analog vco_div2 pfd_up pfd_dn pll_en cp_trim0 cp_trim1 vctrl bias_ref
+ vdd vss
X0 vctrl.t2 a_400_12030 vss.t170 ppolyf_u r_width=2u r_length=37.5u
X1 sf.t2 dqn.t6 vdd.t108 vdd.t6 pfet_03v3 ad=0.65p pd=3.3u as=0.65p ps=3.3u w=1u l=0.28u
X2 a_4150_2036.t4 vbp_vco.t14 vdd.t98 vdd.t34 pfet_03v3 ad=1.3p pd=5.52u as=3.25p ps=11.3u w=5u l=0.5u
X3 vfilt vss.t134 cap_nmos_03v3_b c_width=35u c_length=12u
X4 vcp_n.t2 cp_trim1.t1 t2.t1 vss.t65 nfet_03v3 ad=1.22p pd=5.22u as=1.22p ps=5.22u w=2u l=0.28u
X5 vbp.t1 pll_en.t16 vdd.t16 vdd.t15 pfet_03v3 ad=0.65p pd=3.3u as=0.65p ps=3.3u w=1u l=0.28u
X6 vco_div2.t1 dqb.t3 vss.t92 vss.t91 nfet_03v3 ad=0.39p pd=2.02u as=0.915p ps=4.22u w=1.5u l=0.28u
X7 vdd.t62 clkb.t7 vdd.t61 vdd.t6 pfet_03v3 ad=0.65p pd=3.3u as=0 ps=0 w=1u l=0.45u
X8 vfilt vss.t126 cap_nmos_03v3_b c_width=35u c_length=12u
X9 vs.t2 a_4200_12030 vss.t157 ppolyf_u r_width=1u r_length=21.5u
X10 a_13200_19482 a_12600_12030 vss.t67 ppolyf_u r_width=1u r_length=36.6u
X11 vdump.t1 vbh.t6 vdd.t56 vdd.t55 pfet_03v3 ad=2.6p pd=9.3u as=2.6p ps=9.3u w=4u l=2u
X12 vss.t28 vbn_vco.t7 a_6394_0.t0 vss.t27 nfet_03v3 ad=1.22p pd=5.22u as=0.52p ps=2.52u w=2u l=0.5u
X13 m1.t2 ck.t3 mf.t3 vss.t109 nfet_03v3 ad=0.305p pd=2.22u as=0.305p ps=2.22u w=0.5u l=0.28u
X14 vss.t201 sf.t4 vss.t200 vss.t199 nfet_03v3 ad=2.44p pd=9.22u as=0 ps=0 w=4u l=1u
X15 dqb.t1 dqn.t5 vdd.t107 vdd.t22 pfet_03v3 ad=1.3p pd=5.3u as=1.3p ps=5.3u w=2u l=0.28u
X16 vbp_vco.t1 pll_en.t12 vi.t2 vss.t18 nfet_03v3 ad=3.05p pd=11.22u as=3.05p ps=11.22u w=5u l=0.28u
X17 vbt.t9 vbp.t17 vdd.t102 vdd.t101 pfet_03v3 ad=2.6p pd=9.3u as=2.6p ps=9.3u w=4u l=2u
X18 vbh.t3 vbh.t2 vdd.t64 vdd.t63 pfet_03v3 ad=2.6p pd=9.3u as=2.6p ps=9.3u w=4u l=2u
X19 vbl.t7 vbl.t6 vss.t175 vss.t174 nfet_03v3 ad=1.22p pd=5.22u as=1.22p ps=5.22u w=2u l=2u
X20 vfilt vss.t140 cap_nmos_03v3_b c_width=35u c_length=12u
X21 t2.t3 vbp.t9 vdd.t88 vdd.t87 pfet_03v3 ad=2.6p pd=9.3u as=2.6p ps=9.3u w=4u l=2u
X22 bias_ref.t0 a_10200_12030 vss.t97 ppolyf_u r_width=1u r_length=36.6u
X23 up_s.t3 vcp_p.t7 vdd.t123 vdd.t122 pfet_03v3 ad=32.5p pd=0.1013m as=32.5p ps=0.1013m w=50u l=4u
X24 a_1200_19662 a_400_12030 vss.t203 ppolyf_u r_width=2u r_length=37.5u
X25 bias_ref.t1 a_8400_12030 vss.t153 ppolyf_u r_width=1u r_length=30u
X26 vst.t0 vref.t3 vss.t52 vss.t51 nfet_03v3 ad=3.05p pd=11.22u as=3.05p ps=11.22u w=5u l=1u
X27 dqb.t0 dqn.t3 vss.t111 vss.t110 nfet_03v3 ad=0.61p pd=3.22u as=0.61p ps=3.22u w=1u l=0.28u
X28 a_5274_0.t2 r3.t4 r4.t2 vss.t114 nfet_03v3 ad=0.915p pd=4.22u as=0.39p ps=2.02u w=1.5u l=0.28u
X29 a_7950_0.t2 r4.t4 r5.t2 vss.t116 nfet_03v3 ad=0.915p pd=4.22u as=0.39p ps=2.02u w=1.5u l=0.28u
X30 vcp_p.t5 vcp_n.t15 vss.t104 vss.t103 nfet_03v3 ad=12.2p pd=41.22u as=12.2p ps=41.22u w=20u l=4u
X31 a_3034_0.t2 vbn_vco.t14 vss.t56 vss.t55 nfet_03v3 ad=0.52p pd=2.52u as=1.22p ps=5.22u w=2u l=0.5u
X32 en_b.t1 pll_en.t15 vdd.t12 vdd.t11 pfet_03v3 ad=1.3p pd=5.3u as=1.3p ps=5.3u w=2u l=0.28u
X33 vnt.t4 vref.t6 vss.t60 vss.t59 nfet_03v3 ad=1.22p pd=5.22u as=1.22p ps=5.22u w=2u l=2u
X34 vdd.t24 pll_en.t4 nb.t1 vdd.t22 pfet_03v3 ad=1.3p pd=5.3u as=0.52p ps=2.52u w=2u l=0.28u
X35 vcp_n.t7 vbp.t16 vdd.t112 vdd.t111 pfet_03v3 ad=2.6p pd=9.3u as=2.6p ps=9.3u w=4u l=2u
X36 vfilt vss.t132 cap_nmos_03v3_b c_width=35u c_length=12u
X37 vdump.t9 vdump.t8 vnt.t5 vss.t150 nfet_03v3 ad=3.05p pd=11.22u as=3.05p ps=11.22u w=5u l=1u
X38 vst.t1 en_b.t8 vss.t75 vss.t74 nfet_03v3 ad=0.61p pd=3.22u as=0.61p ps=3.22u w=1u l=0.28u
X39 a_14400_19482 a_15000_12030 vss.t14 ppolyf_u r_width=1u r_length=36.6u
X40 vbh.t5 vbh.t4 vdd.t74 vdd.t73 pfet_03v3 ad=2.6p pd=9.3u as=2.6p ps=9.3u w=4u l=2u
X41 a_7950_0.t4 en_b.t2 vss.t173 vss.t172 nfet_03v3 ad=0.305p pd=2.22u as=0.305p ps=2.22u w=0.5u l=0.28u
X42 vref.t1 a_6000_12030 vss.t84 ppolyf_u r_width=1u r_length=30u
X43 dn_b.t1 pfd_dn.t0 vdd.t42 vdd.t41 pfet_03v3 ad=1.3p pd=5.3u as=1.3p ps=5.3u w=2u l=0.28u
X44 vcl.t3 vref.t12 vss.t162 vss.t161 nfet_03v3 ad=7.625p pd=26.22u as=7.625p ps=26.22u w=12.5u l=1u
X45 a_5270_2036.t0 pll_en.t9 vdd.t7 vdd.t6 pfet_03v3 ad=0.65p pd=3.3u as=0.65p ps=3.3u w=1u l=0.28u
X46 m2.t3 m1.t6 vdd.t109 vdd.t22 pfet_03v3 ad=1.3p pd=5.3u as=1.3p ps=5.3u w=2u l=0.28u
X47 vbt.t8 vbp.t15 vdd.t66 vdd.t65 pfet_03v3 ad=2.6p pd=9.3u as=2.6p ps=9.3u w=4u l=2u
X48 t2.t2 vbp.t13 vdd.t48 vdd.t47 pfet_03v3 ad=2.6p pd=9.3u as=2.6p ps=9.3u w=4u l=2u
X49 vcp_n.t9 vcp_n.t8 vss.t155 vss.t154 nfet_03v3 ad=12.2p pd=41.22u as=12.2p ps=41.22u w=20u l=4u
X50 a_4154_0.t4 en_b.t4 vss.t147 vss.t146 nfet_03v3 ad=0.305p pd=2.22u as=0.305p ps=2.22u w=0.5u l=0.28u
X51 vcp_n.t3 en_b.t10 vss.t195 vss.t194 nfet_03v3 ad=0.61p pd=3.22u as=0.61p ps=3.22u w=1u l=0.28u
X52 a_12000_19482 a_11400_12030 vss.t98 ppolyf_u r_width=1u r_length=36.6u
X53 a_9070_n100 r5.t4 nb.t3 vss.t76 nfet_03v3 ad=1.22p pd=5.22u as=0.52p ps=2.52u w=2u l=0.28u
X54 vdump.t2 pll_en.t18 vdd.t5 vdd.t4 pfet_03v3 ad=0.65p pd=3.3u as=0.65p ps=3.3u w=1u l=0.28u
X55 s1.t1 ck.t4 sf.t1 vdd.t6 pfet_03v3 ad=0.65p pd=3.3u as=0.65p ps=3.3u w=1u l=0.28u
X56 vbl.t0 vctrl.t10 vbt.t0 vdd.t0 pfet_03v3 ad=3.25p pd=11.3u as=3.25p ps=11.3u w=5u l=1u
X57 a_4154_0.t2 r1.t5 r2.t3 vss.t144 nfet_03v3 ad=0.915p pd=4.22u as=0.39p ps=2.02u w=1.5u l=0.28u
X58 a_1200_19662 a_2000_12030 vss.t189 ppolyf_u r_width=2u r_length=37.5u
X59 vbl.t1 vctrl.t7 vbt.t3 vdd.t3 pfet_03v3 ad=3.25p pd=11.3u as=3.25p ps=11.3u w=5u l=1u
X60 t1a.t0 vbp.t12 vdd.t33 vdd.t32 pfet_03v3 ad=2.6p pd=9.3u as=2.6p ps=9.3u w=4u l=2u
X61 vcp_p.t0 pll_en.t17 vdd.t10 vdd.t9 pfet_03v3 ad=0.65p pd=3.3u as=0.65p ps=3.3u w=1u l=0.28u
X62 vdump.t5 vbl.t8 vss.t106 vss.t105 nfet_03v3 ad=1.22p pd=5.22u as=1.22p ps=5.22u w=2u l=2u
X63 vbn_vco.t4 en_b.t5 vss.t185 vss.t184 nfet_03v3 ad=0.61p pd=3.22u as=0.61p ps=3.22u w=1u l=0.28u
X64 vcp_n.t5 vbp.t8 vdd.t72 vdd.t71 pfet_03v3 ad=2.6p pd=9.3u as=2.6p ps=9.3u w=4u l=2u
X65 vdump.t11 vdump.t10 vnt.t6 vss.t156 nfet_03v3 ad=3.05p pd=11.22u as=3.05p ps=11.22u w=5u l=1u
X66 vcp_n.t4 vbp.t6 vdd.t68 vdd.t67 pfet_03v3 ad=2.6p pd=9.3u as=2.6p ps=9.3u w=4u l=2u
X67 vbp_vco.t2 pll_en.t14 vdd.t14 vdd.t13 pfet_03v3 ad=0.65p pd=3.3u as=0.65p ps=3.3u w=1u l=0.28u
X68 up_b.t1 pfd_up.t1 vdd.t27 vdd.t26 pfet_03v3 ad=1.3p pd=5.3u as=1.3p ps=5.3u w=2u l=0.28u
X69 vbh.t0 vctrl.t6 vnt.t1 vss.t10 nfet_03v3 ad=3.05p pd=11.22u as=3.05p ps=11.22u w=5u l=1u
X70 vss.t181 nb.t6 vco_out.t6 vss.t180 nfet_03v3 ad=1.83p pd=7.22u as=0.78p ps=3.52u w=3u l=0.28u
X71 vdump.t17 vdump.t16 vbt.t6 vdd.t110 pfet_03v3 ad=3.25p pd=11.3u as=3.25p ps=11.3u w=5u l=1u
X72 vdd.t115 vbp_vco.t11 a_5270_2036.t4 vdd.t34 pfet_03v3 ad=3.25p pd=11.3u as=1.3p ps=5.52u w=5u l=0.5u
X73 vi.t0 vctrl.t3 vs.t1 vss.t13 nfet_03v3 ad=3.05p pd=11.22u as=3.05p ps=11.22u w=5u l=1u
X74 a_19434_n100 pll_en.t0 vss.t20 vss.t19 nfet_03v3 ad=1.22p pd=5.22u as=1.22p ps=5.22u w=2u l=0.28u
X75 m1.t3 ck.t5 s1.t4 vdd.t22 pfet_03v3 ad=1.3p pd=5.3u as=1.3p ps=5.3u w=2u l=0.28u
X76 vbp.t3 vbp.t2 vdd.t100 vdd.t99 pfet_03v3 ad=2.6p pd=9.3u as=2.6p ps=9.3u w=4u l=2u
X77 vbt.t10 vbp.t7 vdd.t117 vdd.t116 pfet_03v3 ad=2.6p pd=9.3u as=2.6p ps=9.3u w=4u l=2u
X78 vbn_vco.t3 vbp_vco.t18 vdd.t78 vdd.t77 pfet_03v3 ad=3.25p pd=11.3u as=3.25p ps=11.3u w=5u l=0.5u
X79 a_9070_n100 pll_en.t2 vss.t22 vss.t21 nfet_03v3 ad=0.52p pd=2.52u as=1.22p ps=5.22u w=2u l=0.28u
X80 vdd.t82 dqb.t4 vco_div2.t2 vdd.t29 pfet_03v3 ad=1.95p pd=7.3u as=0.78p ps=3.52u w=3u l=0.28u
X81 clkb.t1 vco_out.t9 vdd.t52 vdd.t6 pfet_03v3 ad=0.65p pd=3.3u as=0.65p ps=3.3u w=1u l=0.28u
X82 vcl.t0 vref.t14 vss.t102 vss.t101 nfet_03v3 ad=7.625p pd=26.22u as=7.625p ps=26.22u w=12.5u l=1u
X83 vnt.t2 vref.t8 vss.t44 vss.t43 nfet_03v3 ad=1.22p pd=5.22u as=1.22p ps=5.22u w=2u l=2u
X84 vfilt vss.t128 cap_nmos_03v3_b c_width=35u c_length=12u
X85 vdd.t113 vbp_vco.t9 a_6390_2036.t3 vdd.t34 pfet_03v3 ad=3.25p pd=11.3u as=1.3p ps=5.52u w=5u l=0.5u
X86 vcp_n.t1 cp_trim1.t0 t1c.t1 vss.t66 nfet_03v3 ad=1.22p pd=5.22u as=1.22p ps=5.22u w=2u l=0.28u
X87 a_3034_0.t3 r2.t4 r3.t3 vss.t79 nfet_03v3 ad=0.915p pd=4.22u as=0.39p ps=2.02u w=1.5u l=0.28u
X88 va.t1 vbp.t11 vdd.t58 vdd.t57 pfet_03v3 ad=2.6p pd=9.3u as=2.6p ps=9.3u w=4u l=2u
X89 t1a.t1 cp_trim0.t3 vdd.t38 vdd.t37 pfet_03v3 ad=0.65p pd=3.3u as=0.65p ps=3.3u w=1u l=0.28u
X90 dn_s.t2 vcp_n.t13 vss.t165 vss.t164 nfet_03v3 ad=12.2p pd=41.22u as=12.2p ps=41.22u w=20u l=4u
X91 vbp.t0 vst.t4 vss.t191 vss.t190 nfet_03v3 ad=0.305p pd=2.22u as=0.305p ps=2.22u w=0.5u l=4u
X92 dn_s.t0 vcp_n.t14 vss.t1 vss.t0 nfet_03v3 ad=12.2p pd=41.22u as=12.2p ps=41.22u w=20u l=4u
X93 vbp.t4 va.t3 vref.t0 vss.t61 nfet_03v3 ad=2.44p pd=9.22u as=2.44p ps=9.22u w=4u l=1u
X94 nb.t0 pll_en.t5 vdd.t23 vdd.t22 pfet_03v3 ad=0.52p pd=2.52u as=1.3p ps=5.3u w=2u l=0.28u
X95 a_7800_18162 a_7200_12030 vss.t57 ppolyf_u r_width=1u r_length=30u
X96 vref.t2 en_b.t6 vss.t100 vss.t99 nfet_03v3 ad=0.61p pd=3.22u as=0.61p ps=3.22u w=1u l=0.28u
X97 dn_b.t0 pfd_dn.t1 vss.t64 vss.t63 nfet_03v3 ad=0.61p pd=3.22u as=0.61p ps=3.22u w=1u l=0.28u
X98 vss.t34 vbn_vco.t5 a_7950_0.t0 vss.t33 nfet_03v3 ad=1.22p pd=5.22u as=0.52p ps=2.52u w=2u l=0.5u
X99 vco_out.t5 nb.t9 vdd.t106 vdd.t29 pfet_03v3 ad=0.78p pd=3.52u as=1.95p ps=7.3u w=3u l=0.28u
X100 vdd.t35 vbp_vco.t15 a_3030_2036.t1 vdd.t34 pfet_03v3 ad=3.25p pd=11.3u as=1.3p ps=5.52u w=5u l=0.5u
X101 vfilt vss.t124 cap_nmos_03v3_b c_width=35u c_length=12u
X102 s1.t3 ck.t2 m2.t2 vss.t143 nfet_03v3 ad=0.61p pd=3.22u as=0.61p ps=3.22u w=1u l=0.28u
X103 vbl.t2 vctrl.t9 vbt.t1 vdd.t1 pfet_03v3 ad=3.25p pd=11.3u as=3.25p ps=11.3u w=5u l=1u
X104 vfilt vss.t138 cap_nmos_03v3_b c_width=35u c_length=12u
X105 t1b.t2 vbp.t10 vdd.t95 vdd.t94 pfet_03v3 ad=2.6p pd=9.3u as=2.6p ps=9.3u w=4u l=2u
X106 vcl.t4 a_4200_12030 vss.t176 ppolyf_u r_width=1u r_length=21.5u
X107 a_13200_19482 a_13800_12030 vss.t80 ppolyf_u r_width=1u r_length=36.6u
X108 vdd.t105 nb.t8 vco_out.t4 vdd.t29 pfet_03v3 ad=1.95p pd=7.3u as=0.78p ps=3.52u w=3u l=0.28u
X109 vss.t54 vbn_vco.t13 a_3034_0.t1 vss.t53 nfet_03v3 ad=1.22p pd=5.22u as=0.52p ps=2.52u w=2u l=0.5u
X110 clkb.t0 vco_out.t8 vss.t94 vss.t93 nfet_03v3 ad=0.305p pd=2.22u as=0.305p ps=2.22u w=0.5u l=0.28u
X111 a_7946_2036.t2 r4.t6 r5.t0 vdd.t29 pfet_03v3 ad=1.95p pd=7.3u as=0.78p ps=3.52u w=3u l=0.28u
X112 up_s.t2 vcp_p.t8 vdd.t46 vdd.t45 pfet_03v3 ad=32.5p pd=0.1013m as=32.5p ps=0.1013m w=50u l=4u
X113 vbh.t1 vctrl.t5 vnt.t0 vss.t11 nfet_03v3 ad=3.05p pd=11.22u as=3.05p ps=11.22u w=5u l=1u
X114 vdd.t97 vbp_vco.t13 a_4150_2036.t3 vdd.t34 pfet_03v3 ad=3.25p pd=11.3u as=1.3p ps=5.52u w=5u l=0.5u
X115 vdump.t13 vdump.t12 vbt.t4 vdd.t79 pfet_03v3 ad=3.25p pd=11.3u as=3.25p ps=11.3u w=5u l=1u
X116 a_4154_0.t1 vbn_vco.t12 vss.t7 vss.t6 nfet_03v3 ad=0.52p pd=2.52u as=1.22p ps=5.22u w=2u l=0.5u
X117 vss.t169 dqb.t2 vco_div2.t3 vss.t168 nfet_03v3 ad=0.915p pd=4.22u as=0.39p ps=2.02u w=1.5u l=0.28u
X118 vfilt a_2000_12030 vss.t202 ppolyf_u r_width=2u r_length=37.5u
X119 vfilt vss.t130 cap_nmos_03v3_b c_width=35u c_length=12u
X120 vdump.t4 vbl.t9 vss.t108 vss.t107 nfet_03v3 ad=1.22p pd=5.22u as=1.22p ps=5.22u w=2u l=2u
X121 a_3030_2036.t4 r2.t6 r3.t1 vdd.t29 pfet_03v3 ad=1.95p pd=7.3u as=0.78p ps=3.52u w=3u l=0.28u
X122 a_10800_19482 a_10200_12030 vss.t177 ppolyf_u r_width=1u r_length=36.6u
X123 vbl.t5 vbl.t4 vss.t193 vss.t192 nfet_03v3 ad=1.22p pd=5.22u as=1.22p ps=5.22u w=2u l=2u
X124 vbp_vco.t0 pll_en.t13 vi.t3 vss.t17 nfet_03v3 ad=3.05p pd=11.22u as=3.05p ps=11.22u w=5u l=0.28u
X125 vcp_n.t0 cp_trim0.t1 t1a.t2 vss.t45 nfet_03v3 ad=1.22p pd=5.22u as=1.22p ps=5.22u w=2u l=0.28u
X126 ck.t0 vss.t211 vco_out.t0 vdd.t6 pfet_03v3 ad=0.65p pd=3.3u as=0.65p ps=3.3u w=1u l=0.28u
X127 vdd.t50 r5.t8 nb.t4 vdd.t22 pfet_03v3 ad=1.3p pd=5.3u as=0.52p ps=2.52u w=2u l=0.28u
X128 vfilt vss.t122 cap_nmos_03v3_b c_width=35u c_length=12u
X129 t1b.t1 cp_trim0.t2 vdd.t40 vdd.t39 pfet_03v3 ad=0.65p pd=3.3u as=0.65p ps=3.3u w=1u l=0.28u
X130 vctrl.t0 pfd_dn.t2 dn_s.t1 vss.t62 nfet_03v3 ad=1.22p pd=5.22u as=1.22p ps=5.22u w=2u l=0.5u
X131 vcl.t2 vref.t11 vss.t160 vss.t159 nfet_03v3 ad=7.625p pd=26.22u as=7.625p ps=26.22u w=12.5u l=1u
X132 ck.t1 vdd.t124 vco_out.t3 vss.t142 nfet_03v3 ad=0.305p pd=2.22u as=0.305p ps=2.22u w=0.5u l=0.28u
X133 vdd.t59 nb.t10 vco_out.t1 vdd.t29 pfet_03v3 ad=1.95p pd=7.3u as=0.78p ps=3.52u w=3u l=0.28u
X134 dqn.t0 pll_en.t3 vdd.t25 vdd.t6 pfet_03v3 ad=0.65p pd=3.3u as=0.65p ps=3.3u w=1u l=0.28u
X135 vco_out.t7 nb.t7 vss.t183 vss.t182 nfet_03v3 ad=0.78p pd=3.52u as=1.83p ps=7.22u w=3u l=0.28u
X136 r4.t3 r3.t5 a_5274_0.t3 vss.t115 nfet_03v3 ad=0.39p pd=2.02u as=0.915p ps=4.22u w=1.5u l=0.28u
X137 vfilt vss.t136 cap_nmos_03v3_b c_width=35u c_length=12u
X138 r5.t1 r4.t5 a_7950_0.t3 vss.t117 nfet_03v3 ad=0.39p pd=2.02u as=0.915p ps=4.22u w=1.5u l=0.28u
X139 a_4150_2036.t2 r1.t7 r2.t0 vdd.t29 pfet_03v3 ad=1.95p pd=7.3u as=0.78p ps=3.52u w=3u l=0.28u
X140 vss.t69 a_15000_12030 vss.t68 ppolyf_u r_width=1u r_length=36.6u
X141 a_6600_18162 a_6000_12030 vss.t85 ppolyf_u r_width=1u r_length=30u
X142 vss.t188 m1.t5 vss.t187 vss.t186 nfet_03v3 ad=2.44p pd=9.22u as=0 ps=0 w=4u l=1u
X143 vss.t32 vbn_vco.t9 a_5274_0.t1 vss.t31 nfet_03v3 ad=1.22p pd=5.22u as=0.52p ps=2.52u w=2u l=0.5u
X144 vco_div2.t0 dqb.t5 vdd.t31 vdd.t29 pfet_03v3 ad=0.78p pd=3.52u as=1.95p ps=7.3u w=3u l=0.28u
X145 vcl.t1 vref.t13 vss.t113 vss.t112 nfet_03v3 ad=7.625p pd=26.22u as=7.625p ps=26.22u w=12.5u l=1u
X146 vdd.t69 vbp_vco.t7 a_7946_2036.t3 vdd.t34 pfet_03v3 ad=3.25p pd=11.3u as=1.3p ps=5.52u w=5u l=0.5u
X147 a_6394_0.t1 vbn_vco.t8 vss.t30 vss.t29 nfet_03v3 ad=0.52p pd=2.52u as=1.22p ps=5.22u w=2u l=0.5u
X148 dqn.t1 s1.t7 a_19434_n100.t0 vss.t82 nfet_03v3 ad=1.22p pd=5.22u as=1.22p ps=5.22u w=2u l=0.28u
X149 a_5270_2036.t2 r3.t6 r4.t0 vdd.t29 pfet_03v3 ad=1.95p pd=7.3u as=0.78p ps=3.52u w=3u l=0.28u
X150 vbl.t3 vctrl.t8 vbt.t2 vdd.t2 pfet_03v3 ad=3.25p pd=11.3u as=3.25p ps=11.3u w=5u l=1u
X151 s1.t0 clkb.t2 sf.t0 vss.t81 nfet_03v3 ad=0.305p pd=2.22u as=0.305p ps=2.22u w=0.5u l=0.28u
X152 a_12000_19482 a_12600_12030 vss.t163 ppolyf_u r_width=1u r_length=36.6u
X153 vcp_n.t11 vcp_n.t10 vss.t149 vss.t148 nfet_03v3 ad=12.2p pd=41.22u as=12.2p ps=41.22u w=20u l=4u
X154 vdump.t3 pfd_up.t0 up_s.t0 vdd.t28 pfet_03v3 ad=2.6p pd=9.3u as=2.6p ps=9.3u w=4u l=0.5u
X155 mf.t1 m2.t4 vss.t96 vss.t95 nfet_03v3 ad=0.305p pd=2.22u as=0.305p ps=2.22u w=0.5u l=0.28u
X156 a_3030_2036.t0 pll_en.t11 vdd.t8 vdd.t6 pfet_03v3 ad=0.65p pd=3.3u as=0.65p ps=3.3u w=1u l=0.28u
X157 r4.t1 r3.t7 a_5270_2036.t1 vdd.t29 pfet_03v3 ad=0.78p pd=3.52u as=1.95p ps=7.3u w=3u l=0.28u
X158 vss.t42 s1.t6 vss.t41 vss.t40 nfet_03v3 ad=2.44p pd=9.22u as=0 ps=0 w=4u l=1u
X159 vbp_vco.t4 vbp_vco.t3 vdd.t81 vdd.t80 pfet_03v3 ad=3.25p pd=11.3u as=3.25p ps=11.3u w=5u l=0.5u
X160 a_6390_2036.t2 r5.t10 r1.t2 vdd.t29 pfet_03v3 ad=1.95p pd=7.3u as=0.78p ps=3.52u w=3u l=0.28u
X161 r2.t2 r1.t6 a_4154_0.t3 vss.t145 nfet_03v3 ad=0.39p pd=2.02u as=0.915p ps=4.22u w=1.5u l=0.28u
X162 a_7800_18162 a_8400_12030 vss.t58 ppolyf_u r_width=1u r_length=30u
X163 vbp_vco.t6 vbp_vco.t5 vdd.t104 vdd.t103 pfet_03v3 ad=3.25p pd=11.3u as=3.25p ps=11.3u w=5u l=0.5u
X164 vss.t24 pll_en.t1 a_9070_n100 vss.t23 nfet_03v3 ad=1.22p pd=5.22u as=0.52p ps=2.52u w=2u l=0.28u
X165 vnt.t3 vref.t5 vss.t48 vss.t47 nfet_03v3 ad=1.22p pd=5.22u as=1.22p ps=5.22u w=2u l=2u
X166 a_4150_2036.t0 pll_en.t10 vdd.t17 vdd.t6 pfet_03v3 ad=0.65p pd=3.3u as=0.65p ps=3.3u w=1u l=0.28u
X167 mf.t0 m2.t5 vdd.t30 vdd.t6 pfet_03v3 ad=0.65p pd=3.3u as=0.65p ps=3.3u w=1u l=0.28u
X168 r5.t3 r4.t7 a_7946_2036.t1 vdd.t29 pfet_03v3 ad=0.78p pd=3.52u as=1.95p ps=7.3u w=3u l=0.28u
X169 r1.t1 r5.t11 a_6390_2036.t1 vdd.t29 pfet_03v3 ad=0.78p pd=3.52u as=1.95p ps=7.3u w=3u l=0.28u
X170 vfilt vss.t118 cap_nmos_03v3_b c_width=35u c_length=12u
X171 vnt.t7 vref.t9 vss.t167 vss.t166 nfet_03v3 ad=1.22p pd=5.22u as=1.22p ps=5.22u w=2u l=2u
X172 s1.t2 clkb.t5 m2.t1 vdd.t22 pfet_03v3 ad=1.3p pd=5.3u as=1.3p ps=5.3u w=2u l=0.28u
X173 vbt.t11 vbp.t5 vdd.t119 vdd.t118 pfet_03v3 ad=2.6p pd=9.3u as=2.6p ps=9.3u w=4u l=2u
X174 en_b.t0 pll_en.t19 vss.t16 vss.t15 nfet_03v3 ad=0.61p pd=3.22u as=0.61p ps=3.22u w=1u l=4u
X175 vst.t3 en_b.t9 vdd.t121 vdd.t120 pfet_03v3 ad=0.325p pd=2.3u as=0.325p ps=2.3u w=0.5u l=10u
X176 vi.t4 vref.t10 vss.t152 vss.t151 nfet_03v3 ad=1.22p pd=5.22u as=1.22p ps=5.22u w=2u l=2u
X177 vcp_p.t4 vcp_p.t3 vdd.t86 vdd.t85 pfet_03v3 ad=32.5p pd=0.1013m as=32.5p ps=0.1013m w=50u l=4u
X178 a_7950_0.t1 vbn_vco.t6 vss.t50 vss.t49 nfet_03v3 ad=0.52p pd=2.52u as=1.22p ps=5.22u w=2u l=0.5u
X179 nb.t2 r5.t5 a_9070_n100 vss.t70 nfet_03v3 ad=0.52p pd=2.52u as=1.22p ps=5.22u w=2u l=0.28u
X180 vdump.t18 dn_b.t2 dn_s.t3 vss.t204 nfet_03v3 ad=1.22p pd=5.22u as=1.22p ps=5.22u w=2u l=0.5u
X181 a_14400_19482 a_13800_12030 vss.t158 ppolyf_u r_width=1u r_length=36.6u
X182 vdump.t7 vdump.t6 vbt.t5 vdd.t84 pfet_03v3 ad=3.25p pd=11.3u as=3.25p ps=11.3u w=5u l=1u
X183 vctrl.t1 up_b.t2 up_s.t1 vdd.t51 pfet_03v3 ad=2.6p pd=9.3u as=2.6p ps=9.3u w=4u l=0.5u
X184 r3.t2 r2.t7 a_3030_2036.t3 vdd.t29 pfet_03v3 ad=0.78p pd=3.52u as=1.95p ps=7.3u w=3u l=0.28u
X185 va.t2 en_b.t7 vss.t73 vss.t72 nfet_03v3 ad=0.61p pd=3.22u as=0.61p ps=3.22u w=1u l=0.28u
X186 a_5270_2036.t3 vbp_vco.t12 vdd.t96 vdd.t34 pfet_03v3 ad=1.3p pd=5.52u as=3.25p ps=11.3u w=5u l=0.5u
X187 r1.t0 pll_en.t7 vdd.t21 vdd.t20 pfet_03v3 ad=0.325p pd=2.3u as=0.325p ps=2.3u w=0.5u l=0.28u
X188 nb.t5 r5.t9 vdd.t93 vdd.t22 pfet_03v3 ad=0.52p pd=2.52u as=1.3p ps=5.3u w=2u l=0.28u
X189 up_b.t0 pfd_up.t2 vss.t26 vss.t25 nfet_03v3 ad=0.61p pd=3.22u as=0.61p ps=3.22u w=1u l=0.28u
X190 vi.t1 vctrl.t4 vs.t0 vss.t12 nfet_03v3 ad=3.05p pd=11.22u as=3.05p ps=11.22u w=5u l=1u
X191 t2.t0 cp_trim1.t2 vdd.t44 vdd.t43 pfet_03v3 ad=0.65p pd=3.3u as=0.65p ps=3.3u w=1u l=0.28u
X192 vdump.t0 vbh.t7 vdd.t54 vdd.t53 pfet_03v3 ad=2.6p pd=9.3u as=2.6p ps=9.3u w=4u l=2u
X193 vss.t210 clkb.t4 vss.t209 vss.t208 nfet_03v3 ad=0.61p pd=3.22u as=0 ps=0 w=1u l=0.45u
X194 vco_out.t2 nb.t11 vdd.t60 vdd.t29 pfet_03v3 ad=0.78p pd=3.52u as=1.95p ps=7.3u w=3u l=0.28u
X195 vcp_p.t2 vcp_p.t1 vdd.t92 vdd.t91 pfet_03v3 ad=32.5p pd=0.1013m as=32.5p ps=0.1013m w=50u l=4u
X196 vbn_vco.t2 vbp_vco.t17 vdd.t76 vdd.t75 pfet_03v3 ad=3.25p pd=11.3u as=3.25p ps=11.3u w=5u l=0.5u
X197 vst.t2 vref.t4 vss.t78 vss.t77 nfet_03v3 ad=3.05p pd=11.22u as=3.05p ps=11.22u w=5u l=1u
X198 a_10800_19482 a_11400_12030 vss.t88 ppolyf_u r_width=1u r_length=36.6u
X199 va.t0 vref.t7 vss.t87 vss.t86 nfet_03v3 ad=1.22p pd=5.22u as=1.22p ps=5.22u w=2u l=2u
X200 vss.t5 vbn_vco.t11 a_4154_0.t0 vss.t4 nfet_03v3 ad=1.22p pd=5.22u as=0.52p ps=2.52u w=2u l=0.5u
X201 vctrl.t11 vss.t8 cap_nmos_03v3_b c_width=43u c_length=12u
X202 m1.t1 clkb.t3 s1.t5 vss.t207 nfet_03v3 ad=0.61p pd=3.22u as=0.61p ps=3.22u w=1u l=0.28u
X203 r3.t0 r2.t5 a_3034_0.t0 vss.t37 nfet_03v3 ad=0.39p pd=2.02u as=0.915p ps=4.22u w=1.5u l=0.28u
X204 r2.t1 r1.t8 a_4150_2036.t1 vdd.t29 pfet_03v3 ad=0.78p pd=3.52u as=1.95p ps=7.3u w=3u l=0.28u
X205 a_7946_2036.t4 vbp_vco.t8 vdd.t70 vdd.t34 pfet_03v3 ad=1.3p pd=5.52u as=3.25p ps=11.3u w=5u l=0.5u
X206 a_6390_2036.t4 vbp_vco.t10 vdd.t114 vdd.t34 pfet_03v3 ad=1.3p pd=5.52u as=3.25p ps=11.3u w=5u l=0.5u
X207 a_5274_0.t4 en_b.t3 vss.t179 vss.t178 nfet_03v3 ad=0.305p pd=2.22u as=0.305p ps=2.22u w=0.5u l=0.28u
X208 a_7946_2036.t0 pll_en.t6 vdd.t19 vdd.t6 pfet_03v3 ad=0.65p pd=3.3u as=0.65p ps=3.3u w=1u l=0.28u
X209 a_5274_0.t0 vbn_vco.t10 vss.t3 vss.t2 nfet_03v3 ad=0.52p pd=2.52u as=1.22p ps=5.22u w=2u l=0.5u
X210 vbn_vco.t1 vbn_vco.t0 vss.t39 vss.t38 nfet_03v3 ad=2.44p pd=9.22u as=2.44p ps=9.22u w=4u l=0.5u
X211 dqn.t2 s1.t8 vdd.t49 vdd.t22 pfet_03v3 ad=1.3p pd=5.3u as=1.3p ps=5.3u w=2u l=0.28u
X212 vcp_n.t6 vbp.t14 vdd.t90 vdd.t89 pfet_03v3 ad=2.6p pd=9.3u as=2.6p ps=9.3u w=4u l=2u
X213 t1c.t0 cp_trim0.t0 t1b.t0 vss.t46 nfet_03v3 ad=1.22p pd=5.22u as=1.22p ps=5.22u w=2u l=0.28u
X214 a_3030_2036.t2 vbp_vco.t16 vdd.t36 vdd.t34 pfet_03v3 ad=1.3p pd=5.52u as=3.25p ps=11.3u w=5u l=0.5u
X215 m2.t0 m1.t4 vss.t90 vss.t89 nfet_03v3 ad=0.61p pd=3.22u as=0.61p ps=3.22u w=1u l=0.28u
X216 vcp_p.t6 vcp_n.t12 vss.t36 vss.t35 nfet_03v3 ad=12.2p pd=41.22u as=12.2p ps=41.22u w=20u l=4u
X217 vdump.t15 vdump.t14 vbt.t7 vdd.t83 pfet_03v3 ad=3.25p pd=11.3u as=3.25p ps=11.3u w=5u l=1u
X218 a_6394_0.t2 r5.t6 r1.t4 vss.t71 nfet_03v3 ad=0.915p pd=4.22u as=0.39p ps=2.02u w=1.5u l=0.28u
X219 vfilt vss.t120 cap_nmos_03v3_b c_width=35u c_length=12u
X220 a_6600_18162 a_7200_12030 vss.t171 ppolyf_u r_width=1u r_length=30u
X221 sf.t3 dqn.t4 vss.t206 vss.t205 nfet_03v3 ad=0.305p pd=2.22u as=0.305p ps=2.22u w=0.5u l=0.28u
X222 vss.t198 mf.t4 vss.t197 vss.t196 nfet_03v3 ad=2.44p pd=9.22u as=0 ps=0 w=4u l=1u
X223 r1.t3 r5.t7 a_6394_0.t3 vss.t83 nfet_03v3 ad=0.39p pd=2.02u as=0.915p ps=4.22u w=1.5u l=0.28u
X224 m1.t0 clkb.t6 mf.t2 vdd.t6 pfet_03v3 ad=0.65p pd=3.3u as=0.65p ps=3.3u w=1u l=0.28u
X225 a_6390_2036.t0 pll_en.t8 vdd.t18 vdd.t6 pfet_03v3 ad=0.65p pd=3.3u as=0.65p ps=3.3u w=1u l=0.28u
R0 vco_div2 vco_div2.n2 6.68608
R1 vco_div2.n2 vco_div2.n1 5.00509
R2 vco_div2.n1 vco_div2.t1 1.0925
R3 vco_div2.n1 vco_div2.t3 1.0925
R4 vco_div2.n2 vco_div2.n0 4.96805
R5 vco_div2.n0 vco_div2.t0 0.607167
R6 vco_div2.n0 vco_div2.t2 0.607167
R7 bias_ref bias_ref.n0 38.4912
R8 bias_ref.n0 bias_ref.t0 20.1588
R9 bias_ref.n0 bias_ref.t1 22.9937
R10 pll_en.n1 pll_en.n0 4.5005
R11 pll_en pll_en.n1 11.6495
R12 pll_en.n1 pll_en.n2 7.6775
R13 pll_en.n13 pll_en.n12 4.5005
R14 pll_en.n2 pll_en.n13 6.6485
R15 pll_en.n13 pll_en.n14 1.5185
R16 pll_en.n14 pll_en.n15 1.6505
R17 pll_en.n15 pll_en.n16 0.6245
R18 pll_en.n16 pll_en.n17 1.6505
R19 pll_en.n17 pll_en.n18 1.6505
R20 pll_en.n18 pll_en.t11 43.6029
R21 pll_en.n18 pll_en.t10 41.9529
R22 pll_en.n17 pll_en.t9 41.9529
R23 pll_en.n16 pll_en.t8 41.9529
R24 pll_en.n15 pll_en.t7 35.435
R25 pll_en.n14 pll_en.t6 41.9529
R26 pll_en.n12 pll_en.n11 6.56403
R27 pll_en.n11 pll_en.t1 45.7328
R28 pll_en.n11 pll_en.t2 45.5434
R29 pll_en.n12 pll_en.n10 4.94576
R30 pll_en.n10 pll_en.t4 45.7328
R31 pll_en.n10 pll_en.t5 45.5434
R32 pll_en.n7 pll_en.n6 4.5005
R33 pll_en.n2 pll_en.n9 10.1502
R34 pll_en.n9 pll_en.n7 3.9875
R35 pll_en.n9 pll_en.n8 13.8965
R36 pll_en.n8 pll_en.t12 95.5714
R37 pll_en.n8 pll_en.t13 94.4689
R38 pll_en.n6 pll_en.n3 0.5945
R39 pll_en.n3 pll_en.n4 0.626
R40 pll_en.n4 pll_en.n5 0.626
R41 pll_en.n5 pll_en.t14 50.3903
R42 pll_en.n5 pll_en.t15 56.073
R43 pll_en.n4 pll_en.t16 43.2623
R44 pll_en.n3 pll_en.t17 43.2623
R45 pll_en.n6 pll_en.t18 44.4143
R46 pll_en.n7 pll_en.t19 43.3385
R47 pll_en.n0 pll_en.t0 52.1069
R48 pll_en.n0 pll_en.t3 37.4529
R49 pfd_up.n0 pfd_up.n1 0.023
R50 pfd_up pfd_up.n0 17.4425
R51 pfd_up.n1 pfd_up.t2 74.8543
R52 pfd_up.n0 pfd_up.t0 54.6402
R53 pfd_up.n1 pfd_up.t1 57.5805
R54 pfd_dn pfd_dn.n0 13.685
R55 pfd_dn.n0 pfd_dn.n1 27.5562
R56 pfd_dn.n1 pfd_dn.t1 46.7811
R57 pfd_dn.n1 pfd_dn.t2 48.975
R58 pfd_dn.n0 pfd_dn.t0 59.1645
R59 cp_trim0.n1 cp_trim0.n0 10.9355
R60 cp_trim0 cp_trim0.n1 7.025
R61 cp_trim0.n1 cp_trim0.n2 22.4105
R62 cp_trim0.n2 cp_trim0.t2 54.5078
R63 cp_trim0.n2 cp_trim0.t3 53.3873
R64 cp_trim0.n0 cp_trim0.t0 60.1318
R65 cp_trim0.n0 cp_trim0.t1 61.3468
R66 cp_trim1.n1 cp_trim1.n0 0.068
R67 cp_trim1 cp_trim1.n1 17.285
R68 cp_trim1.n1 cp_trim1.t2 86.8718
R69 cp_trim1.n0 cp_trim1.t0 60.4918
R70 cp_trim1.n0 cp_trim1.t1 61.7068
R71 vctrl.n4 vctrl.n3 4.5005
R72 vctrl.n10 vctrl.n9 4.5005
R73 vctrl vctrl.n10 18.9793
R74 vctrl.n10 vctrl.n4 3.9875
R75 vctrl.n4 vctrl.n6 10.823
R76 vctrl.n6 vctrl.n5 7.03625
R77 vctrl.n9 vctrl.n7 3.686
R78 vctrl.n9 vctrl.n8 16.8395
R79 vctrl.n8 vctrl.t3 40.7877
R80 vctrl.n8 vctrl.t4 40.0182
R81 vctrl.n7 vctrl.t5 40.0182
R82 vctrl.n7 vctrl.t6 42.3267
R83 vctrl.n6 vctrl.t2 24.3534
R84 vctrl.n5 vctrl.t0 25.8641
R85 vctrl.n5 vctrl.t11 67.4552
R86 vctrl.n1 vctrl.n0 1.283
R87 vctrl.n3 vctrl.n1 2.336
R88 vctrl.n3 vctrl.n2 0.0275
R89 vctrl.n2 vctrl.t1 18.3577
R90 vctrl.n2 vctrl.t7 40.1274
R91 vctrl.n1 vctrl.t8 40.1274
R92 vctrl.n0 vctrl.t9 40.1274
R93 vctrl.n0 vctrl.t10 42.4899
R94 vdd vdd.n79 0.98975
R95 vdd.n78 vdd.n77 0.5005
R96 vdd.n79 vdd.n78 1.5035
R97 vdd.n78 vdd.n115 6.80969
R98 vdd.n81 vdd.n80 0.293
R99 vdd.n82 vdd.n81 0.30515
R100 vdd.n83 vdd.n82 0.08735
R101 vdd.n84 vdd.n83 0.2975
R102 vdd.n85 vdd.n84 0.30065
R103 vdd.n86 vdd.n85 0.08735
R104 vdd.n87 vdd.n86 0.2075
R105 vdd.n88 vdd.n87 0.203
R106 vdd.n89 vdd.n88 0.21065
R107 vdd.n90 vdd.n89 0.08735
R108 vdd.n91 vdd.n90 0.2075
R109 vdd.n92 vdd.n91 0.203
R110 vdd.n93 vdd.n92 0.21065
R111 vdd.n94 vdd.n93 0.08735
R112 vdd.n115 vdd.n94 0.11615
R113 vdd.n115 vdd.n95 0.08735
R114 vdd.n95 vdd.n96 0.2075
R115 vdd.n96 vdd.n97 0.21065
R116 vdd.n97 vdd.n98 0.08735
R117 vdd.n98 vdd.n99 0.2075
R118 vdd.n99 vdd.n100 0.203
R119 vdd.n100 vdd.n101 0.21065
R120 vdd.n101 vdd.n102 0.08735
R121 vdd.n102 vdd.n103 0.2075
R122 vdd.n103 vdd.n104 0.203
R123 vdd.n104 vdd.n105 0.1256
R124 vdd.n105 vdd.n106 0.13325
R125 vdd.n106 vdd.n107 0.08735
R126 vdd.n80 vdd.t91 113.022
R127 vdd.t91 vdd.t45 125.194
R128 vdd.n108 vdd.t45 83.7832
R129 vdd.n108 vdd.t122 83.7832
R130 vdd.t122 vdd.t85 125.194
R131 vdd.n109 vdd.t85 83.7832
R132 vdd.n109 vdd.t101 64.5228
R133 vdd.t101 vdd.t111 86.6723
R134 vdd.t65 vdd.t111 86.6723
R135 vdd.n110 vdd.t65 64.5228
R136 vdd.n110 vdd.t89 64.5228
R137 vdd.t89 vdd.t47 86.6723
R138 vdd.t32 vdd.t47 86.6723
R139 vdd.n111 vdd.t32 64.5228
R140 vdd.n111 vdd.t99 64.5228
R141 vdd.t99 vdd.t57 86.6723
R142 vdd.t57 vdd.t94 86.6723
R143 vdd.n112 vdd.t94 64.5228
R144 vdd.n112 vdd.t87 64.5228
R145 vdd.t87 vdd.t71 86.6723
R146 vdd.t71 vdd.t116 86.6723
R147 vdd.n113 vdd.t116 64.5228
R148 vdd.n113 vdd.t67 64.5228
R149 vdd.t67 vdd.t118 86.6723
R150 vdd.t118 vdd.t43 70.1084
R151 vdd.t37 vdd.t43 53.5444
R152 vdd.n114 vdd.t37 47.9589
R153 vdd.n114 vdd.t39 47.9589
R154 vdd.t39 vdd.n107 77.248
R155 vdd.n106 vdd.n114 29.1523
R156 vdd.n101 vdd.n113 29.1523
R157 vdd.n97 vdd.n112 29.1523
R158 vdd.n93 vdd.n111 29.1523
R159 vdd.n89 vdd.n110 29.1523
R160 vdd.n85 vdd.n109 29.1523
R161 vdd.n82 vdd.n108 29.1523
R162 vdd.n107 vdd.t40 24.6968
R163 vdd.n105 vdd.t38 24.6968
R164 vdd.n104 vdd.t44 24.6968
R165 vdd.n103 vdd.t119 14.696
R166 vdd.n102 vdd.t68 14.696
R167 vdd.n100 vdd.t117 14.696
R168 vdd.n99 vdd.t72 14.696
R169 vdd.n98 vdd.t88 14.696
R170 vdd.n96 vdd.t95 14.696
R171 vdd.n95 vdd.t58 14.696
R172 vdd.n94 vdd.t100 14.696
R173 vdd.n92 vdd.t33 14.696
R174 vdd.n91 vdd.t48 14.696
R175 vdd.n90 vdd.t90 14.696
R176 vdd.n88 vdd.t66 14.696
R177 vdd.n87 vdd.t112 14.696
R178 vdd.n86 vdd.t102 14.696
R179 vdd.n84 vdd.t86 8.42581
R180 vdd.n83 vdd.t123 8.42581
R181 vdd.n81 vdd.t46 8.42581
R182 vdd.n80 vdd.t92 8.42581
R183 vdd.n79 vdd.t124 36.8326
R184 vdd.n1 vdd.n11 0.15845
R185 vdd.n2 vdd.n1 0.7295
R186 vdd.n3 vdd.n2 0.08735
R187 vdd.n4 vdd.n3 0.203
R188 vdd.n5 vdd.n4 0.2075
R189 vdd.n6 vdd.n5 0.21065
R190 vdd.n7 vdd.n6 0.08735
R191 vdd.n8 vdd.n7 0.203
R192 vdd.n9 vdd.n8 0.4001
R193 vdd.n77 vdd.n9 0.13055
R194 vdd.n77 vdd.n10 0.0032
R195 vdd.n10 vdd.n60 0.08735
R196 vdd.n60 vdd.n61 0.1301
R197 vdd.n61 vdd.n62 0.1256
R198 vdd.n62 vdd.n0 0.1256
R199 vdd.n0 vdd.n63 0.13325
R200 vdd.n63 vdd.n64 0.08735
R201 vdd.n64 vdd.n65 0.5675
R202 vdd.n65 vdd.n66 0.14315
R203 vdd.n66 vdd.n67 0.08735
R204 vdd.n67 vdd.n68 0.14
R205 vdd.n68 vdd.n69 0.1355
R206 vdd.n69 vdd.n70 0.131
R207 vdd.n11 vdd.t0 431.449
R208 vdd.t0 vdd.t79 505.781
R209 vdd.t79 vdd.t84 505.781
R210 vdd.t1 vdd.t84 505.781
R211 vdd.n71 vdd.t1 411.851
R212 vdd.n71 vdd.t2 411.851
R213 vdd.t2 vdd.t110 505.781
R214 vdd.t110 vdd.t83 505.781
R215 vdd.t3 vdd.t83 505.781
R216 vdd.n72 vdd.t3 411.851
R217 vdd.n72 vdd.t63 484.104
R218 vdd.t63 vdd.t53 650.289
R219 vdd.t55 vdd.t53 650.289
R220 vdd.n73 vdd.t55 484.104
R221 vdd.n73 vdd.t73 484.104
R222 vdd.t73 vdd.t26 526.013
R223 vdd.t26 vdd.t51 417.63
R224 vdd.t28 vdd.t51 433.526
R225 vdd.t4 vdd.t28 417.63
R226 vdd.n74 vdd.t4 359.827
R227 vdd.n74 vdd.t41 359.827
R228 vdd.t41 vdd.t9 401.735
R229 vdd.t9 vdd.t15 401.735
R230 vdd.t11 vdd.t15 401.735
R231 vdd.n75 vdd.t11 359.827
R232 vdd.n75 vdd.t120 1062.14
R233 vdd.t120 vdd.t80 1119.94
R234 vdd.n76 vdd.t80 375.724
R235 vdd.n76 vdd.t77 375.724
R236 vdd.t77 vdd.t75 433.526
R237 vdd.t75 vdd.t103 433.526
R238 vdd.t13 vdd.t103 417.63
R239 vdd.n70 vdd.t13 378.991
R240 vdd.n66 vdd.n76 19.0273
R241 vdd.n63 vdd.n75 19.0273
R242 vdd.n10 vdd.n74 19.0273
R243 vdd.n6 vdd.n73 19.0273
R244 vdd.n2 vdd.n72 19.0273
R245 vdd.n1 vdd.n71 19.0273
R246 vdd.n70 vdd.t14 14.5718
R247 vdd.n69 vdd.t104 4.15247
R248 vdd.n68 vdd.t76 4.15247
R249 vdd.n67 vdd.t78 4.15247
R250 vdd.n65 vdd.t81 4.15247
R251 vdd.n64 vdd.t121 17.5681
R252 vdd.n62 vdd.t16 14.5718
R253 vdd.n61 vdd.t10 14.5718
R254 vdd.n60 vdd.t42 7.26817
R255 vdd.n11 vdd.n12 6.87314
R256 vdd.n12 vdd.n14 2.21673
R257 vdd.n24 vdd.n13 12.6234
R258 vdd.n24 vdd.n15 12.6005
R259 vdd.n24 vdd.n16 12.6005
R260 vdd.n24 vdd.n17 12.6005
R261 vdd.n24 vdd.n18 12.6005
R262 vdd.n24 vdd.n19 12.6005
R263 vdd.n24 vdd.n20 12.6005
R264 vdd.n21 vdd.n24 6.175
R265 vdd.n24 vdd.n22 6.175
R266 vdd.n24 vdd.n23 6.175
R267 vdd.n24 vdd.n25 12.6005
R268 vdd.n13 vdd.n26 0.0956459
R269 vdd.n26 vdd.n27 0.152214
R270 vdd.n27 vdd.n28 0.0686429
R271 vdd.n28 vdd.n29 0.140643
R272 vdd.n29 vdd.n15 0.00757143
R273 vdd.n15 vdd.n30 0.145143
R274 vdd.n30 vdd.n31 0.0686429
R275 vdd.n31 vdd.n32 0.140643
R276 vdd.n32 vdd.n33 0.152214
R277 vdd.n33 vdd.n16 0.0101429
R278 vdd.n16 vdd.n34 0.059
R279 vdd.n34 vdd.n35 0.140643
R280 vdd.n35 vdd.n36 0.152214
R281 vdd.n36 vdd.n37 0.0686429
R282 vdd.n37 vdd.n17 0.0962857
R283 vdd.n17 vdd.n38 0.0448571
R284 vdd.n38 vdd.n39 0.140643
R285 vdd.n39 vdd.n40 0.152214
R286 vdd.n40 vdd.n41 0.0686429
R287 vdd.n41 vdd.n18 0.110429
R288 vdd.n18 vdd.n42 0.0307143
R289 vdd.n42 vdd.n43 0.123929
R290 vdd.n43 vdd.n44 0.0686429
R291 vdd.n44 vdd.n45 0.123929
R292 vdd.n45 vdd.n46 0.0686429
R293 vdd.n46 vdd.n19 0.101429
R294 vdd.n19 vdd.n47 0.023
R295 vdd.n47 vdd.n48 0.0686429
R296 vdd.n48 vdd.n49 0.123929
R297 vdd.n50 vdd.n49 0.0686429
R298 vdd.n51 vdd.n50 0.140643
R299 vdd.n52 vdd.n51 0.0834286
R300 vdd.n20 vdd.n52 0.0095
R301 vdd.n14 vdd.n20 0.399714
R302 vdd.n14 vdd.n21 0.368071
R303 vdd.n21 vdd.n53 0.433
R304 vdd.n53 vdd.n54 0.140643
R305 vdd.n54 vdd.n22 0.447143
R306 vdd.n22 vdd.n55 0.471571
R307 vdd.n55 vdd.n56 0.140643
R308 vdd.n56 vdd.n57 0.140643
R309 vdd.n57 vdd.n23 0.268429
R310 vdd.n23 vdd.n58 0.619429
R311 vdd.n58 vdd.n59 0.140643
R312 vdd.n59 vdd.n25 0.00821429
R313 vdd.n25 vdd.t82 4.69411
R314 vdd.n59 vdd.t31 4.57839
R315 vdd.n58 vdd.t107 5.88015
R316 vdd.n57 vdd.t108 10.9352
R317 vdd.n56 vdd.t49 5.88015
R318 vdd.n55 vdd.t25 10.9352
R319 vdd.n54 vdd.t30 10.9352
R320 vdd.n53 vdd.t109 5.88015
R321 vdd.n52 vdd.t61 10.9352
R322 vdd.n51 vdd.t62 10.9352
R323 vdd.n50 vdd.t52 10.9352
R324 vdd.n49 vdd.t105 4.57839
R325 vdd.n48 vdd.t106 4.57839
R326 vdd.n47 vdd.t59 4.57839
R327 vdd.n46 vdd.t60 4.57839
R328 vdd.n45 vdd.t24 5.88015
R329 vdd.n44 vdd.t23 5.88015
R330 vdd.n43 vdd.t50 5.88015
R331 vdd.n42 vdd.t93 5.88015
R332 vdd.n41 vdd.t19 10.9352
R333 vdd.n40 vdd.t69 2.01891
R334 vdd.n39 vdd.t70 2.01891
R335 vdd.n38 vdd.t21 13.9344
R336 vdd.n37 vdd.t18 10.9352
R337 vdd.n36 vdd.t113 2.01891
R338 vdd.n35 vdd.t114 2.01891
R339 vdd.n34 vdd.t7 10.9352
R340 vdd.n33 vdd.t115 2.01891
R341 vdd.n32 vdd.t96 2.01891
R342 vdd.n31 vdd.t17 10.9352
R343 vdd.n30 vdd.t97 2.01891
R344 vdd.n29 vdd.t98 2.01891
R345 vdd.n28 vdd.t8 10.9352
R346 vdd.n27 vdd.t35 2.01891
R347 vdd.n26 vdd.t36 2.01891
R348 vdd.t6 vdd.t20 2.28298
R349 vdd.t22 vdd.t6 4.56546
R350 vdd.t29 vdd.t22 4.56546
R351 vdd.t34 vdd.t29 65.7359
R352 vdd.n24 vdd.t34 38.3462
R353 vdd.n12 vdd.n13 0.345969
R354 vdd.n9 vdd.t5 14.5718
R355 vdd.n8 vdd.t27 7.26817
R356 vdd.n7 vdd.t74 4.57101
R357 vdd.n5 vdd.t56 4.57101
R358 vdd.n4 vdd.t54 4.57101
R359 vdd.n3 vdd.t64 4.57101
R360 vdd.n0 vdd.t12 7.26817
R361 vss vss.n56 1.01289
R362 vss vss.n224 0.31029
R363 vss.n1 vss.n0 10.4005
R364 vss.n3 vss.n2 10.4005
R365 vss.n5 vss.n4 10.4005
R366 vss.n7 vss.n6 10.4005
R367 vss.n9 vss.n8 10.4005
R368 vss.n11 vss.n10 10.4005
R369 vss.n13 vss.n12 10.4005
R370 vss.n15 vss.n14 10.4005
R371 vss.n17 vss.n16 10.4005
R372 vss.n19 vss.n18 10.4005
R373 vss.n21 vss.n20 10.4005
R374 vss.n23 vss.n22 10.4005
R375 vss.n25 vss.n24 10.4005
R376 vss.n223 vss.n222 0.149643
R377 vss.n222 vss.n221 0.211357
R378 vss.n221 vss.n1 0.00757143
R379 vss.n1 vss.n220 0.142571
R380 vss.n219 vss.n220 0.0712143
R381 vss.n218 vss.n219 0.140643
R382 vss.n217 vss.n218 0.149643
R383 vss.n3 vss.n217 0.0127143
R384 vss.n216 vss.n3 0.059
R385 vss.n215 vss.n216 0.140643
R386 vss.n214 vss.n215 0.149643
R387 vss.n5 vss.n214 0.167
R388 vss.n213 vss.n5 0.185
R389 vss.n212 vss.n213 0.149643
R390 vss.n211 vss.n212 0.0712143
R391 vss.n7 vss.n211 0.110429
R392 vss.n210 vss.n7 0.222286
R393 vss.n209 vss.n210 0.121357
R394 vss.n208 vss.n209 0.0712143
R395 vss.n9 vss.n208 0.101429
R396 vss.n207 vss.n9 0.0204286
R397 vss.n206 vss.n207 0.262786
R398 vss.n205 vss.n206 0.140643
R399 vss.n204 vss.n205 0.0808571
R400 vss.n11 vss.n204 0.0120714
R401 vss.n224 vss.n11 0.2975
R402 vss.n224 vss.n203 0.156071
R403 vss.n203 vss.n13 0.0622143
R404 vss.n13 vss.n202 0.0545
R405 vss.n202 vss.n201 0.4595
R406 vss.n201 vss.n15 0.00178571
R407 vss.n15 vss.n200 0.114929
R408 vss.n200 vss.n199 0.0660714
R409 vss.n199 vss.n198 0.140643
R410 vss.n198 vss.n17 0.194643
R411 vss.n17 vss.n19 0.514786
R412 vss.n19 vss.n197 0.219071
R413 vss.n197 vss.n196 0.280786
R414 vss.n196 vss.n21 0.0159286
R415 vss.n21 vss.n195 0.125214
R416 vss.n195 vss.n194 0.116214
R417 vss.n194 vss.n193 0.0660714
R418 vss.n193 vss.n192 0.116214
R419 vss.n192 vss.n23 0.0930714
R420 vss.n23 vss.n191 0.366929
R421 vss.n191 vss.n190 0.140643
R422 vss.n190 vss.n25 0.00821429
R423 vss.n223 vss.t56 3.85787
R424 vss.n222 vss.t54 3.85787
R425 vss.n221 vss.t7 3.85787
R426 vss.n220 vss.t5 3.85787
R427 vss.n219 vss.t147 13.1287
R428 vss.n218 vss.t3 3.85787
R429 vss.n217 vss.t32 3.85787
R430 vss.n216 vss.t179 13.1287
R431 vss.n215 vss.t30 3.85787
R432 vss.n214 vss.t28 3.85787
R433 vss.n213 vss.t50 3.85787
R434 vss.n212 vss.t34 3.85787
R435 vss.n211 vss.t173 13.1287
R436 vss.n210 vss.t22 4.97103
R437 vss.n209 vss.t24 4.97103
R438 vss.n208 vss.t183 3.59261
R439 vss.n207 vss.t181 3.59261
R440 vss.n206 vss.t94 13.1287
R441 vss.n205 vss.t209 10.5494
R442 vss.n204 vss.t210 10.5494
R443 vss.n203 vss.t187 2.90418
R444 vss.n202 vss.t188 2.90418
R445 vss.n201 vss.t197 2.90418
R446 vss.n200 vss.t198 2.90418
R447 vss.n199 vss.t90 10.5494
R448 vss.n198 vss.t96 13.1287
R449 vss.n197 vss.t20 4.97103
R450 vss.n196 vss.t206 13.1287
R451 vss.n195 vss.t41 2.90418
R452 vss.n194 vss.t42 2.90418
R453 vss.n193 vss.t200 2.90418
R454 vss.n192 vss.t201 2.90418
R455 vss.n191 vss.t111 10.5494
R456 vss.n190 vss.t92 6.50024
R457 vss.n25 vss.t169 6.61338
R458 vss.n28 vss.n27 0.509553
R459 vss.n27 vss.n223 0.144334
R460 vss.n27 vss.n26 10.4049
R461 vss vss.n28 1.91573
R462 vss.n28 vss.n29 9.49664
R463 vss.n189 vss.n55 0.5005
R464 vss.n30 vss.n29 0.20075
R465 vss.n31 vss.n30 0.08645
R466 vss.n32 vss.n31 0.1994
R467 vss.n33 vss.n32 0.2057
R468 vss.n34 vss.n33 0.20615
R469 vss.n35 vss.n34 0.08645
R470 vss.n36 vss.n35 0.1994
R471 vss.n37 vss.n36 0.2057
R472 vss.n38 vss.n37 0.20615
R473 vss.n39 vss.n38 0.08645
R474 vss.n40 vss.n39 0.2057
R475 vss.n41 vss.n40 0.1994
R476 vss.n55 vss.n41 0.06395
R477 vss.n55 vss.n42 0.1427
R478 vss.n42 vss.n43 0.08645
R479 vss.n43 vss.n44 0.3596
R480 vss.n44 vss.n45 0.1544
R481 vss.n45 vss.n46 0.16115
R482 vss.n46 vss.n47 0.08645
R483 vss.n47 vss.n48 0.2894
R484 vss.n48 vss.n49 0.122
R485 vss.n49 vss.n50 0.122
R486 vss.n50 vss.n51 0.13505
R487 vss.n51 vss.n52 0.08645
R488 vss.n52 vss.n53 0.1319
R489 vss.n53 vss.n54 0.56435
R490 vss.n56 vss.n189 0.885071
R491 vss.n129 vss.n128 0.5005
R492 vss.n131 vss.n130 0.5005
R493 vss.n188 vss.n187 0.5005
R494 vss.n189 vss.n188 3.02154
R495 vss.n188 vss.n131 1.26365
R496 vss.n131 vss.n129 4.93858
R497 vss.n129 vss.n89 2.72418
R498 vss.n187 vss.t69 16.7666
R499 vss.n132 vss.t170 3.46717
R500 vss.n133 vss.t203 3.46717
R501 vss.n134 vss.t189 3.46717
R502 vss.n135 vss.t202 3.46717
R503 vss.n136 vss.t157 10.4005
R504 vss.n137 vss.t176 10.4005
R505 vss.t84 vss.n138 10.4005
R506 vss.n139 vss.t85 10.4005
R507 vss.n140 vss.t171 10.4005
R508 vss.n141 vss.t57 10.4005
R509 vss.n142 vss.t58 10.4005
R510 vss.n143 vss.t153 10.4005
R511 vss.n144 vss.t97 10.4005
R512 vss.n145 vss.t177 10.4005
R513 vss.n146 vss.t88 10.4005
R514 vss.n147 vss.t98 10.4005
R515 vss.n148 vss.t163 10.4005
R516 vss.n149 vss.t67 10.4005
R517 vss.n150 vss.t80 10.4005
R518 vss.n151 vss.t158 10.4005
R519 vss.n152 vss.t14 10.4005
R520 vss.n187 vss.n132 17.3635
R521 vss.n132 vss.n133 0.947868
R522 vss.n133 vss.n134 0.947868
R523 vss.n134 vss.n135 0.947868
R524 vss.n135 vss.n136 1.53997
R525 vss.n136 vss.n137 0.711026
R526 vss.n137 vss.n138 1.42155
R527 vss.n138 vss.n139 0.711026
R528 vss.n139 vss.n140 0.711026
R529 vss.n140 vss.n141 0.711026
R530 vss.n141 vss.n142 0.711026
R531 vss.n142 vss.n143 0.711026
R532 vss.n143 vss.n144 1.42155
R533 vss.n144 vss.n145 0.711026
R534 vss.n145 vss.n146 0.711026
R535 vss.n146 vss.n147 0.711026
R536 vss.n147 vss.n148 0.711026
R537 vss.n148 vss.n149 0.711026
R538 vss.n149 vss.n150 0.711026
R539 vss.n150 vss.n151 0.711026
R540 vss.n151 vss.n152 0.711026
R541 vss.n152 vss.t68 11.111
R542 vss.n161 vss.n153 20.1686
R543 vss.n164 vss.n154 20.1686
R544 vss.n167 vss.n155 20.1686
R545 vss.n168 vss.n156 20.1686
R546 vss.n173 vss.n157 20.1686
R547 vss.n159 vss.t170 111.99
R548 vss.t170 vss.t154 66.4169
R549 vss.t154 vss.t203 80.3607
R550 vss.t203 vss.t189 146.778
R551 vss.t189 vss.t103 8.44015
R552 vss.t103 vss.t202 138.338
R553 vss.t202 vss.n153 19.8153
R554 vss.n153 vss.t0 158.153
R555 vss.t157 vss.t0 60.5458
R556 vss.t157 vss.t176 110.082
R557 vss.t176 vss.t164 64.9491
R558 vss.t164 vss.t84 155.216
R559 vss.n154 vss.t84 2.93603
R560 vss.n154 vss.t85 107.147
R561 vss.t85 vss.t35 51.0054
R562 vss.t35 vss.t171 59.0781
R563 vss.t171 vss.t57 110.082
R564 vss.t57 vss.t148 66.4169
R565 vss.t58 vss.t148 43.6665
R566 vss.t58 vss.t153 110.082
R567 vss.t153 vss.t62 17.6137
R568 vss.t62 vss.n155 93.9375
R569 vss.n155 vss.t204 93.9375
R570 vss.t97 vss.t204 14.6782
R571 vss.t97 vss.t45 88.4334
R572 vss.t177 vss.t45 21.65
R573 vss.t177 vss.t65 77.4251
R574 vss.t88 vss.t65 32.6583
R575 vss.t88 vss.t46 66.4169
R576 vss.t98 vss.t46 43.6665
R577 vss.t98 vss.t66 55.4087
R578 vss.t163 vss.t66 54.6748
R579 vss.t163 vss.n156 35.2269
R580 vss.n156 vss.t67 74.8565
R581 vss.t67 vss.t25 15.0451
R582 vss.t25 vss.t80 95.0383
R583 vss.t80 vss.t63 4.03686
R584 vss.t63 vss.t194 99.0747
R585 vss.t158 vss.t194 6.97239
R586 vss.t158 vss.t14 110.082
R587 vss.t14 vss.t15 50.2715
R588 vss.t15 vss.t68 59.812
R589 vss.t68 vss.n157 98.3408
R590 vss.n157 vss.t101 103.112
R591 vss.t101 vss.t112 125.495
R592 vss.t112 vss.t161 125.495
R593 vss.t159 vss.t161 125.495
R594 vss.n158 vss.t159 103.112
R595 vss.n186 vss.n158 3753.4
R596 vss.n29 vss.t10 506.462
R597 vss.t10 vss.n185 319.43
R598 vss.n185 vss.t150 275.911
R599 vss.t150 vss.t156 595.341
R600 vss.t11 vss.t156 595.341
R601 vss.n178 vss.t11 489.154
R602 vss.n178 vss.t192 576.192
R603 vss.t192 vss.t107 769.417
R604 vss.t105 vss.t107 769.417
R605 vss.n179 vss.t105 576.192
R606 vss.n179 vss.t174 576.192
R607 vss.t174 vss.t151 769.417
R608 vss.t166 vss.t151 769.417
R609 vss.n180 vss.t166 576.192
R610 vss.n180 vss.t43 576.192
R611 vss.t43 vss.t86 769.417
R612 vss.t59 vss.t86 769.417
R613 vss.n181 vss.t59 576.192
R614 vss.n181 vss.t47 576.192
R615 vss.t47 vss.t61 682.379
R616 vss.t61 vss.t77 595.341
R617 vss.t51 vss.t77 595.341
R618 vss.n182 vss.t51 489.154
R619 vss.n182 vss.t190 750.269
R620 vss.t190 vss.t74 793.788
R621 vss.t72 vss.t74 470.005
R622 vss.t99 vss.t72 470.005
R623 vss.n183 vss.t99 426.486
R624 vss.n183 vss.t38 445.635
R625 vss.t38 vss.t184 489.154
R626 vss.t184 vss.t12 532.673
R627 vss.t12 vss.t13 595.341
R628 vss.t17 vss.t13 532.673
R629 vss.n184 vss.t17 426.486
R630 vss.n184 vss.t18 426.486
R631 vss.t18 vss.n186 177.559
R632 vss.n54 vss.n186 265.942
R633 vss.n185 vss.n26 5288.69
R634 vss.n26 vss.t37 500.954
R635 vss.t37 vss.t55 19.4722
R636 vss.t55 vss.t79 122.141
R637 vss.t79 vss.t53 58.4155
R638 vss.t53 vss.n0 715.143
R639 vss.n0 vss.t145 76.1171
R640 vss.t145 vss.t6 19.4722
R641 vss.t6 vss.t144 122.141
R642 vss.t144 vss.t4 58.4155
R643 vss.t4 vss.t146 405.365
R644 vss.t146 vss.t115 385.894
R645 vss.t2 vss.t115 19.4722
R646 vss.t114 vss.t2 122.141
R647 vss.t31 vss.t114 58.4155
R648 vss.n2 vss.t31 148.694
R649 vss.n2 vss.t178 256.673
R650 vss.t178 vss.t83 385.894
R651 vss.t83 vss.t29 19.4722
R652 vss.t29 vss.t71 122.141
R653 vss.t27 vss.t71 58.4155
R654 vss.n4 vss.t27 573.529
R655 vss.n4 vss.t117 603.622
R656 vss.t117 vss.t49 19.4722
R657 vss.t49 vss.t116 122.141
R658 vss.t33 vss.t116 58.4155
R659 vss.t172 vss.t33 405.365
R660 vss.n6 vss.t172 207.108
R661 vss.n6 vss.t70 178.786
R662 vss.t70 vss.t76 141.613
R663 vss.t76 vss.t21 385.894
R664 vss.t21 vss.t23 141.613
R665 vss.t182 vss.t23 385.894
R666 vss.t180 vss.t182 141.613
R667 vss.n8 vss.t180 40.714
R668 vss.n8 vss.t93 872.686
R669 vss.t208 vss.t93 400.94
R670 vss.n10 vss.t208 142.498
R671 vss.n10 vss.t142 258.442
R672 vss.t142 vss.t186 1147.06
R673 vss.n12 vss.t186 10.6214
R674 vss.n12 vss.t207 424.837
R675 vss.t207 vss.n14 991.285
R676 vss.n14 vss.t196 155.774
R677 vss.t196 vss.t89 435.459
R678 vss.t89 vss.t95 385.894
R679 vss.t109 vss.t95 385.894
R680 vss.n16 vss.t109 53.1051
R681 vss.n16 vss.t143 1030.23
R682 vss.n18 vss.t143 385.894
R683 vss.n18 vss.t19 697.441
R684 vss.t19 vss.t82 385.894
R685 vss.n20 vss.t82 332.789
R686 vss.n20 vss.t205 53.1051
R687 vss.t205 vss.t40 449.62
R688 vss.t40 vss.t199 499.183
R689 vss.n22 vss.t199 414.216
R690 vss.n22 vss.t81 21.2423
R691 vss.t81 vss.t110 1083.33
R692 vss.n24 vss.t110 311.548
R693 vss.n24 vss.t91 74.3469
R694 vss.t91 vss.t168 141.613
R695 vss.n54 vss.n184 16.7936
R696 vss.n51 vss.n183 16.7936
R697 vss.n46 vss.n182 16.7936
R698 vss.n42 vss.n181 16.7936
R699 vss.n38 vss.n180 16.7936
R700 vss.n34 vss.n179 16.7936
R701 vss.n30 vss.n178 16.7936
R702 vss.n177 vss.n158 20.3292
R703 vss.n160 vss.n159 0.2894
R704 vss.n161 vss.n160 0.30245
R705 vss.n162 vss.n161 0.08645
R706 vss.n163 vss.n162 0.2957
R707 vss.n164 vss.n163 0.29615
R708 vss.n165 vss.n164 0.08645
R709 vss.n166 vss.n165 0.2957
R710 vss.n167 vss.n166 0.42755
R711 vss.n130 vss.n167 0.4982
R712 vss.n130 vss.n168 0.2192
R713 vss.n168 vss.n169 0.08645
R714 vss.n169 vss.n170 0.122
R715 vss.n170 vss.n171 0.122
R716 vss.n171 vss.n172 0.1283
R717 vss.n172 vss.n173 0.29615
R718 vss.n173 vss.n174 0.08645
R719 vss.n174 vss.n175 0.1607
R720 vss.n175 vss.n176 0.1544
R721 vss.n176 vss.n177 0.1544
R722 vss.n177 vss.t160 5.98309
R723 vss.n176 vss.t162 5.98309
R724 vss.n175 vss.t113 5.98309
R725 vss.n174 vss.t102 5.98309
R726 vss.n172 vss.t16 18.5931
R727 vss.n171 vss.t195 19.4758
R728 vss.n170 vss.t64 19.4758
R729 vss.n169 vss.t26 18.5931
R730 vss.n166 vss.t149 5.00704
R731 vss.n165 vss.t36 5.00704
R732 vss.n163 vss.t165 5.00704
R733 vss.n162 vss.t1 5.00704
R734 vss.n160 vss.t104 5.00704
R735 vss.n159 vss.t155 5.00704
R736 vss.n91 vss.n90 0.6701
R737 vss.n92 vss.n91 0.6701
R738 vss.n93 vss.n92 0.6701
R739 vss.n128 vss.n93 0.00995
R740 vss.n128 vss.n94 0.66065
R741 vss.n96 vss.n95 0.0868014
R742 vss.n97 vss.n96 0.0868014
R743 vss.n94 vss.n97 7.65156
R744 vss.n97 vss.n127 4.57882
R745 vss.t140 vss.n127 0.0473
R746 vss.n99 vss.n98 0.0868014
R747 vss.n101 vss.n100 0.0868014
R748 vss.n103 vss.n102 0.0868014
R749 vss.n104 vss.n103 0.0868014
R750 vss.n106 vss.n105 0.0868014
R751 vss.n108 vss.n107 0.0868014
R752 vss.n109 vss.n108 0.0868014
R753 vss.n111 vss.n110 0.0868014
R754 vss.n113 vss.n112 0.0868014
R755 vss.n114 vss.n113 0.0868014
R756 vss.n116 vss.n115 0.0868014
R757 vss.n118 vss.n117 0.0868014
R758 vss.n119 vss.n118 0.0868014
R759 vss.n121 vss.n120 0.0868014
R760 vss.n123 vss.n122 0.0868014
R761 vss.n124 vss.n123 0.0868014
R762 vss.n126 vss.n125 0.0868014
R763 vss.n98 vss.n100 353.161
R764 vss.n100 vss.n102 66.5544
R765 vss.n102 vss.n105 353.075
R766 vss.n105 vss.n107 66.5544
R767 vss.n107 vss.n110 353.075
R768 vss.n110 vss.n112 66.5544
R769 vss.n112 vss.n115 353.075
R770 vss.n115 vss.n117 66.5544
R771 vss.n117 vss.n120 353.075
R772 vss.n120 vss.n122 66.5544
R773 vss.n122 vss.n125 353.075
R774 vss.n125 vss.n95 66.5544
R775 vss.n95 vss.n127 353.161
R776 vss.n126 vss.n124 4.57882
R777 vss.n94 vss.n124 6.98196
R778 vss.t138 vss.n126 0.0473
R779 vss.n123 vss.t138 0.0473
R780 vss.n121 vss.n119 4.57882
R781 vss.n93 vss.n119 6.98196
R782 vss.t136 vss.n121 0.0473
R783 vss.n118 vss.t136 0.0473
R784 vss.n116 vss.n114 4.57882
R785 vss.n92 vss.n114 6.98196
R786 vss.t134 vss.n116 0.0473
R787 vss.n113 vss.t134 0.0473
R788 vss.n111 vss.n109 4.57882
R789 vss.n91 vss.n109 6.98196
R790 vss.t132 vss.n111 0.0473
R791 vss.n108 vss.t132 0.0473
R792 vss.n106 vss.n104 4.57882
R793 vss.n90 vss.n104 6.98196
R794 vss.t130 vss.n106 0.0473
R795 vss.n103 vss.t130 0.0473
R796 vss.n101 vss.n99 4.57882
R797 vss.n90 vss.n99 7.65156
R798 vss.t128 vss.n101 0.0473
R799 vss.n98 vss.t128 0.0473
R800 vss.n96 vss.t140 0.0473
R801 vss.n58 vss.n57 0.6701
R802 vss.n59 vss.n58 0.6701
R803 vss.n60 vss.n59 0.6701
R804 vss.n89 vss.n60 0.00995
R805 vss.n62 vss.n61 0.0697308
R806 vss.n63 vss.n62 0.0697308
R807 vss.n89 vss.n63 7.99131
R808 vss.n63 vss.n88 5.26015
R809 vss.t8 vss.n88 0.038593
R810 vss.n65 vss.n64 0.0868014
R811 vss.n67 vss.n66 0.0868014
R812 vss.n69 vss.n68 0.0868014
R813 vss.n70 vss.n69 0.0868014
R814 vss.n72 vss.n71 0.0868014
R815 vss.n74 vss.n73 0.0868014
R816 vss.n75 vss.n74 0.0868014
R817 vss.n77 vss.n76 0.0868014
R818 vss.n79 vss.n78 0.0868014
R819 vss.n80 vss.n79 0.0868014
R820 vss.n82 vss.n81 0.0868014
R821 vss.n84 vss.n83 0.0868014
R822 vss.n85 vss.n84 0.0868014
R823 vss.n87 vss.n86 0.0868014
R824 vss.n64 vss.n66 288.168
R825 vss.n66 vss.n68 54.3033
R826 vss.n68 vss.n71 288.082
R827 vss.n71 vss.n73 54.3033
R828 vss.n73 vss.n76 288.082
R829 vss.n76 vss.n78 54.3033
R830 vss.n78 vss.n81 288.082
R831 vss.n81 vss.n83 54.3033
R832 vss.n83 vss.n86 288.082
R833 vss.n86 vss.n61 54.3033
R834 vss.n61 vss.n88 288.151
R835 vss.n87 vss.n85 4.57882
R836 vss.n60 vss.n85 8.78196
R837 vss.t126 vss.n87 0.0473
R838 vss.n84 vss.t126 0.0473
R839 vss.n82 vss.n80 4.57882
R840 vss.n59 vss.n80 8.78196
R841 vss.t124 vss.n82 0.0473
R842 vss.n79 vss.t124 0.0473
R843 vss.n77 vss.n75 4.57882
R844 vss.n58 vss.n75 8.78196
R845 vss.t122 vss.n77 0.0473
R846 vss.n74 vss.t122 0.0473
R847 vss.n72 vss.n70 4.57882
R848 vss.n57 vss.n70 8.78196
R849 vss.t120 vss.n72 0.0473
R850 vss.n69 vss.t120 0.0473
R851 vss.n67 vss.n65 4.57882
R852 vss.n57 vss.n65 9.45156
R853 vss.t118 vss.n67 0.0473
R854 vss.n64 vss.t118 0.0473
R855 vss.n62 vss.t8 0.038593
R856 vss.n56 vss.t211 45.7912
R857 vss.n53 vss.t185 15.2181
R858 vss.n52 vss.t39 4.5894
R859 vss.n50 vss.t100 16.1008
R860 vss.n49 vss.t73 16.1008
R861 vss.n48 vss.t75 16.1008
R862 vss.n47 vss.t191 17.7943
R863 vss.n45 vss.t52 4.15694
R864 vss.n44 vss.t78 4.15694
R865 vss.n43 vss.t48 7.39109
R866 vss.n41 vss.t60 7.39109
R867 vss.n40 vss.t87 7.39109
R868 vss.n39 vss.t44 7.39109
R869 vss.n37 vss.t167 7.39109
R870 vss.n36 vss.t152 7.39109
R871 vss.n35 vss.t175 7.39109
R872 vss.n33 vss.t106 7.39109
R873 vss.n32 vss.t108 7.39109
R874 vss.n31 vss.t193 7.39109
R875 a_19434_n100 a_19434_n100.t0 16.3801
R876 a_7950_0.n0 a_7950_0.t1 0.8195
R877 a_7950_0.n0 a_7950_0.t0 0.8195
R878 a_7950_0.n3 a_7950_0.n0 7.36905
R879 a_7950_0.n3 a_7950_0.n1 0.1625
R880 a_7950_0.n2 a_7950_0.n3 8.17078
R881 a_7950_0 a_7950_0.n2 0.8825
R882 a_7950_0.n2 a_7950_0.t3 1.6805
R883 a_7950_0.n1 a_7950_0.t2 9.58978
R884 a_7950_0.n1 a_7950_0.t4 16.8058
R885 a_6394_0.n0 a_6394_0.t1 0.8195
R886 a_6394_0.n0 a_6394_0.t0 0.8195
R887 a_6394_0.n2 a_6394_0.n0 7.36905
R888 a_6394_0.n1 a_6394_0.n2 8.17078
R889 a_6394_0 a_6394_0.n1 0.8825
R890 a_6394_0.n1 a_6394_0.t3 1.6805
R891 a_6394_0.n2 a_6394_0.t2 9.75178
R892 a_5274_0.t0 a_5274_0.n0 0.8195
R893 a_5274_0.n0 a_5274_0.t1 0.8195
R894 a_5274_0.n3 a_5274_0.n0 7.36905
R895 a_5274_0.n3 a_5274_0.n1 0.1625
R896 a_5274_0.n2 a_5274_0.n3 8.17078
R897 a_5274_0 a_5274_0.n2 0.8825
R898 a_5274_0.n2 a_5274_0.t3 1.6805
R899 a_5274_0.n1 a_5274_0.t2 9.58978
R900 a_5274_0.n1 a_5274_0.t4 16.8058
R901 a_4154_0.n0 a_4154_0.t1 0.8195
R902 a_4154_0.n0 a_4154_0.t0 0.8195
R903 a_4154_0.n3 a_4154_0.n0 7.36905
R904 a_4154_0.n3 a_4154_0.n1 0.1625
R905 a_4154_0.n2 a_4154_0.n3 8.17078
R906 a_4154_0 a_4154_0.n2 0.8825
R907 a_4154_0.n2 a_4154_0.t3 1.6805
R908 a_4154_0.n1 a_4154_0.t2 9.58978
R909 a_4154_0.n1 a_4154_0.t4 16.8058
R910 a_3034_0 a_3034_0.n0 0.8825
R911 a_3034_0.n0 a_3034_0.t0 1.6805
R912 a_3034_0.n0 a_3034_0.n2 8.17078
R913 a_3034_0.n2 a_3034_0.n1 7.36905
R914 a_3034_0.n1 a_3034_0.t2 0.8195
R915 a_3034_0.n1 a_3034_0.t1 0.8195
R916 a_3034_0.n2 a_3034_0.t3 9.75178
R917 sf.n0 sf.t1 20.3167
R918 sf sf.n0 0.542
R919 sf sf.n1 0.275
R920 sf.n1 sf.n2 5.6465
R921 sf.n2 sf.t3 16.3228
R922 sf.n2 sf.t2 14.9378
R923 sf.n1 sf.t4 35.5733
R924 sf.n0 sf.t0 20.8228
R925 mf.t0 mf.n0 14.6978
R926 mf.n2 mf.n0 4.5005
R927 mf.n0 mf.t1 16.5628
R928 mf.n2 mf.n1 0.3005
R929 mf.n1 mf.t2 20.0768
R930 mf.n1 mf.t3 21.0628
R931 mf mf.n2 0.278
R932 mf mf.t4 37.3298
R933 m2.n0 m2.t1 14.2909
R934 m2 m2.n0 0.941
R935 m2.n2 m2.n1 4.5005
R936 m2 m2.n2 1.52
R937 m2.n2 m2.n3 4.8005
R938 m2.n3 m2.t0 15.0777
R939 m2.n3 m2.t3 8.91189
R940 m2.n1 m2.t4 32.0733
R941 m2.n1 m2.t5 37.9329
R942 m2.n0 m2.t2 19.5777
R943 dqn.t1 dqn.n0 8.76855
R944 dqn.n4 dqn.n0 4.5005
R945 dqn.n0 dqn.t2 9.87189
R946 dqn.n2 dqn.n1 4.5005
R947 dqn.n2 dqn.n4 0.3005
R948 dqn dqn.n2 1.5905
R949 dqn dqn.n3 7.0625
R950 dqn.n3 dqn.t3 37.6312
R951 dqn.n3 dqn.t5 51.9286
R952 dqn.n1 dqn.t4 31.1133
R953 dqn.n1 dqn.t6 38.8929
R954 dqn.n4 dqn.t0 19.8097
R955 s1.t2 s1.n6 14.1319
R956 s1.n3 s1.n2 4.5005
R957 s1.n6 s1.n3 1.2155
R958 s1.n3 s1.n4 1.2785
R959 s1.n4 s1.n5 1.9865
R960 s1.n5 s1.t1 19.8487
R961 s1.n5 s1.t0 21.3027
R962 s1.n4 s1.t6 36.0533
R963 s1.n2 s1.t7 50.9069
R964 s1.n2 s1.t8 51.6886
R965 s1 s1.n6 0.776
R966 s1 s1.n0 0.116
R967 s1.n0 s1.n1 5.2115
R968 s1.n1 s1.t5 19.7367
R969 s1.n1 s1.t4 14.1319
R970 s1.n0 s1.t3 18.8578
R971 clkb.t1 clkb.n0 13.9778
R972 clkb.n0 clkb.t0 17.2827
R973 clkb.n2 clkb.n1 4.5005
R974 clkb.n2 clkb.n0 4.8005
R975 clkb.n3 clkb.n2 3.9635
R976 clkb clkb.n3 3.482
R977 clkb clkb.n4 1.4
R978 clkb.n4 clkb.n5 1.8065
R979 clkb.n5 clkb.t2 41.0949
R980 clkb.n5 clkb.t5 55.9313
R981 clkb.n4 clkb.t6 42.8955
R982 clkb.n3 clkb.t3 43.0738
R983 clkb.n1 clkb.t4 29.7619
R984 clkb.n1 clkb.t7 29.7459
R985 m1.t3 m1.n4 14.6119
R986 m1 m1.n4 0.935
R987 m1.n2 m1.n1 4.5005
R988 m1 m1.n2 0.473
R989 m1.n2 m1.n3 1.6025
R990 m1.n3 m1.t0 20.3288
R991 m1.n3 m1.t2 20.8228
R992 m1.n1 m1.t4 37.3912
R993 m1.n1 m1.t6 52.1686
R994 m1.n4 m1.n0 0.8915
R995 m1.n0 m1.t5 36.7133
R996 m1.n0 m1.t1 18.3778
R997 ck.t0 ck.n3 18.7178
R998 ck.n0 ck.n3 2.9345
R999 ck.n1 ck.n0 3.0395
R1000 ck ck.n1 0.632
R1001 ck ck.n2 1.175
R1002 ck.n2 ck.t4 49.5165
R1003 ck.n2 ck.t2 42.8338
R1004 ck.n1 ck.t3 36.3159
R1005 ck.n0 ck.t5 56.1712
R1006 ck.n3 ck.t1 22.4338
R1007 vco_out.n0 vco_out.t2 0.607167
R1008 vco_out.n0 vco_out.t1 0.607167
R1009 vco_out.n2 vco_out.n0 3.63647
R1010 vco_out.n4 vco_out.n2 2.25783
R1011 vco_out.n6 vco_out.n5 1.5005
R1012 vco_out.n6 vco_out.n4 0.426
R1013 vco_out vco_out.n6 0.29125
R1014 vco_out vco_out.n7 0.88825
R1015 vco_out.n7 vco_out.t0 13.0259
R1016 vco_out.n7 vco_out.t3 14.6046
R1017 vco_out.n5 vco_out.t9 37.9372
R1018 vco_out.n5 vco_out.t8 30.729
R1019 vco_out.n4 vco_out.n3 5.01392
R1020 vco_out.n3 vco_out.t5 0.607167
R1021 vco_out.n3 vco_out.t4 0.607167
R1022 vco_out.n2 vco_out.n1 3.04708
R1023 vco_out.n1 vco_out.t7 0.5465
R1024 vco_out.n1 vco_out.t6 0.5465
R1025 dqb.t1 dqb.n0 10.1119
R1026 dqb.n0 dqb.t0 13.8777
R1027 dqb dqb.n0 4.6505
R1028 dqb dqb.n3 4.6505
R1029 dqb.n3 dqb.n2 4.88403
R1030 dqb.n2 dqb.t2 39.215
R1031 dqb.n2 dqb.t3 39.0255
R1032 dqb.n3 dqb.n1 6.62576
R1033 dqb.n1 dqb.t4 58.7685
R1034 dqb.n1 dqb.t5 58.5791
R1035 nb.n0 nb.t0 0.9105
R1036 nb.n0 nb.t1 0.9105
R1037 nb.n9 nb.n0 5.55804
R1038 nb nb.n9 0.170303
R1039 nb nb.n7 0.0597105
R1040 nb.n7 nb.n8 7.61063
R1041 nb.n8 nb.t8 58.7685
R1042 nb.n8 nb.t9 58.5791
R1043 nb.n7 nb.n6 1.50761
R1044 nb.n6 nb.n5 4.81225
R1045 nb.n5 nb.t6 58.7685
R1046 nb.n5 nb.t7 58.5791
R1047 nb.n6 nb.n4 5.38274
R1048 nb.n4 nb.t10 58.7685
R1049 nb.n4 nb.t11 58.5791
R1050 nb.n9 nb.n1 1.49711
R1051 nb.n1 nb.n3 3.79261
R1052 nb.n3 nb.t2 0.8195
R1053 nb.n3 nb.t3 0.8195
R1054 nb.n1 nb.n2 4.33492
R1055 nb.n2 nb.t5 0.9105
R1056 nb.n2 nb.t4 0.9105
R1057 r4.n0 r4.t1 0.607167
R1058 r4.n0 r4.t0 0.607167
R1059 r4.n1 r4.n0 8.06634
R1060 r4.n1 r4.n5 8.25966
R1061 r4.n5 r4.t3 1.0925
R1062 r4.n5 r4.t2 1.0925
R1063 r4 r4.n1 6.3515
R1064 r4 r4.n4 6.3515
R1065 r4.n4 r4.n3 4.88403
R1066 r4.n3 r4.t4 39.215
R1067 r4.n3 r4.t5 39.0255
R1068 r4.n4 r4.n2 6.62576
R1069 r4.n2 r4.t6 58.7685
R1070 r4.n2 r4.t7 58.5791
R1071 r5.n0 r5.t3 0.607167
R1072 r5.n0 r5.t0 0.607167
R1073 r5.n1 r5.n0 7.82634
R1074 r5.n8 r5.n1 4.5005
R1075 r5.n1 r5.n9 8.49966
R1076 r5.n9 r5.t1 1.0925
R1077 r5.n9 r5.t2 1.0925
R1078 r5.n8 r5.n7 5.8685
R1079 r5.n7 r5.n6 5.12403
R1080 r5.n6 r5.t4 45.7328
R1081 r5.n6 r5.t5 45.5434
R1082 r5.n7 r5.n5 6.38576
R1083 r5.n5 r5.t8 45.7328
R1084 r5.n5 r5.t9 45.5434
R1085 r5 r5.n8 0.5945
R1086 r5 r5.n4 6.4925
R1087 r5.n4 r5.n3 5.12403
R1088 r5.n3 r5.t6 39.215
R1089 r5.n3 r5.t7 39.0255
R1090 r5.n4 r5.n2 6.38576
R1091 r5.n2 r5.t11 58.5791
R1092 r5.n2 r5.t10 58.7685
R1093 r3.n0 r3.t2 0.607167
R1094 r3.n0 r3.t1 0.607167
R1095 r3.n1 r3.n0 7.82634
R1096 r3.n1 r3.n5 8.49966
R1097 r3.n5 r3.t0 1.0925
R1098 r3.n5 r3.t3 1.0925
R1099 r3 r3.n1 6.0245
R1100 r3 r3.n4 6.0245
R1101 r3.n4 r3.n3 5.12403
R1102 r3.n3 r3.t4 39.215
R1103 r3.n3 r3.t5 39.0255
R1104 r3.n4 r3.n2 6.38576
R1105 r3.n2 r3.t6 58.7685
R1106 r3.n2 r3.t7 58.5791
R1107 r1.t1 r1.n0 0.607167
R1108 r1.n0 r1.t2 0.607167
R1109 r1.n1 r1.n0 7.58634
R1110 r1.n5 r1.n1 4.5005
R1111 r1.n1 r1.n6 8.73966
R1112 r1.n6 r1.t3 1.0925
R1113 r1.n6 r1.t4 1.0925
R1114 r1.n5 r1.t0 23.5268
R1115 r1 r1.n5 0.9395
R1116 r1 r1.n4 7.1735
R1117 r1.n4 r1.n3 5.36403
R1118 r1.n3 r1.t5 39.215
R1119 r1.n3 r1.t6 39.0255
R1120 r1.n4 r1.n2 6.14576
R1121 r1.n2 r1.t8 58.5791
R1122 r1.n2 r1.t7 58.7685
R1123 r2.n0 r2.t1 0.607167
R1124 r2.n0 r2.t0 0.607167
R1125 r2.n1 r2.n0 8.06634
R1126 r2.n1 r2.n5 8.25966
R1127 r2.n5 r2.t2 1.0925
R1128 r2.n5 r2.t3 1.0925
R1129 r2 r2.n1 5.4635
R1130 r2 r2.n4 5.4695
R1131 r2.n4 r2.n3 4.88403
R1132 r2.n3 r2.t4 39.215
R1133 r2.n3 r2.t5 39.0255
R1134 r2.n4 r2.n2 6.62576
R1135 r2.n2 r2.t7 58.5791
R1136 r2.n2 r2.t6 58.7685
R1137 a_7946_2036.t2 a_7946_2036.n3 6.95759
R1138 a_7946_2036.n1 a_7946_2036.n3 0.167
R1139 a_7946_2036.n3 a_7946_2036.t0 13.887
R1140 a_7946_2036.n2 a_7946_2036.n1 6.24309
R1141 a_7946_2036 a_7946_2036.n2 0.537167
R1142 a_7946_2036.n2 a_7946_2036.t1 0.9805
R1143 a_7946_2036.n1 a_7946_2036.n0 6.20245
R1144 a_7946_2036.n0 a_7946_2036.t4 0.3645
R1145 a_7946_2036.n0 a_7946_2036.t3 0.3645
R1146 a_6390_2036.t2 a_6390_2036.n3 6.95759
R1147 a_6390_2036.n1 a_6390_2036.n3 0.167
R1148 a_6390_2036.n3 a_6390_2036.t0 13.887
R1149 a_6390_2036.n2 a_6390_2036.n1 6.24309
R1150 a_6390_2036 a_6390_2036.n2 0.537167
R1151 a_6390_2036.n2 a_6390_2036.t1 0.9805
R1152 a_6390_2036.n1 a_6390_2036.n0 6.20245
R1153 a_6390_2036.n0 a_6390_2036.t4 0.3645
R1154 a_6390_2036.n0 a_6390_2036.t3 0.3645
R1155 a_5270_2036.t2 a_5270_2036.n3 6.95759
R1156 a_5270_2036.n1 a_5270_2036.n3 0.167
R1157 a_5270_2036.n3 a_5270_2036.t0 13.887
R1158 a_5270_2036.n2 a_5270_2036.n1 6.24309
R1159 a_5270_2036 a_5270_2036.n2 0.537167
R1160 a_5270_2036.n2 a_5270_2036.t1 0.9805
R1161 a_5270_2036.n1 a_5270_2036.n0 6.20245
R1162 a_5270_2036.n0 a_5270_2036.t3 0.3645
R1163 a_5270_2036.n0 a_5270_2036.t4 0.3645
R1164 a_4150_2036.t2 a_4150_2036.n3 6.95759
R1165 a_4150_2036.n1 a_4150_2036.n3 0.167
R1166 a_4150_2036.n3 a_4150_2036.t0 13.887
R1167 a_4150_2036.n2 a_4150_2036.n1 6.24309
R1168 a_4150_2036 a_4150_2036.n2 0.537167
R1169 a_4150_2036.n2 a_4150_2036.t1 0.9805
R1170 a_4150_2036.n1 a_4150_2036.n0 6.20245
R1171 a_4150_2036.n0 a_4150_2036.t4 0.3645
R1172 a_4150_2036.n0 a_4150_2036.t3 0.3645
R1173 a_3030_2036 a_3030_2036.n0 0.537167
R1174 a_3030_2036.n0 a_3030_2036.t3 0.9805
R1175 a_3030_2036.n0 a_3030_2036.n2 6.24309
R1176 a_3030_2036.n2 a_3030_2036.n3 0.167
R1177 a_3030_2036.n3 a_3030_2036.t0 13.887
R1178 a_3030_2036.n3 a_3030_2036.t4 6.95759
R1179 a_3030_2036.n2 a_3030_2036.n1 6.20245
R1180 a_3030_2036.n1 a_3030_2036.t2 0.3645
R1181 a_3030_2036.n1 a_3030_2036.t1 0.3645
R1182 vi.n2 vi.t2 13.0544
R1183 vi vi.n0 6.16325
R1184 vi.n0 vi.n1 0.77
R1185 vi.n1 vi.n2 0.365
R1186 vi.n2 vi.t3 11.9519
R1187 vi.n1 vi.t0 11.9519
R1188 vi.n0 vi.t1 11.9519
R1189 vi vi.t4 22.8266
R1190 vnt.n5 vnt.t0 11.4119
R1191 vnt.n1 vnt.n0 0.77
R1192 vnt.n5 vnt.n1 0.77
R1193 vnt vnt.n5 5.01125
R1194 vnt vnt.n2 2.35175
R1195 vnt.n2 vnt.n3 1.49
R1196 vnt.n3 vnt.n4 1.9895
R1197 vnt.n4 vnt.t3 15.3768
R1198 vnt.n4 vnt.t4 13.8873
R1199 vnt.n3 vnt.t2 13.8873
R1200 vnt.n2 vnt.t7 13.8873
R1201 vnt.n1 vnt.t6 11.4119
R1202 vnt.n0 vnt.t5 11.4119
R1203 vnt.n0 vnt.t1 12.1814
R1204 vbn_vco.t2 vbn_vco.n0 12.4312
R1205 vbn_vco.n12 vbn_vco.n0 12.8075
R1206 vbn_vco vbn_vco.n11 27.4021
R1207 vbn_vco vbn_vco.n2 9.14337
R1208 vbn_vco.n2 vbn_vco.n12 0.54725
R1209 vbn_vco.n11 vbn_vco.n5 1.5845
R1210 vbn_vco.n5 vbn_vco.n7 1.6505
R1211 vbn_vco.n7 vbn_vco.n9 1.6505
R1212 vbn_vco.n9 vbn_vco.n10 11.7621
R1213 vbn_vco.n10 vbn_vco.t5 29.8501
R1214 vbn_vco.n10 vbn_vco.t6 29.6085
R1215 vbn_vco.n9 vbn_vco.n8 9.45808
R1216 vbn_vco.n8 vbn_vco.t7 29.8501
R1217 vbn_vco.n8 vbn_vco.t8 29.6085
R1218 vbn_vco.n7 vbn_vco.n6 9.45808
R1219 vbn_vco.n6 vbn_vco.t9 29.8501
R1220 vbn_vco.n6 vbn_vco.t10 29.6085
R1221 vbn_vco.n5 vbn_vco.n4 9.45808
R1222 vbn_vco.n4 vbn_vco.t11 29.8501
R1223 vbn_vco.n4 vbn_vco.t12 29.6085
R1224 vbn_vco.n11 vbn_vco.n3 9.50758
R1225 vbn_vco.n3 vbn_vco.t13 29.8501
R1226 vbn_vco.n3 vbn_vco.t14 29.6085
R1227 vbn_vco.n12 vbn_vco.t4 20.2415
R1228 vbn_vco.n2 vbn_vco.n1 10.6768
R1229 vbn_vco.n1 vbn_vco.t1 1.88813
R1230 vbn_vco.n1 vbn_vco.t0 44.5424
R1231 vbn_vco.n0 vbn_vco.t3 12.1387
R1232 vst.t0 vst.n2 13.0319
R1233 vst vst.n2 0.88925
R1234 vst vst.n1 1.1525
R1235 vst.n1 vst.n0 0.068
R1236 vst.n1 vst.t3 35.2815
R1237 vst.n0 vst.t1 21.5195
R1238 vst.n0 vst.t4 15.367
R1239 vst.n2 vst.t2 13.8014
R1240 vbh.t1 vbh.n5 11.5919
R1241 vbh vbh.n5 2.03338
R1242 vbh vbh.n4 17.1489
R1243 vbh.n4 vbh.n1 0.0275
R1244 vbh.n1 vbh.n2 1.013
R1245 vbh.n2 vbh.n3 11.3292
R1246 vbh.n3 vbh.t5 1.83599
R1247 vbh.n3 vbh.t4 12.2744
R1248 vbh.n2 vbh.t6 22.039
R1249 vbh.n1 vbh.t7 22.039
R1250 vbh.n4 vbh.n0 11.1447
R1251 vbh.n0 vbh.t3 1.83599
R1252 vbh.n0 vbh.t2 12.2744
R1253 vbh.n5 vbh.t0 13.9004
R1254 vbl.t0 vbl.n0 13.9499
R1255 vbl.n1 vbl.n0 1.283
R1256 vbl.n2 vbl.n1 1.24475
R1257 vbl.n7 vbl.n2 12.0875
R1258 vbl.n4 vbl.n7 0.059
R1259 vbl vbl.n4 0.5765
R1260 vbl vbl.n5 0.419
R1261 vbl.n5 vbl.n6 12.812
R1262 vbl.n6 vbl.t7 3.47655
R1263 vbl.n6 vbl.t6 8.58548
R1264 vbl.n5 vbl.t8 19.8463
R1265 vbl.n4 vbl.t9 19.8463
R1266 vbl.n7 vbl.n3 12.596
R1267 vbl.n3 vbl.t5 3.47655
R1268 vbl.n3 vbl.t4 8.58548
R1269 vbl.n2 vbl.t1 12.7057
R1270 vbl.n1 vbl.t3 11.5874
R1271 vbl.n0 vbl.t2 11.5874
R1272 vbp_vco.t1 vbp_vco.n0 13.4144
R1273 vbp_vco vbp_vco.n16 25.4311
R1274 vbp_vco vbp_vco.n1 9.05563
R1275 vbp_vco.n1 vbp_vco.n0 1.12775
R1276 vbp_vco.n16 vbp_vco.n10 1.3445
R1277 vbp_vco.n10 vbp_vco.n12 1.6505
R1278 vbp_vco.n12 vbp_vco.n14 1.6505
R1279 vbp_vco.n14 vbp_vco.n15 11.7638
R1280 vbp_vco.n15 vbp_vco.t7 51.8961
R1281 vbp_vco.n15 vbp_vco.t8 51.6545
R1282 vbp_vco.n14 vbp_vco.n13 9.45982
R1283 vbp_vco.n13 vbp_vco.t9 51.8961
R1284 vbp_vco.n13 vbp_vco.t10 51.6545
R1285 vbp_vco.n12 vbp_vco.n11 9.45982
R1286 vbp_vco.n11 vbp_vco.t11 51.8961
R1287 vbp_vco.n11 vbp_vco.t12 51.6545
R1288 vbp_vco.n10 vbp_vco.n9 9.45982
R1289 vbp_vco.n9 vbp_vco.t13 51.8961
R1290 vbp_vco.n9 vbp_vco.t14 51.6545
R1291 vbp_vco.n16 vbp_vco.n8 9.73582
R1292 vbp_vco.n8 vbp_vco.t15 51.8961
R1293 vbp_vco.n8 vbp_vco.t16 51.6545
R1294 vbp_vco.n1 vbp_vco.n7 12.4475
R1295 vbp_vco.n4 vbp_vco.n3 0.6755
R1296 vbp_vco.n7 vbp_vco.n4 0.428
R1297 vbp_vco.n7 vbp_vco.n6 0.07925
R1298 vbp_vco.n6 vbp_vco.t2 19.8
R1299 vbp_vco.n6 vbp_vco.n5 10.1233
R1300 vbp_vco.n5 vbp_vco.t6 1.6447
R1301 vbp_vco.n5 vbp_vco.t5 51.9932
R1302 vbp_vco.n4 vbp_vco.t17 61.8952
R1303 vbp_vco.n3 vbp_vco.t18 61.8952
R1304 vbp_vco.n3 vbp_vco.n2 11.462
R1305 vbp_vco.n2 vbp_vco.t4 1.6447
R1306 vbp_vco.n2 vbp_vco.t3 51.9932
R1307 vbp_vco.n0 vbp_vco.t0 12.3119
R1308 vs vs.t1 12.0093
R1309 vs.n0 vs.t2 66.8035
R1310 vs vs.n0 0.352625
R1311 vs.n0 vs.t0 11.5919
R1312 vcl.t0 vcl.n0 14.0076
R1313 vcl.n2 vcl.n0 0.02075
R1314 vcl.n2 vcl.n1 0.74975
R1315 vcl vcl.n2 21.965
R1316 vcl vcl.t4 31.285
R1317 vcl.n1 vcl.t2 14.0076
R1318 vcl.n1 vcl.t3 13.2381
R1319 vcl.n0 vcl.t1 13.2381
R1320 up_b.t1 up_b.n0 14.4844
R1321 up_b up_b.t0 55.724
R1322 up_b up_b.n0 0.3605
R1323 up_b.n0 up_b.t2 56.0239
R1324 en_b.t1 en_b.n8 14.3044
R1325 en_b.n7 en_b.n8 5.81675
R1326 en_b.n4 en_b.n7 3.0875
R1327 en_b en_b.n4 18.9553
R1328 en_b en_b.n5 1.4915
R1329 en_b.n5 en_b.n6 3.9845
R1330 en_b.n6 en_b.t4 38.4633
R1331 en_b.n6 en_b.t3 36.8133
R1332 en_b.n5 en_b.t2 36.8133
R1333 en_b.n4 en_b.n1 8.4155
R1334 en_b.n1 en_b.n2 0.608
R1335 en_b.n2 en_b.n3 0.608
R1336 en_b.n3 en_b.t5 46.4256
R1337 en_b.n3 en_b.t6 44.6661
R1338 en_b.n2 en_b.t7 44.6661
R1339 en_b.n1 en_b.t8 44.6661
R1340 en_b.n7 en_b.n0 22.9888
R1341 en_b.n0 en_b.t0 25.3715
R1342 en_b.n0 en_b.t10 47.861
R1343 en_b.n8 en_b.t9 16.9751
R1344 t1c.t0 t1c 19.0646
R1345 t1c t1c.t1 19.0646
R1346 vdump.t3 vdump.n16 12.366
R1347 vdump.n15 vdump.n9 4.5005
R1348 vdump.n4 vdump.n2 2.858
R1349 vdump.n6 vdump.n4 0.788
R1350 vdump.n9 vdump.n6 0.02975
R1351 vdump.n9 vdump.n7 3.27875
R1352 vdump.n7 vdump.n8 1.013
R1353 vdump.n8 vdump.n16 3.4835
R1354 vdump.n14 vdump.n15 8.4875
R1355 vdump vdump.n12 1.73975
R1356 vdump vdump.n13 1.51475
R1357 vdump.n13 vdump.n14 0.47075
R1358 vdump.n14 vdump.t5 14.9516
R1359 vdump.n13 vdump.t4 14.4273
R1360 vdump.n12 vdump.n11 10.2695
R1361 vdump.n11 vdump.t11 1.68292
R1362 vdump.n11 vdump.t10 30.1453
R1363 vdump.n12 vdump.n10 11.039
R1364 vdump.n10 vdump.t9 1.68292
R1365 vdump.n10 vdump.t8 30.1453
R1366 vdump.n15 vdump.t18 45.2343
R1367 vdump.n16 vdump.t2 19.98
R1368 vdump.n8 vdump.t1 12.366
R1369 vdump.n7 vdump.t0 12.366
R1370 vdump.n6 vdump.n5 10.3032
R1371 vdump.n5 vdump.t15 1.6447
R1372 vdump.n5 vdump.t14 30.2254
R1373 vdump.n4 vdump.n3 10.3032
R1374 vdump.n3 vdump.t17 1.6447
R1375 vdump.n3 vdump.t16 30.2254
R1376 vdump.n2 vdump.n1 10.3032
R1377 vdump.n1 vdump.t7 1.6447
R1378 vdump.n1 vdump.t6 30.2254
R1379 vdump.n2 vdump.n0 11.0908
R1380 vdump.n0 vdump.t13 1.6447
R1381 vdump.n0 vdump.t12 30.2254
R1382 dn_b.t1 dn_b 18.6446
R1383 dn_b dn_b.n0 22.8988
R1384 dn_b.n0 dn_b.t0 24.1295
R1385 dn_b.n0 dn_b.t2 48.7005
R1386 vref.n12 vref.t0 12.9244
R1387 vref.n1 vref.n0 1.49
R1388 vref.n2 vref.n1 0.995
R1389 vref.n3 vref.n2 0.995
R1390 vref vref.n3 1.45963
R1391 vref vref.n4 0.030875
R1392 vref.n4 vref.n12 0.19625
R1393 vref.n12 vref.n7 0.02525
R1394 vref.n7 vref.n5 1.319
R1395 vref.n5 vref.n6 0.77
R1396 vref.n7 vref.n11 19.31
R1397 vref.n11 vref.t1 35.5713
R1398 vref.n11 vref.n8 14.1552
R1399 vref.n8 vref.n9 0.77
R1400 vref.n9 vref.n10 0.77
R1401 vref.n10 vref.t11 69.8502
R1402 vref.n10 vref.t12 69.0807
R1403 vref.n9 vref.t13 69.0807
R1404 vref.n8 vref.t14 69.0807
R1405 vref.n6 vref.t2 24.134
R1406 vref.n6 vref.t3 40.7382
R1407 vref.n5 vref.t4 40.7382
R1408 vref.n4 vref.t5 19.8463
R1409 vref.n3 vref.t6 19.8463
R1410 vref.n2 vref.t7 19.8463
R1411 vref.n1 vref.t8 19.8463
R1412 vref.n0 vref.t9 19.8463
R1413 vref.n0 vref.t10 20.8408
R1414 dn_s.t0 dn_s.n0 14.0665
R1415 dn_s dn_s.n0 1.7285
R1416 dn_s dn_s.n1 2.021
R1417 dn_s.n1 dn_s.t3 18.7743
R1418 dn_s.n1 dn_s.t1 17.6223
R1419 dn_s.n0 dn_s.t2 12.622
R1420 t1b t1b.t0 20.6857
R1421 t1b t1b.n0 24.7359
R1422 t1b.n0 t1b.t1 38.3693
R1423 t1b.n0 t1b.t2 23.1052
R1424 va.t1 va.n1 68.535
R1425 va.n0 va.n1 0.0095
R1426 va va.n0 0.55175
R1427 va va.t2 23.6143
R1428 va.n0 va.t3 36.4132
R1429 va.n1 va.t0 17.4806
R1430 t1a t1a.t2 18.5032
R1431 t1a t1a.n0 23.8134
R1432 t1a.n0 t1a.t1 39.7687
R1433 t1a.n0 t1a.t0 22.3177
R1434 t2 t2.t1 20.8094
R1435 t2 t2.n1 26.2996
R1436 t2.n1 t2.n0 0.00725
R1437 t2.n1 t2.t0 34.8233
R1438 t2.n0 t2.t3 22.671
R1439 t2.n0 t2.t2 28.7235
R1440 vcp_n.t11 vcp_n.n0 2.56676
R1441 vcp_n.n0 vcp_n.t10 20.9799
R1442 vcp_n.n13 vcp_n.n0 9.69575
R1443 vcp_n.n3 vcp_n.n2 1.94
R1444 vcp_n.n4 vcp_n.n3 1.445
R1445 vcp_n.n5 vcp_n.n4 1.94
R1446 vcp_n vcp_n.n5 0.44825
R1447 vcp_n vcp_n.n13 0.8285
R1448 vcp_n.n13 vcp_n.n9 1.77575
R1449 vcp_n.n9 vcp_n.n6 0.64175
R1450 vcp_n.n6 vcp_n.n7 0.608
R1451 vcp_n.n7 vcp_n.n8 1.2155
R1452 vcp_n.n9 vcp_n.n12 23.6525
R1453 vcp_n.n12 vcp_n.n10 0.05225
R1454 vcp_n.n12 vcp_n.n11 8.02625
R1455 vcp_n.n11 vcp_n.t4 25.011
R1456 vcp_n.n11 vcp_n.t5 22.491
R1457 vcp_n.n10 vcp_n.t6 22.491
R1458 vcp_n.n10 vcp_n.t7 25.011
R1459 vcp_n.n8 vcp_n.t3 25.1533
R1460 vcp_n.n8 vcp_n.t1 17.2623
R1461 vcp_n.n7 vcp_n.t2 17.2623
R1462 vcp_n.n6 vcp_n.t0 17.2623
R1463 vcp_n.n5 vcp_n.t12 30.5283
R1464 vcp_n.n4 vcp_n.t13 30.5283
R1465 vcp_n.n3 vcp_n.t14 30.5283
R1466 vcp_n.n2 vcp_n.t15 30.5283
R1467 vcp_n.n2 vcp_n.n1 11.309
R1468 vcp_n.n1 vcp_n.t9 2.56676
R1469 vcp_n.n1 vcp_n.t8 20.9799
R1470 vbt.n6 vbt.t3 11.9317
R1471 vbt.n1 vbt.n0 0.788
R1472 vbt.n2 vbt.n1 0.788
R1473 vbt vbt.n2 0.64175
R1474 vbt vbt.n3 0.64175
R1475 vbt.n3 vbt.n4 0.788
R1476 vbt.n4 vbt.n5 0.788
R1477 vbt.n5 vbt.n6 0.26375
R1478 vbt.n6 vbt.n7 42.9665
R1479 vbt.n7 vbt.n8 2.0255
R1480 vbt.n8 vbt.n9 10.598
R1481 vbt.n9 vbt.t11 24.831
R1482 vbt.n9 vbt.t10 22.311
R1483 vbt.n8 vbt.t8 22.311
R1484 vbt.n7 vbt.t9 22.311
R1485 vbt.n5 vbt.t7 11.4074
R1486 vbt.n4 vbt.t6 11.4074
R1487 vbt.n3 vbt.t2 11.4074
R1488 vbt.n2 vbt.t1 11.4074
R1489 vbt.n1 vbt.t5 11.4074
R1490 vbt.n0 vbt.t4 11.4074
R1491 vbt.n0 vbt.t0 12.1949
R1492 vbp.t4 vbp.n0 13.6241
R1493 vbp vbp.n0 1.22
R1494 vbp.n0 vbp.n15 8.4875
R1495 vbp.n15 vbp.n14 34.8508
R1496 vbp.n15 vbp.t1 25.0852
R1497 vbp.n2 vbp.n1 1.013
R1498 vbp.n3 vbp.n2 1.508
R1499 vbp.n4 vbp.n3 1.013
R1500 vbp.n5 vbp.n4 1.013
R1501 vbp.n7 vbp.n5 1.33925
R1502 vbp.n8 vbp.n7 1.18175
R1503 vbp.n14 vbp.n8 0.1985
R1504 vbp.n14 vbp.n9 0.815
R1505 vbp.n9 vbp.n10 1.508
R1506 vbp.n10 vbp.n11 1.013
R1507 vbp.n11 vbp.n12 1.013
R1508 vbp.n12 vbp.n13 1.508
R1509 vbp.n13 vbp.t5 33.1765
R1510 vbp.n13 vbp.t6 32.164
R1511 vbp.n12 vbp.t7 32.164
R1512 vbp.n11 vbp.t8 32.164
R1513 vbp.n10 vbp.t9 32.164
R1514 vbp.n9 vbp.t10 32.164
R1515 vbp.n8 vbp.t11 32.164
R1516 vbp.n7 vbp.n6 20.1155
R1517 vbp.n6 vbp.t3 1.83599
R1518 vbp.n6 vbp.t2 12.2744
R1519 vbp.n5 vbp.t12 32.164
R1520 vbp.n4 vbp.t13 32.164
R1521 vbp.n3 vbp.t14 32.164
R1522 vbp.n2 vbp.t15 32.164
R1523 vbp.n1 vbp.t16 32.164
R1524 vbp.n1 vbp.t17 33.1765
R1525 vbp vbp.t0 25.0362
R1526 up_s.t2 up_s.n0 17.8183
R1527 up_s.n1 up_s.n0 48.785
R1528 up_s up_s.n1 0.29525
R1529 up_s up_s.t0 12.1635
R1530 up_s.n1 up_s.t1 11.8687
R1531 up_s.n0 up_s.t3 15.8608
R1532 vcp_p.t4 vcp_p.n0 5.96191
R1533 vcp_p.n0 vcp_p.t3 48.3696
R1534 vcp_p.n4 vcp_p.n0 10.9276
R1535 vcp_p.n3 vcp_p.n2 1.958
R1536 vcp_p.n4 vcp_p.n3 0.086
R1537 vcp_p.n6 vcp_p.n5 4.5005
R1538 vcp_p.n6 vcp_p.n4 18.4325
R1539 vcp_p vcp_p.n6 26.8014
R1540 vcp_p vcp_p.t0 25.2371
R1541 vcp_p.n5 vcp_p.t6 15.5223
R1542 vcp_p.n5 vcp_p.t5 14.6853
R1543 vcp_p.n3 vcp_p.t7 57.9578
R1544 vcp_p.n2 vcp_p.t8 57.9578
R1545 vcp_p.n2 vcp_p.n1 11.3506
R1546 vcp_p.n1 vcp_p.t2 5.96191
R1547 vcp_p.n1 vcp_p.t1 48.3696
C0 vbn_vco vi 2.5123f
C1 t2 pfd_dn 0.07501f
C2 s1 vco_div2 0
C3 dqb sf 0.00334f
C4 pll_en t2 0.0713f
C5 pfd_up t1a 0.01691f
C6 vcp_p vref 0.06391f
C7 pll_en ck 0.20659f
C8 a_13200_19482 a_14400_19482 0.00585f
C9 a_5270_2036 r5 0.00645f
C10 r2 a_5274_0 0
C11 vbn_vco bias_ref 0.05372f
C12 pfd_dn vi 0
C13 r5 r4 0.76807f
C14 t2 cp_trim0 1.98411f
C15 pll_en vco_div2 0.07512f
C16 pfd_up vcp_p 0.18181f
C17 pll_en vi 0.38487f
C18 vctrl a_5274_0 0.03536f
C19 vcl up_s 0.04166f
C20 up_b vbp 0.01037f
C21 vcp_n vbp 9.05131f
C22 m2 s1 0.35403f
C23 vbt vbh 0
C24 vco_out vdd 1.7699f
C25 pfd_dn bias_ref 0
C26 r2 a_4154_0 0.12529f
C27 pll_en bias_ref 0.06863f
C28 t1a t1c 0.11815f
C29 t2 en_b 0.11755f
C30 a_6394_0 r3 0
C31 vdd vnt 0.39588f
C32 vctrl a_4154_0 0.00223f
C33 dn_b vdump 0.99379f
C34 ck en_b 0.03669f
C35 va vbn_vco 0.03168f
C36 vst vref 1.11674f
C37 pll_en m2 0.37963f
C38 pfd_dn cp_trim1 0.07834f
C39 a_10800_19482 bias_ref 0.01549f
C40 en_b vi 0.22442f
C41 a_10200_12030 vctrl 0
C42 pll_en cp_trim1 0.38453f
C43 t1b vref 0.0064f
C44 pfd_up vst 0.3491f
C45 vbp_vco vnt 0.0425f
C46 a_5270_2036 a_4150_2036 0.09903f
C47 pfd_dn dn_s 0.22459f
C48 pfd_dn va 0.11577f
C49 r4 a_4150_2036 0.01183f
C50 r1 r5 0.72005f
C51 r2 vdd 0.38745f
C52 clkb vco_out 0.5187f
C53 cp_trim0 cp_trim1 1.21829f
C54 m1 ck 0.5064f
C55 pll_en va 4.86974f
C56 pfd_up vref 0.21496f
C57 pfd_up t1b 0
C58 en_b bias_ref 0.05259f
C59 vbt t2 0.26147f
C60 a_13800_12030 vdd 0.00122f
C61 vs a_12000_19482 0.00168f
C62 vdd vctrl 5.53687f
C63 vcp_p a_10200_12030 0.00439f
C64 vdump up_s 0.25103f
C65 dn_b vbp 0.03144f
C66 m2 en_b 0
C67 cp_trim0 va 0.02926f
C68 vbp_vco r2 0.02798f
C69 a_7946_2036 vdd 1.10603f
C70 dqn a_19434_n100 0.0773f
C71 t1a vdd 4.71023f
C72 vbt vfilt 0.31939f
C73 en_b cp_trim1 0.40766f
C74 vbp_vco vctrl 0.2127f
C75 a_7800_18162 bias_ref 0.00948f
C76 vcp_p vdd 20.6567f
C77 vbp_vco a_7946_2036 0.27897f
C78 t2 vs 0
C79 t1c vref 0.01204f
C80 t1b t1c 0.91825f
C81 a_7950_0 bias_ref 0
C82 va en_b 4.37607f
C83 a_6390_2036 r3 0
C84 m2 m1 0.39614f
C85 a_3034_0 r1 0
C86 vcl a_12000_19482 0.00132f
C87 r1 a_4150_2036 0.09967f
C88 pfd_dn vbn_vco 0.04997f
C89 a_8400_12030 a_7200_12030 0.00585f
C90 pfd_up t1c 0.07192f
C91 vs vfilt 0.71378f
C92 up_s vbp 1.13572f
C93 vs vi 0.49461f
C94 vbp_vco vcp_p 0
C95 vco_out r5 0
C96 pll_en vbn_vco 0.25926f
C97 a_13200_19482 vref 0.01368f
C98 a_11400_12030 vctrl 0
C99 a_5270_2036 r3 0.09942f
C100 pll_en s1 0.28098f
C101 up_b vctrl 0.44195f
C102 vdd a_19434_n100 0
C103 vcp_n vctrl 0.36217f
C104 vbt cp_trim1 0.06657f
C105 r3 r4 0.39123f
C106 mf vdd 0.19048f
C107 r1 a_3030_2036 0.00645f
C108 a_6600_18162 a_7800_18162 0.00585f
C109 vs bias_ref 0.15601f
C110 vcp_n t1a 0.73828f
C111 t2 vcl 0
C112 t1a up_b 0.0896f
C113 pll_en pfd_dn 0.48654f
C114 vbt dn_s 0.06708f
C115 vbt va 0.09992f
C116 vst vdd 1.25611f
C117 vdump vbh 0.96545f
C118 vdd a_9070_n100 0
C119 dn_b a_14400_19482 0
C120 a_11400_12030 vcp_p 0.00439f
C121 cp_trim0 pfd_dn 0.065f
C122 nb bias_ref 0.18778f
C123 up_b vcp_p 0.50439f
C124 vcl vfilt 0.09853f
C125 vcp_n vcp_p 3.15736f
C126 vdd vref 3.72248f
C127 t1b vdd 5.51706f
C128 vbn_vco en_b 0.74064f
C129 vs cp_trim1 0.00101f
C130 pll_en cp_trim0 0.44467f
C131 a_4154_0 a_5274_0 0.06051f
C132 vbp_vco vst 0.15161f
C133 vbt a_6000_12030 0
C134 s1 en_b 0.0215f
C135 ck sf 0.08075f
C136 pfd_up vdd 3.04569f
C137 clkb a_19434_n100 0
C138 vcl bias_ref 0.00215f
C139 mf clkb 0.08644f
C140 vs dn_s 0.00568f
C141 va vs 0.0366f
C142 vctrl r5 0.06543f
C143 vbp_vco vref 2.50356f
C144 a_6000_12030 a_7200_12030 0.00585f
C145 sf vco_div2 0
C146 pfd_dn en_b 0.37735f
C147 a_7946_2036 r5 0.25376f
C148 r1 r3 0.32275f
C149 pll_en en_b 4.27441f
C150 a_13800_12030 dn_b 0.00984f
C151 dn_b vctrl 0.00347f
C152 pfd_up vbp_vco 0.82244f
C153 vbl vbh 0.19431f
C154 s1 m1 0.57846f
C155 vcl cp_trim1 0.00205f
C156 vbn_vco a_7950_0 0.18732f
C157 cp_trim0 en_b 0.1122f
C158 vbt vbn_vco 0
C159 t1a dn_b 0.76832f
C160 a_1200_19662 vfilt 0.00928f
C161 t2 vdump 0.0032f
C162 vdd a_5274_0 0
C163 t1c vdd 0.0294f
C164 vcl va 0.0396f
C165 r2 a_3034_0 0.08212f
C166 up_b vref 0.07501f
C167 up_b t1b 0.03206f
C168 vcl dn_s 0.00743f
C169 vcp_n vref 0.18349f
C170 vcp_n t1b 0.17251f
C171 pll_en m1 0.12664f
C172 vdump vfilt 0.09325f
C173 r2 a_4150_2036 0.24979f
C174 dn_b vcp_p 0.05675f
C175 dqn vdd 0.76023f
C176 vdump vi 0
C177 vbn_vco a_6394_0 0.26815f
C178 pfd_up a_11400_12030 0.00139f
C179 vdd a_4154_0 0
C180 pll_en a_7950_0 0
C181 pfd_up up_b 1.40268f
C182 pfd_up vcp_n 0.22642f
C183 a_13200_19482 vdd 0.03701f
C184 vctrl a_4150_2036 0.00335f
C185 up_s vctrl 0.40216f
C186 vs vbn_vco 0.50599f
C187 vdump a_8400_12030 0
C188 vdump bias_ref 0.06209f
C189 r2 a_3030_2036 0.11202f
C190 vbt cp_trim0 0.03026f
C191 t2 vbp 4.66024f
C192 t1a up_s 0.1329f
C193 pll_en a_6394_0 0
C194 a_9070_n100 r5 0.10046f
C195 pfd_dn vs 0.13737f
C196 m1 en_b 0.01066f
C197 vcp_p up_s 4.64703f
C198 pll_en vs 0.31982f
C199 vfilt vbp 0.54035f
C200 vi vbp 0.08039f
C201 vbl vi 0.01838f
C202 vbh vnt 1.9816f
C203 up_b t1c 0.07486f
C204 en_b a_7950_0 0.01356f
C205 dqn clkb 0.1328f
C206 vcp_n t1c 0.66125f
C207 cp_trim0 vs 0.00101f
C208 dn_b t1b 0.51245f
C209 vdump va 0
C210 vs a_10800_19482 0.00168f
C211 dn_b vref 3.16506f
C212 vdump dn_s 1.55454f
C213 pll_en nb 0.86356f
C214 vbp_vco vdd 8.80634f
C215 en_b a_6394_0 0.00158f
C216 pfd_dn vcl 0.09059f
C217 r2 r3 0.67669f
C218 pfd_up dn_b 0.09272f
C219 a_11400_12030 a_10200_12030 0.00585f
C220 up_b a_10200_12030 0.00314f
C221 pll_en vcl 0.07266f
C222 vdump a_6000_12030 0.00304f
C223 vs en_b 0.30121f
C224 r3 vctrl 0.01436f
C225 s1 sf 0.47236f
C226 vbp cp_trim1 0.17454f
C227 vbh vctrl 2.66101f
C228 a_5274_0 r5 0.0029f
C229 clkb vdd 1.15559f
C230 vco_out ck 0.38582f
C231 cp_trim0 vcl 0.00301f
C232 vcl a_10800_19482 0.00132f
C233 nb en_b 0.35094f
C234 vbn_vco r4 0.11395f
C235 vbp dn_s 0
C236 va vbp 4.04463f
C237 up_s vref 0.05808f
C238 t1b up_s 0.02759f
C239 up_b vdd 1.28867f
C240 vcp_n vdd 8.89922f
C241 pll_en a_6390_2036 0.03805f
C242 pll_en sf 0.09209f
C243 a_6394_0 a_7950_0 0.01441f
C244 dqb dqn 0.2408f
C245 dn_b t1c 0.07887f
C246 vdump vbn_vco 0.67606f
C247 vbh vcp_p 0.00423f
C248 pfd_up up_s 0.42282f
C249 pfd_dn a_15000_12030 0.01181f
C250 vcl en_b 0.0478f
C251 vnt vi 0.03911f
C252 vbt vs 0.03937f
C253 vco_out bias_ref 0.26657f
C254 vbp_vco up_b 0
C255 pll_en a_5270_2036 0.03683f
C256 vbl a_6000_12030 0
C257 pll_en r4 0.11728f
C258 a_13200_19482 dn_b 0.00319f
C259 pfd_dn vdump 0.07147f
C260 vnt bias_ref 0.09245f
C261 nb a_7950_0 0.02836f
C262 a_6390_2036 en_b 0.00139f
C263 pll_en vdump 0.34074f
C264 vdd r5 0.75365f
C265 dqb vdd 0.57298f
C266 t2 t1a 0.48898f
C267 up_b a_11400_12030 0
C268 t1c up_s 0.00229f
C269 vbn_vco r1 0.03796f
C270 cp_trim0 vdump 0
C271 vcp_n up_b 0.33729f
C272 vbn_vco vbp 0.08074f
C273 vbt vcl 0.11308f
C274 vfilt vctrl 6.27092f
C275 a_3034_0 a_4154_0 0.02242f
C276 vi vctrl 3.65471f
C277 vbl vbn_vco 0.20194f
C278 a_15000_12030 en_b 0
C279 a_5270_2036 en_b 0.00139f
C280 dn_b vdd 0.69775f
C281 a_6000_12030 a_4200_12030 0.00234f
C282 en_b r4 0.18491f
C283 t1a vfilt 0
C284 vbp_vco r5 0.02143f
C285 vbh vref 0.14046f
C286 va vnt 0.49711f
C287 a_8400_12030 vctrl 0
C288 va a_14400_19482 0
C289 vctrl bias_ref 0.11786f
C290 pfd_dn vbp 0.69024f
C291 vdump en_b 0.00187f
C292 a_10200_12030 up_s 0.00295f
C293 pll_en r1 0.259f
C294 a_7946_2036 bias_ref 0.002f
C295 vfilt vcp_p 0.17141f
C296 vbp_vco dn_b 0
C297 pll_en vbp 0.7002f
C298 pfd_up vbh 0.0087f
C299 vcp_p vi 0
C300 vcl vs 2.759f
C301 a_12000_19482 vref 0.00106f
C302 cp_trim0 vbp 0.08966f
C303 vdd a_3034_0 0
C304 dqb clkb 0
C305 ck a_19434_n100 0
C306 vcp_p a_8400_12030 0.00439f
C307 mf ck 0.17626f
C308 vcp_p bias_ref 0.06159f
C309 a_7950_0 r4 0.07352f
C310 vdd a_4150_2036 0.97689f
C311 vdd up_s 6.58045f
C312 t1a cp_trim1 1.08985f
C313 pfd_up a_12000_19482 0.01405f
C314 a_13800_12030 va 0.00822f
C315 r3 a_5274_0 0.07237f
C316 dn_s vctrl 0.67761f
C317 va vctrl 1.44134f
C318 a_6600_18162 vctrl 0.00648f
C319 up_b dn_b 0.23392f
C320 vbt vdump 4.98447f
C321 vcp_n dn_b 0.128f
C322 en_b r1 0.32206f
C323 en_b vbp 4.66802f
C324 s1 vco_out 0.00538f
C325 vbp_vco a_4150_2036 0.41367f
C326 t1a va 0.09992f
C327 t2 t1b 0.50193f
C328 vdd a_3030_2036 1.00205f
C329 a_6394_0 r4 0.01261f
C330 t1a dn_s 0.00468f
C331 t2 vref 0.56341f
C332 vbp_vco up_s 0
C333 vst vi 0.14015f
C334 vbn_vco vnt 0.03937f
C335 vdump a_7200_12030 0
C336 r3 a_4154_0 0.01385f
C337 a_6000_12030 vctrl 0.01456f
C338 pfd_up t2 0.23452f
C339 vcp_p dn_s 0.83394f
C340 va vcp_p 0.04587f
C341 vfilt vref 0.111f
C342 t1b vfilt 0.14717f
C343 vi vref 0.84329f
C344 pll_en vco_out 0.28488f
C345 m2 mf 0.35977f
C346 vbp_vco a_3030_2036 0.45398f
C347 pfd_dn a_14400_19482 0.00273f
C348 a_9070_n100 bias_ref 0.01945f
C349 vdump vs 0.04046f
C350 nb r4 0.00591f
C351 a_7950_0 r1 0
C352 pll_en vnt 0.00499f
C353 pfd_up vi 0
C354 a_11400_12030 up_s 0.01047f
C355 r2 vbn_vco 0.21171f
C356 pll_en a_14400_19482 0
C357 vref bias_ref 0.1592f
C358 up_b up_s 0.33583f
C359 vcp_n up_s 0.66639f
C360 vbt vbp 8.50563f
C361 vbt vbl 2.05293f
C362 vcp_p a_6000_12030 0.00439f
C363 a_13200_19482 a_12000_19482 0.00585f
C364 vbn_vco vctrl 0.53075f
C365 vdd r3 0.38394f
C366 pfd_up bias_ref 0.00772f
C367 t2 t1c 0.0696f
C368 vbh vdd 5.75774f
C369 a_6394_0 r1 0.11445f
C370 vco_out en_b 0.29669f
C371 t1b cp_trim1 2.28634f
C372 vref cp_trim1 0.01212f
C373 va vst 0.16091f
C374 pll_en r2 0.07323f
C375 a_13800_12030 pfd_dn 0.00352f
C376 pfd_dn vctrl 0.92261f
C377 vcl vdump 0.06857f
C378 a_12600_12030 vdump 0
C379 dqn ck 0.2334f
C380 a_5270_2036 a_6390_2036 0.09903f
C381 vs vbp 0.04866f
C382 vbp_vco r3 0.03332f
C383 en_b vnt 0
C384 a_13800_12030 pll_en 0.00804f
C385 a_6390_2036 r4 0.0033f
C386 en_b a_14400_19482 0.00958f
C387 vbp_vco vbh 0.10759f
C388 va vref 0.78902f
C389 va t1b 0.13556f
C390 pll_en vctrl 0.47728f
C391 pfd_up cp_trim1 0.14767f
C392 vcp_p vbn_vco 0
C393 dn_s vref 0.01204f
C394 a_6600_18162 vref 0.00948f
C395 dqn vco_div2 0.00542f
C396 t1a pfd_dn 0.36183f
C397 vbt a_4200_12030 0.00288f
C398 a_12000_19482 vdd 0.00249f
C399 pll_en a_7946_2036 0.03702f
C400 nb r1 0
C401 m1 vco_out 0.01504f
C402 pfd_up va 0.03769f
C403 pfd_dn vcp_p 0.21367f
C404 a_5270_2036 r4 0.24986f
C405 vco_out a_7950_0 0
C406 t1a cp_trim0 2.4752f
C407 r2 en_b 0.06225f
C408 dn_b up_s 0.06934f
C409 pll_en vcp_p 0.40346f
C410 s1 a_19434_n100 0.05093f
C411 vcl vbp 0.05166f
C412 t2 vdd 7.42248f
C413 m2 dqn 0
C414 mf s1 0.43955f
C415 up_b vbh 0.01683f
C416 a_13800_12030 en_b 0.01062f
C417 t1c cp_trim1 0.17106f
C418 en_b vctrl 0.31769f
C419 ck vdd 1.03623f
C420 a_8400_12030 a_10200_12030 0.00234f
C421 a_10200_12030 bias_ref 0.01425f
C422 vst vbn_vco 0.14041f
C423 a_7946_2036 en_b 0.00139f
C424 vdd vco_div2 0.39567f
C425 vfilt vdd 1.54943f
C426 vdd vi 0.25685f
C427 a_6390_2036 r1 0.25367f
C428 pll_en a_19434_n100 0.01495f
C429 vbn_vco vref 0.41594f
C430 pll_en mf 0.08586f
C431 pfd_dn vst 0
C432 vcp_p en_b 0.13105f
C433 vdd bias_ref 0.97344f
C434 vctrl a_7800_18162 0
C435 vs a_14400_19482 0.00168f
C436 a_13200_19482 va 0
C437 pll_en vst 0.24875f
C438 pfd_up vbn_vco 0.11988f
C439 vbp_vco vi 1.02453f
C440 nb vco_out 1.51394f
C441 a_5270_2036 r1 0.01216f
C442 pll_en a_9070_n100 0.09165f
C443 pfd_dn vref 0.55141f
C444 pfd_dn t1b 0.03173f
C445 a_7950_0 vctrl 0
C446 a_15000_12030 vbp 0.00908f
C447 r3 r5 0.00322f
C448 vbt vctrl 1.41992f
C449 r1 r4 0.3206f
C450 a_5270_2036 vbl 0
C451 m2 vdd 0.54694f
C452 clkb ck 1.86148f
C453 a_3030_2036 a_4150_2036 0.09903f
C454 pll_en vref 0.63299f
C455 pll_en t1b 0.0016f
C456 vcp_n t2 2.65097f
C457 t2 up_b 0.05572f
C458 vbt t1a 1.78734f
C459 vbp_vco bias_ref 0.05372f
C460 pfd_up pfd_dn 0.47839f
C461 clkb vco_div2 0
C462 vctrl a_7200_12030 0.00329f
C463 vdd cp_trim1 5.08152f
C464 vdump vbp 0
C465 cp_trim0 vref 0.28895f
C466 cp_trim0 t1b 2.27605f
C467 a_6394_0 vctrl 0.0342f
C468 vdump vbl 1.68883f
C469 pfd_up pll_en 1.84466f
C470 vref a_10800_19482 0.00106f
C471 vbn_vco a_5274_0 0.30737f
C472 vcp_n vfilt 0.64645f
C473 vbt vcp_p 2.61354f
C474 up_b vi 0
C475 vdd dn_s 0.00516f
C476 va vdd 3.56089f
C477 vcl a_14400_19482 0.00132f
C478 vst en_b 2.23306f
C479 vs vctrl 0.68186f
C480 pfd_up cp_trim0 0.02536f
C481 clkb bias_ref 0
C482 en_b a_9070_n100 0.00218f
C483 vcp_p a_7200_12030 0.00439f
C484 a_11400_12030 bias_ref 0.00104f
C485 up_b a_8400_12030 0.00454f
C486 t1a vs 0
C487 up_b bias_ref 0.67993f
C488 en_b vref 1.04558f
C489 t1b en_b 0.18362f
C490 vbn_vco a_4154_0 0.3124f
C491 m2 clkb 0.64549f
C492 s1 dqn 1.16744f
C493 mf m1 0.83048f
C494 vbp_vco va 0.03058f
C495 a_3034_0 r3 0.11453f
C496 pfd_dn t1c 0.0696f
C497 pll_en a_5274_0 0
C498 r3 a_4150_2036 0.00705f
C499 pfd_up en_b 0.17417f
C500 nb a_7946_2036 0.02328f
C501 vdump a_4200_12030 0.00235f
C502 vs vcp_p 0.12674f
C503 vbh up_s 0.01329f
C504 dqb ck 0.00113f
C505 up_b cp_trim1 0.50793f
C506 vcl vctrl 0.09988f
C507 pll_en dqn 0.33469f
C508 a_12600_12030 a_13800_12030 0.00585f
C509 vcp_n cp_trim1 1.88173f
C510 cp_trim0 t1c 1.84562f
C511 t2 dn_b 0.08681f
C512 a_7950_0 a_9070_n100 0.06219f
C513 pll_en a_4154_0 0
C514 r3 a_3030_2036 0.25117f
C515 dqb vco_div2 0.55309f
C516 a_13200_19482 pll_en 0
C517 t1a vcl 0
C518 up_b dn_s 0.18288f
C519 vbt vref 0.00828f
C520 vbt t1b 0.09995f
C521 vcp_n dn_s 2.57217f
C522 vcp_n va 0.12988f
C523 vbn_vco vdd 2.13262f
C524 a_12000_19482 up_s 0
C525 dn_b vi 0
C526 en_b a_5274_0 0.01502f
C527 s1 vdd 0.5526f
C528 vdump vnt 0.94832f
C529 a_6390_2036 vctrl 0.05595f
C530 r5 bias_ref 0.00651f
C531 vcl vcp_p 0.1141f
C532 a_12600_12030 vcp_p 0.00439f
C533 a_5270_2036 r2 0
C534 a_6390_2036 a_7946_2036 0.02632f
C535 vbl a_4200_12030 0
C536 r2 r4 0.00641f
C537 pfd_dn vdd 1.21292f
C538 vbp_vco vbn_vco 5.36929f
C539 dn_b bias_ref 0
C540 a_13800_12030 a_15000_12030 0.00585f
C541 en_b a_4154_0 0.01355f
C542 a_5270_2036 vctrl 0.05307f
C543 pll_en vdd 9.94968f
C544 t2 up_s 0.25835f
C545 a_1200_19662 vctrl 0.01597f
C546 t1b vs 0
C547 a_13200_19482 en_b 0
C548 vs vref 0.10886f
C549 vctrl r4 0.06992f
C550 vdump a_2000_12030 0.00517f
C551 a_7946_2036 r4 0.09942f
C552 vbp_vco pfd_dn 0.12139f
C553 nb a_9070_n100 0.31943f
C554 cp_trim0 vdd 6.61814f
C555 vfilt up_s 0.05371f
C556 pfd_up vs 0.10199f
C557 dn_b cp_trim1 0.66194f
C558 vdump vctrl 5.31426f
C559 vi up_s 0
C560 vnt vbp 0.00172f
C561 pll_en vbp_vco 1.26041f
C562 a_14400_19482 vbp 0.01393f
C563 vbl vnt 0.1714f
C564 s1 clkb 0.57292f
C565 up_b vbn_vco 0
C566 t1a vdump 0.0417f
C567 dn_b va 0.04507f
C568 dn_b dn_s 0.03228f
C569 a_6394_0 a_5274_0 0.06004f
C570 up_s bias_ref 0.34081f
C571 sf a_19434_n100 0
C572 en_b vdd 5.82785f
C573 vcl vref 5.1339f
C574 vcl t1b 0
C575 a_12600_12030 vref 0
C576 pll_en clkb 0.65905f
C577 pfd_dn up_b 0.15224f
C578 r2 r1 0.46234f
C579 vdump vcp_p 0.74818f
C580 vcp_n pfd_dn 1.18138f
C581 vbl a_2000_12030 0
C582 pll_en up_b 0.00411f
C583 pfd_up vcl 0.04913f
C584 vs t1c 0
C585 pll_en vcp_n 0.02966f
C586 a_12600_12030 pfd_up 0.006f
C587 vbp_vco en_b 0.42367f
C588 r1 vctrl 0.08911f
C589 a_13800_12030 vbp 0.00146f
C590 up_s cp_trim1 0.19872f
C591 vbp vctrl 0.1243f
C592 vbl vctrl 2.77609f
C593 m1 vdd 0.56978f
C594 a_7946_2036 r1 0.01161f
C595 cp_trim0 up_b 0.55981f
C596 vcp_n cp_trim0 0.94079f
C597 vdump a_400_12030 0
C598 t1a vbp 4.27593f
C599 vbn_vco r5 0.02255f
C600 up_s dn_s 0.00854f
C601 a_13200_19482 vs 0.00168f
C602 vdd a_7950_0 0
C603 vbt vdd 11.393f
C604 a_9070_n100 r4 0
C605 clkb en_b 0.34732f
C606 dqb s1 0.0125f
C607 vcp_p vbp 0.09297f
C608 vbl vcp_p 0.00118f
C609 dn_b vbn_vco 0
C610 vbh vi 0.09001f
C611 vcl t1c 0
C612 a_4200_12030 a_2000_12030 0.00234f
C613 vcp_n en_b 1.05507f
C614 vbt vbp_vco 0.00234f
C615 vdd a_6394_0 0
C616 pfd_up a_15000_12030 0
C617 a_4200_12030 vctrl 0
C618 pll_en r5 0.2284f
C619 vdump vref 0.05005f
C620 pll_en dqb 0.1032f
C621 pfd_dn dn_b 1.43336f
C622 vbh bias_ref 0.1458f
C623 vs vdd 0.47213f
C624 a_13200_19482 vcl 0.00132f
C625 m1 clkb 0.4232f
C626 vbl a_400_12030 0
C627 pfd_up vdump 0.60745f
C628 pll_en dn_b 3.26148f
C629 vbn_vco a_3034_0 0.30995f
C630 up_b a_7800_18162 0.00138f
C631 nb vdd 1.43755f
C632 dqn sf 0.66999f
C633 vbn_vco a_4150_2036 0.00819f
C634 vco_out a_7946_2036 0
C635 vbp_vco vs 0.32636f
C636 vcp_p a_4200_12030 0.01615f
C637 cp_trim0 dn_b 0.12208f
C638 vst vbp 0.7562f
C639 vbn_vco up_s 0
C640 vbt vcp_n 2.90941f
C641 vnt vctrl 0.71263f
C642 a_5274_0 r4 0.13493f
C643 en_b r5 0.43415f
C644 t2 vfilt 0.02118f
C645 vbp vref 0.9815f
C646 t1b vbp 3.35215f
C647 ck vco_div2 0
C648 vcl vdd 0.11934f
C649 vbl vref 0.02984f
C650 a_12600_12030 vdd 0.02873f
C651 vbn_vco a_3030_2036 0.07013f
C652 pfd_dn up_s 0.04124f
C653 a_4154_0 r4 0.01031f
C654 dn_b en_b 0.04659f
C655 pll_en a_4150_2036 0.03681f
C656 pll_en up_s 0.00314f
C657 pfd_up vbp 0.08887f
C658 a_2000_12030 vctrl 0
C659 up_b vs 0.05979f
C660 vcp_n vs 0.01347f
C661 a_6390_2036 vdd 1.07019f
C662 cp_trim0 up_s 0.07859f
C663 nb clkb 0.00195f
C664 vdd sf 0.2201f
C665 up_s a_10800_19482 0.00919f
C666 m2 ck 0.12665f
C667 a_7950_0 r5 0.13618f
C668 pll_en a_3030_2036 0.01853f
C669 vi bias_ref 0.05372f
C670 a_7946_2036 vctrl 0
C671 vdump a_10200_12030 0
C672 t2 cp_trim1 4.15236f
C673 r1 a_5274_0 0.0129f
C674 en_b a_3034_0 0
C675 a_15000_12030 vdd 0
C676 vbp_vco a_6390_2036 0.40557f
C677 a_5270_2036 vdd 0.97704f
C678 vcp_p a_2000_12030 0
C679 vdd r4 0.36951f
C680 en_b a_4150_2036 0
C681 vco_out a_9070_n100 0.01023f
C682 t1c vbp 0.00917f
C683 t2 va 0.12917f
C684 vbn_vco r3 0.1194f
C685 a_13800_12030 vcp_p 0.00277f
C686 a_6394_0 r5 0.07005f
C687 a_12600_12030 a_11400_12030 0.00585f
C688 vcp_p vctrl 0.49901f
C689 vfilt cp_trim1 0.04531f
C690 up_b vcl 0.05472f
C691 vcp_n vcl 0.05999f
C692 vbh vbn_vco 0.11461f
C693 vst vnt 0
C694 vdump vdd 4.69763f
C695 r1 a_4154_0 0.07128f
C696 vbp_vco a_5270_2036 0.4083f
C697 vbp_vco r4 0.01988f
C698 vfilt dn_s 0.05361f
C699 va vfilt 0.00802f
C700 clkb sf 0.18664f
C701 a_2000_12030 a_400_12030 0.00585f
C702 vnt vref 1.62716f
C703 va vi 0.0334f
C704 pll_en r3 0.11467f
C705 a_400_12030 vctrl 0.00176f
C706 dn_b vs 0.03757f
C707 vbp_vco vdump 0.09775f
C708 nb r5 0.59575f
C709 dn_s bias_ref 0.00202f
C710 va bias_ref 0.00875f
C711 vbt up_s 1.39825f
C712 vst vctrl 0.13997f
C713 vcp_n a_1200_19662 0.00456f
C714 vdd r1 0.45062f
C715 vdd vbp 46.2155f
C716 vbl vdd 1.94154f
C717 a_13800_12030 vref 0.00654f
C718 vref vctrl 0.59475f
C719 va cp_trim1 0.18078f
C720 vdump a_11400_12030 0
C721 up_b vdump 0.72384f
C722 vcl dn_b 0.04401f
C723 vcp_n vdump 0.28206f
C724 en_b r3 0.16562f
C725 s1 ck 2.06719f
C726 vbp_vco r1 0.02886f
C727 vs up_s 0.04908f
C728 t1a vref 0.00602f
C729 t1a t1b 0.19091f
C730 a_13800_12030 pfd_up 0
C731 a_12000_19482 a_10800_19482 0.00585f
C732 a_6390_2036 r5 0.10254f
C733 vbp_vco vbp 0.08159f
C734 pfd_up vctrl 0.15525f
C735 vbp_vco vbl 0.84564f
C736 vco_div2 vss 0.485771f
C737 bias_ref vss 4.50779f
C738 pll_en vss 3.34427f
C739 pfd_up vss 2.53092f
C740 pfd_dn vss 4.88083f
C741 cp_trim0 vss 1.2327f
C742 cp_trim1 vss 1.55462f
C743 vctrl vss 21.9944f
C744 vdd vss 850.696f
C745 a_19434_n100 vss 0.206834f
C747 a_7950_0 vss 0.404503f
C748 a_6394_0 vss 0.166474f
C749 a_5274_0 vss 0.324295f
C750 a_4154_0 vss 0.342516f
C751 a_3034_0 vss 0.208092f
C752 sf vss 0.854472f
C753 mf vss 0.68318f
C754 m2 vss 0.354401f
C755 dqn vss 0.62638f
C756 s1 vss 0.682556f
C757 clkb vss 1.40359f
C758 m1 vss 1.02947f
C759 ck vss 0.686695f
C760 vco_out vss 1.26279f
C761 dqb vss 0.404189f
C762 nb vss 0.478081f
C763 r4 vss 0.406357f
C764 r5 vss 0.615758f
C765 r3 vss 0.440337f
C766 r1 vss 0.506327f
C767 r2 vss 0.45943f
C768 a_7946_2036 vss 0.00921324f
C769 a_6390_2036 vss 0.00455646f
C770 a_5270_2036 vss 0.00457957f
C771 a_4150_2036 vss 0.00461333f
C772 a_3030_2036 vss 0.0147044f
C773 vi vss 1.12497f
C774 vnt vss 3.18322f
C775 vbn_vco vss 4.357f
C776 vst vss 1.9265f
C777 vbh vss 0.979777f
C778 vbl vss 3.37048f
C779 vbp_vco vss 1.86138f
C780 a_15000_12030 vss 0.66425f
C781 a_14400_19482 vss 0.71032f
C782 a_13800_12030 vss 0.65668f
C783 a_13200_19482 vss 0.70084f
C784 a_12600_12030 vss 0.65668f
C785 a_12000_19482 vss 0.71633f
C786 a_11400_12030 vss 0.69464f
C787 a_10800_19482 vss 0.70278f
C788 a_10200_12030 vss 0.6626f
C789 a_8400_12030 vss 0.6626f
C790 a_7800_18162 vss 0.66397f
C791 a_7200_12030 vss 0.65668f
C792 a_6600_18162 vss 0.66397f
C793 a_6000_12030 vss 0.6626f
C794 a_4200_12030 vss 0.66852f
C795 vs vss 4.18688f
C796 a_2000_12030 vss 1.06033f
C797 a_1200_19662 vss 1.15121f
C798 a_400_12030 vss 1.07671f
C799 vcl vss 5.32164f
C800 up_b vss 4.04067f
C801 en_b vss 3.89708f
C802 t1c vss 1.17649f
C803 vdump vss 2.18692f
C804 dn_b vss 1.49386f
C805 vref vss 12.4195f
C806 dn_s vss 1.54233f
C807 t1b vss 1.20842f
C808 va vss 0.688758f
C809 t1a vss 1.55028f
C810 t2 vss 0.827926f
C811 vcp_n vss 12.3835f
C812 vbt vss 0.307439f
C813 vbp vss 0.788919f
C814 up_s vss 2.39972f
C815 vcp_p vss 4.03884f
C816 vcp_p.t4 vss 1.33318f
C817 vcp_p.n0 vss 0.627233f
C818 vcp_p.t2 vss 1.33318f
C819 vcp_p.n1 vss 0.62849f
C820 vcp_p.n2 vss 0.533016f
C821 vcp_p.n3 vss 0.497332f
C822 vcp_p.n4 vss 0.132329f
C823 vcp_p.t5 vss 0.803683f
C824 vcp_p.t6 vss 0.807115f
C825 vcp_p.n5 vss 0.123825f
C826 vcp_p.n6 vss 0.39986f
C827 vcp_p.t0 vss 0.0714266f
C828 up_s.t2 vss 1.9581f
C829 up_s.t3 vss 1.94476f
C830 up_s.n0 vss 1.11982f
C831 up_s.t1 vss 0.147573f
C832 up_s.t0 vss 0.152279f
C833 up_s.n1 vss 0.871958f
C834 vbp.t4 vss 0.131832f
C835 vbp.t0 vss 0.0932332f
C836 vbp.n0 vss 0.105067f
C837 vbp.n1 vss 0.53344f
C838 vbp.n2 vss 0.285015f
C839 vbp.n3 vss 0.285015f
C840 vbp.n4 vss 0.277628f
C841 vbp.n5 vss 0.282497f
C842 vbp.t3 vss 0.100939f
C843 vbp.n6 vss 0.256406f
C844 vbp.n7 vss 0.204795f
C845 vbp.n8 vss 0.267993f
C846 vbp.n9 vss 0.28206f
C847 vbp.n10 vss 0.285015f
C848 vbp.n11 vss 0.277628f
C849 vbp.n12 vss 0.285015f
C850 vbp.n13 vss 0.540826f
C851 vbp.n14 vss 0.410667f
C852 vbp.t1 vss 0.0637336f
C853 vbp.n15 vss 0.670246f
C854 vbt.t3 vss 0.0700965f
C855 vbt.t0 vss 0.0710166f
C856 vbt.t4 vss 0.0852102f
C857 vbt.n0 vss 0.0526005f
C858 vbt.t5 vss 0.0852102f
C859 vbt.n1 vss 0.0307577f
C860 vbt.t1 vss 0.0691934f
C861 vbt.n2 vss 0.0292047f
C862 vbt.t2 vss 0.0691934f
C863 vbt.n3 vss 0.0292047f
C864 vbt.t6 vss 0.0852102f
C865 vbt.n4 vss 0.0307577f
C866 vbt.t7 vss 0.0852102f
C867 vbt.n5 vss 0.0251903f
C868 vbt.n6 vss 0.385336f
C869 vbt.t9 vss 0.262689f
C870 vbt.n7 vss 0.523213f
C871 vbt.t8 vss 0.259619f
C872 vbt.n8 vss 0.268779f
C873 vbt.t10 vss 0.259619f
C874 vbt.n9 vss 0.419996f
C875 vbt.t11 vss 0.279175f
C876 vcp_n.t11 vss 1.17961f
C877 vcp_n.n0 vss 0.61411f
C878 vcp_n.t9 vss 1.17961f
C879 vcp_n.n1 vss 0.621732f
C880 vcp_n.n2 vss 0.50342f
C881 vcp_n.n3 vss 0.454004f
C882 vcp_n.n4 vss 0.454004f
C883 vcp_n.n5 vss 0.432605f
C884 vcp_n.t0 vss 0.206739f
C885 vcp_n.n6 vss 0.156556f
C886 vcp_n.t2 vss 0.212103f
C887 vcp_n.n7 vss 0.168871f
C888 vcp_n.t1 vss 0.203719f
C889 vcp_n.n8 vss 0.392706f
C890 vcp_n.t3 vss 0.198336f
C891 vcp_n.n9 vss 0.368316f
C892 vcp_n.t7 vss 0.989199f
C893 vcp_n.t6 vss 0.955711f
C894 vcp_n.n10 vss 0.630362f
C895 vcp_n.t5 vss 0.955711f
C896 vcp_n.n11 vss 0.801529f
C897 vcp_n.t4 vss 0.989199f
C898 vcp_n.n12 vss 0.489836f
C899 vcp_n.n13 vss 0.0727351f
C900 t2.t1 vss 0.139663f
C901 t2.t2 vss 0.443919f
C902 t2.t3 vss 0.379801f
C903 t2.n0 vss 0.543123f
C904 t2.t0 vss 0.389063f
C905 t2.n1 vss 0.630655f
C906 t1a.t2 vss 0.214265f
C907 t1a.t0 vss 0.673058f
C908 t1a.t1 vss 0.543563f
C909 t1a.n0 vss 1.62767f
C910 va.t1 vss 1.20125f
C911 va.t0 vss 0.13386f
C912 va.n0 vss 0.0781316f
C913 va.t2 vss 0.0767822f
C914 va.n1 vss 1.28767f
C915 t1b.t0 vss 0.200383f
C916 t1b.t2 vss 0.561916f
C917 t1b.t1 vss 0.415311f
C918 t1b.n0 vss 1.25074f
C919 dn_s.t0 vss 1.06302f
C920 dn_s.t2 vss 1.05478f
C921 dn_s.n0 vss 0.188818f
C922 dn_s.t1 vss 0.201555f
C923 dn_s.n1 vss 0.377079f
C924 dn_s.t3 vss 0.26443f
C925 vref.t0 vss 0.508929f
C926 vref.n0 vss 0.58956f
C927 vref.n1 vss 0.334747f
C928 vref.n2 vss 0.310994f
C929 vref.n3 vss 0.33329f
C930 vref.n4 vss 0.226391f
C931 vref.n5 vss 0.320142f
C932 vref.n6 vss 0.74916f
C933 vref.t2 vss 0.231203f
C934 vref.n7 vss 0.612834f
C935 vref.n8 vss 0.875315f
C936 vref.n9 vss 0.478347f
C937 vref.n10 vss 0.919176f
C938 vref.t1 vss 0.407681f
C939 vref.n11 vss 2.15181f
C940 vref.n12 vss 0.1408f
C941 dn_b.t1 vss 0.148846f
C942 dn_b.t0 vss 0.183253f
C943 dn_b.n0 vss 1.38769f
C944 vdump.t3 vss 0.181278f
C945 vdump.t13 vss 0.15196f
C946 vdump.n0 vss 0.166979f
C947 vdump.t7 vss 0.15196f
C948 vdump.n1 vss 0.162797f
C949 vdump.n2 vss 0.185401f
C950 vdump.t17 vss 0.15196f
C951 vdump.n3 vss 0.162797f
C952 vdump.n4 vss 0.130689f
C953 vdump.t15 vss 0.15196f
C954 vdump.n5 vss 0.162797f
C955 vdump.n6 vss 0.0573191f
C956 vdump.t0 vss 0.284621f
C957 vdump.n7 vss 0.167531f
C958 vdump.t1 vss 0.284621f
C959 vdump.n8 vss 0.172844f
C960 vdump.t2 vss 0.0819301f
C961 vdump.n9 vss 0.0858026f
C962 vdump.t18 vss 0.692206f
C963 vdump.t9 vss 0.1508f
C964 vdump.n10 vss 0.160463f
C965 vdump.t11 vss 0.1508f
C966 vdump.n11 vss 0.15645f
C967 vdump.n12 vss 0.153877f
C968 vdump.t4 vss 0.174926f
C969 vdump.n13 vss 0.122981f
C970 vdump.t5 vss 0.177991f
C971 vdump.n14 vss 0.159855f
C972 vdump.n15 vss 1.09116f
C973 vdump.n16 vss 0.266753f
C974 t1c.t0 vss 0.326681f
C975 t1c.t1 vss 0.329642f
C976 en_b.t1 vss 0.180503f
C977 en_b.n0 vss 1.64993f
C978 en_b.t0 vss 0.971241f
C979 en_b.n1 vss 0.554091f
C980 en_b.n2 vss 0.31139f
C981 en_b.n3 vss 0.689473f
C982 en_b.n4 vss 0.816759f
C983 en_b.n5 vss 0.240546f
C984 en_b.n6 vss 0.385249f
C985 en_b.n7 vss 1.13247f
C986 en_b.n8 vss 0.63017f
C987 up_b.t1 vss 0.186624f
C988 up_b.t0 vss 1.33189f
C989 up_b.n0 vss 0.392678f
C990 vcl.t0 vss 0.74102f
C991 vcl.t1 vss 0.73393f
C992 vcl.n0 vss 0.248959f
C993 vcl.t3 vss 0.73393f
C994 vcl.n1 vss 0.271908f
C995 vcl.t2 vss 0.742972f
C996 vcl.n2 vss 0.344347f
C997 vcl.t4 vss 0.213377f
C998 vs.t1 vss 0.281023f
C999 vs.t0 vss 0.277731f
C1000 vs.n0 vss 1.95401f
C1001 vs.t2 vss 1.30281f
C1002 vbp_vco.t1 vss 0.215701f
C1003 vbp_vco.t0 vss 0.207194f
C1004 vbp_vco.n0 vss 0.211541f
C1005 vbp_vco.n1 vss 0.379308f
C1006 vbp_vco.t4 vss 0.123314f
C1007 vbp_vco.n2 vss 0.158371f
C1008 vbp_vco.n3 vss 0.207483f
C1009 vbp_vco.n4 vss 0.117788f
C1010 vbp_vco.t6 vss 0.123314f
C1011 vbp_vco.n5 vss 0.149842f
C1012 vbp_vco.n6 vss 0.157167f
C1013 vbp_vco.t2 vss 0.101371f
C1014 vbp_vco.n7 vss 0.111786f
C1015 vbp_vco.n8 vss 0.0774919f
C1016 vbp_vco.n9 vss 0.0770272f
C1017 vbp_vco.n10 vss 0.0572737f
C1018 vbp_vco.n11 vss 0.0770272f
C1019 vbp_vco.n12 vss 0.0620325f
C1020 vbp_vco.n13 vss 0.0770272f
C1021 vbp_vco.n14 vss 0.110757f
C1022 vbp_vco.n15 vss 0.0864169f
C1023 vbp_vco.n16 vss 0.391855f
C1024 vbl.t0 vss 0.315481f
C1025 vbl.t2 vss 0.286041f
C1026 vbl.n0 vss 0.346659f
C1027 vbl.t3 vss 0.286041f
C1028 vbl.n1 vss 0.165725f
C1029 vbl.t1 vss 0.295876f
C1030 vbl.n2 vss 0.328779f
C1031 vbl.t5 vss 0.15391f
C1032 vbl.n3 vss 0.272126f
C1033 vbl.n4 vss 0.209951f
C1034 vbl.n5 vss 0.401832f
C1035 vbl.t7 vss 0.15391f
C1036 vbl.n6 vss 0.275419f
C1037 vbl.n7 vss 0.318842f
C1038 vbh.t1 vss 0.165906f
C1039 vbh.t0 vss 0.18297f
C1040 vbh.t3 vss 0.170189f
C1041 vbh.n0 vss 0.183647f
C1042 vbh.n1 vss 0.111457f
C1043 vbh.n2 vss 0.200116f
C1044 vbh.t5 vss 0.170189f
C1045 vbh.n3 vss 0.185049f
C1046 vbh.n4 vss 0.233222f
C1047 vbh.n5 vss 0.227139f
C1048 vst.t0 vss 0.388216f
C1049 vst.t2 vss 0.396895f
C1050 vst.n0 vss 0.411992f
C1051 vst.t1 vss 0.15341f
C1052 vst.n1 vss 0.398297f
C1053 vst.t3 vss 0.860462f
C1054 vst.n2 vss 0.334497f
C1055 vbn_vco.t2 vss 0.356764f
C1056 vbn_vco.t3 vss 0.354068f
C1057 vbn_vco.n0 vss 0.395441f
C1058 vbn_vco.t1 vss 0.147458f
C1059 vbn_vco.n1 vss 0.230334f
C1060 vbn_vco.n2 vss 0.496486f
C1061 vbn_vco.t4 vss 0.139534f
C1062 vbn_vco.n3 vss 0.0838511f
C1063 vbn_vco.n4 vss 0.08375f
C1064 vbn_vco.n5 vss 0.0956916f
C1065 vbn_vco.n6 vss 0.08375f
C1066 vbn_vco.n7 vss 0.0973016f
C1067 vbn_vco.n8 vss 0.08375f
C1068 vbn_vco.n9 vss 0.173724f
C1069 vbn_vco.n10 vss 0.0984821f
C1070 vbn_vco.n11 vss 0.727243f
C1071 vbn_vco.n12 vss 0.359641f
C1072 vnt.t0 vss 0.244453f
C1073 vnt.t1 vss 0.251111f
C1074 vnt.t5 vss 0.33423f
C1075 vnt.n0 vss 0.177158f
C1076 vnt.t6 vss 0.33423f
C1077 vnt.n1 vss 0.103611f
C1078 vnt.t7 vss 0.256174f
C1079 vnt.n2 vss 0.219766f
C1080 vnt.t2 vss 0.256174f
C1081 vnt.n3 vss 0.206385f
C1082 vnt.t4 vss 0.256174f
C1083 vnt.n4 vss 0.329425f
C1084 vnt.t3 vss 0.269371f
C1085 vnt.n5 vss 0.260274f
C1086 vi.t2 vss 0.203701f
C1087 vi.t4 vss 0.274748f
C1088 vi.t1 vss 0.18491f
C1089 vi.n0 vss 0.240519f
C1090 vi.t0 vss 0.185108f
C1091 vi.n1 vss 0.0819357f
C1092 vi.t3 vss 0.195985f
C1093 vi.n2 vss 0.167522f
C1094 a_3030_2036.t3 vss 0.00925544f
C1095 a_3030_2036.n0 vss 0.0145843f
C1096 a_3030_2036.t2 vss 0.0168474f
C1097 a_3030_2036.t1 vss 0.0168698f
C1098 a_3030_2036.n1 vss 0.0235931f
C1099 a_3030_2036.n2 vss 0.0214579f
C1100 a_3030_2036.t4 vss 0.0239512f
C1101 a_3030_2036.n3 vss 0.0286357f
C1102 a_3030_2036.t0 vss 0.0101208f
C1103 a_4150_2036.t2 vss 0.0126432f
C1104 a_4150_2036.t4 vss 0.00880425f
C1105 a_4150_2036.t3 vss 0.00881633f
C1106 a_4150_2036.n0 vss 0.0122988f
C1107 a_4150_2036.n1 vss 0.0111858f
C1108 a_4150_2036.t1 vss 0.00498224f
C1109 a_4150_2036.n2 vss 0.0076026f
C1110 a_4150_2036.t0 vss 0.00505886f
C1111 a_4150_2036.n3 vss 0.0149271f
C1112 a_5270_2036.t2 vss 0.0126306f
C1113 a_5270_2036.t3 vss 0.00873891f
C1114 a_5270_2036.t4 vss 0.00875083f
C1115 a_5270_2036.n0 vss 0.0123626f
C1116 a_5270_2036.n1 vss 0.0112439f
C1117 a_5270_2036.t1 vss 0.00492998f
C1118 a_5270_2036.n2 vss 0.00764203f
C1119 a_5270_2036.t0 vss 0.00504951f
C1120 a_5270_2036.n3 vss 0.0150045f
C1121 a_6390_2036.t2 vss 0.0127118f
C1122 a_6390_2036.t4 vss 0.00869464f
C1123 a_6390_2036.t3 vss 0.00870647f
C1124 a_6390_2036.n0 vss 0.0123516f
C1125 a_6390_2036.n1 vss 0.0112337f
C1126 a_6390_2036.t1 vss 0.00501769f
C1127 a_6390_2036.n2 vss 0.00763524f
C1128 a_6390_2036.t0 vss 0.00503324f
C1129 a_6390_2036.n3 vss 0.0149915f
C1130 a_7946_2036.t2 vss 0.0182236f
C1131 a_7946_2036.t4 vss 0.0132286f
C1132 a_7946_2036.t3 vss 0.0132473f
C1133 a_7946_2036.n0 vss 0.0174075f
C1134 a_7946_2036.n1 vss 0.0158326f
C1135 a_7946_2036.t1 vss 0.00737964f
C1136 a_7946_2036.n2 vss 0.0107609f
C1137 a_7946_2036.t0 vss 0.0074052f
C1138 a_7946_2036.n3 vss 0.0211284f
C1139 r2.t0 vss 0.0408037f
C1140 r2.n0 vss 0.0947891f
C1141 r2.n1 vss 0.152926f
C1142 r2.n2 vss 0.0807836f
C1143 r2.n3 vss 0.0527267f
C1144 r2.n4 vss 0.113499f
C1145 r2.t2 vss 0.0230091f
C1146 r2.t3 vss 0.0230614f
C1147 r2.n5 vss 0.030803f
C1148 r2.t1 vss 0.0407579f
C1149 r1.t1 vss 0.0369985f
C1150 r1.n0 vss 0.0821931f
C1151 r1.n1 vss 0.139764f
C1152 r1.n2 vss 0.0693333f
C1153 r1.n3 vss 0.0512583f
C1154 r1.n4 vss 0.127736f
C1155 r1.t0 vss 0.0597938f
C1156 r1.n5 vss 0.171898f
C1157 r1.t3 vss 0.0208467f
C1158 r1.t4 vss 0.0208947f
C1159 r1.n6 vss 0.0310367f
C1160 r1.t2 vss 0.0370409f
C1161 r3.t1 vss 0.0361371f
C1162 r3.n0 vss 0.0863867f
C1163 r3.n1 vss 0.151126f
C1164 r3.n2 vss 0.0732247f
C1165 r3.n3 vss 0.0507147f
C1166 r3.n4 vss 0.114074f
C1167 r3.t0 vss 0.020249f
C1168 r3.t3 vss 0.0202929f
C1169 r3.n5 vss 0.030179f
C1170 r3.t2 vss 0.036099f
C1171 r5.t0 vss 0.0408005f
C1172 r5.n0 vss 0.0960098f
C1173 r5.n1 vss 0.156604f
C1174 r5.n2 vss 0.0813839f
C1175 r5.n3 vss 0.0563663f
C1176 r5.n4 vss 0.13288f
C1177 r5.n5 vss 0.0739205f
C1178 r5.n6 vss 0.0601198f
C1179 r5.n7 vss 0.124967f
C1180 r5.n8 vss 0.085156f
C1181 r5.t1 vss 0.0228989f
C1182 r5.t2 vss 0.0229486f
C1183 r5.n9 vss 0.0335419f
C1184 r5.t3 vss 0.040754f
C1185 r4.t0 vss 0.0341338f
C1186 r4.n0 vss 0.083265f
C1187 r4.n1 vss 0.142805f
C1188 r4.n2 vss 0.0709643f
C1189 r4.n3 vss 0.0463177f
C1190 r4.n4 vss 0.108172f
C1191 r4.t3 vss 0.0191498f
C1192 r4.t2 vss 0.0191923f
C1193 r4.n5 vss 0.0270563f
C1194 r4.t1 vss 0.0340966f
C1195 nb.t1 vss 0.0223855f
C1196 nb.n0 vss 0.097325f
C1197 nb.n1 vss 0.290445f
C1198 nb.t5 vss 0.0206196f
C1199 nb.t4 vss 0.0206611f
C1200 nb.n2 vss 0.0627365f
C1201 nb.t2 vss 0.0205573f
C1202 nb.t3 vss 0.0205988f
C1203 nb.n3 vss 0.0236788f
C1204 nb.n4 vss 0.0467187f
C1205 nb.n5 vss 0.0368062f
C1206 nb.n6 vss 0.174926f
C1207 nb.n7 vss 0.154016f
C1208 nb.n8 vss 0.0876125f
C1209 nb.n9 vss 0.213626f
C1210 nb.t0 vss 0.0223362f
C1211 dqb.t1 vss 0.103613f
C1212 dqb.n0 vss 0.147791f
C1213 dqb.n1 vss 0.0733076f
C1214 dqb.n2 vss 0.0478469f
C1215 dqb.n3 vss 0.0985522f
C1216 dqb.t0 vss 0.0421548f
C1217 vco_out.t1 vss 0.0309722f
C1218 vco_out.n0 vss 0.103569f
C1219 vco_out.t7 vss 0.0308882f
C1220 vco_out.t6 vss 0.0309264f
C1221 vco_out.n1 vss 0.0610316f
C1222 vco_out.n2 vss 0.338296f
C1223 vco_out.t5 vss 0.0309378f
C1224 vco_out.t4 vss 0.0309722f
C1225 vco_out.n3 vss 0.164971f
C1226 vco_out.n4 vss 0.25311f
C1227 vco_out.n5 vss 0.242553f
C1228 vco_out.n6 vss 0.0490307f
C1229 vco_out.t3 vss 0.028627f
C1230 vco_out.n7 vss 0.46401f
C1231 vco_out.t0 vss 0.0952503f
C1232 vco_out.t2 vss 0.0309378f
C1233 ck.t0 vss 0.0716333f
C1234 ck.t1 vss 0.0468371f
C1235 ck.n0 vss 0.316497f
C1236 ck.n1 vss 0.215599f
C1237 ck.n2 vss 0.619683f
C1238 ck.n3 vss 0.311076f
C1239 m1.t3 vss 0.184547f
C1240 m1.t1 vss 0.0764967f
C1241 m1.n0 vss 0.211937f
C1242 m1.n1 vss 0.189269f
C1243 m1.n2 vss 0.0596135f
C1244 m1.t2 vss 0.0597639f
C1245 m1.n3 vss 0.236078f
C1246 m1.t0 vss 0.112347f
C1247 m1.n4 vss 0.147622f
C1248 clkb.t1 vss 0.0565897f
C1249 clkb.n0 vss 0.222419f
C1250 clkb.n1 vss 0.234142f
C1251 clkb.n2 vss 0.165235f
C1252 clkb.n3 vss 0.387053f
C1253 clkb.n4 vss 0.234473f
C1254 clkb.n5 vss 0.604307f
C1255 clkb.t0 vss 0.0315875f
C1256 s1.t2 vss 0.130492f
C1257 s1.t3 vss 0.0666464f
C1258 s1.n0 vss 0.169085f
C1259 s1.t4 vss 0.135867f
C1260 s1.n1 vss 0.273967f
C1261 s1.t5 vss 0.0669401f
C1262 s1.n2 vss 0.161105f
C1263 s1.n3 vss 0.0588192f
C1264 s1.n4 vss 0.16149f
C1265 s1.t0 vss 0.057988f
C1266 s1.n5 vss 0.206243f
C1267 s1.t1 vss 0.105677f
C1268 s1.n6 vss 0.113505f
C1269 dqn.t1 vss 0.0859771f
C1270 dqn.n0 vss 0.162367f
C1271 dqn.t0 vss 0.0792488f
C1272 dqn.n1 vss 0.15643f
C1273 dqn.n2 vss 0.0471134f
C1274 dqn.n3 vss 0.186779f
C1275 dqn.n4 vss 0.122689f
C1276 dqn.t2 vss 0.100235f
C1277 m2.t1 vss 0.108505f
C1278 m2.t2 vss 0.0690201f
C1279 m2.n0 vss 0.156962f
C1280 m2.n1 vss 0.130549f
C1281 m2.n2 vss 0.0475691f
C1282 m2.t3 vss 0.0740346f
C1283 m2.t0 vss 0.036365f
C1284 m2.n3 vss 0.134485f
C1285 mf.t0 vss 0.0526708f
C1286 mf.n0 vss 0.156264f
C1287 mf.t3 vss 0.0581572f
C1288 mf.n1 vss 0.18024f
C1289 mf.t2 vss 0.0980372f
C1290 mf.n2 vss 0.0171498f
C1291 mf.t1 vss 0.0277509f
C1292 sf.t1 vss 0.154999f
C1293 sf.t0 vss 0.0793329f
C1294 sf.n0 vss 0.184616f
C1295 sf.n1 vss 0.136679f
C1296 sf.t2 vss 0.0605106f
C1297 sf.t3 vss 0.0292808f
C1298 sf.n2 vss 0.16163f
C1299 a_3034_0.t0 vss 0.0243157f
C1300 a_3034_0.n0 vss 0.0207688f
C1301 a_3034_0.t3 vss 0.0451365f
C1302 a_3034_0.t2 vss 0.0386513f
C1303 a_3034_0.t1 vss 0.0387834f
C1304 a_3034_0.n1 vss 0.0285391f
C1305 a_3034_0.n2 vss 0.103852f
C1306 a_4154_0.t0 vss 0.0424032f
C1307 a_4154_0.n0 vss 0.0288618f
C1308 a_4154_0.t4 vss 0.0425414f
C1309 a_4154_0.t2 vss 0.0479677f
C1310 a_4154_0.n1 vss 0.0854752f
C1311 a_4154_0.t3 vss 0.0273681f
C1312 a_4154_0.n2 vss 0.0210054f
C1313 a_4154_0.n3 vss 0.0771863f
C1314 a_4154_0.t1 vss 0.042256f
C1315 a_5274_0.t0 vss 0.0413521f
C1316 a_5274_0.n0 vss 0.0307254f
C1317 a_5274_0.t4 vss 0.0374221f
C1318 a_5274_0.t2 vss 0.0488399f
C1319 a_5274_0.n1 vss 0.0910045f
C1320 a_5274_0.t3 vss 0.0269195f
C1321 a_5274_0.n2 vss 0.0223609f
C1322 a_5274_0.n3 vss 0.0821739f
C1323 a_5274_0.t1 vss 0.0414932f
C1324 a_6394_0.t0 vss 0.0352117f
C1325 a_6394_0.n0 vss 0.0277064f
C1326 a_6394_0.t2 vss 0.0440316f
C1327 a_6394_0.t3 vss 0.0238162f
C1328 a_6394_0.n1 vss 0.0201654f
C1329 a_6394_0.n2 vss 0.100823f
C1330 a_6394_0.t1 vss 0.0350939f
C1331 a_7950_0.t0 vss 0.0456466f
C1332 a_7950_0.n0 vss 0.0263115f
C1333 a_7950_0.t4 vss 0.0400258f
C1334 a_7950_0.t2 vss 0.0476675f
C1335 a_7950_0.n1 vss 0.0779364f
C1336 a_7950_0.t3 vss 0.0288736f
C1337 a_7950_0.n2 vss 0.0191514f
C1338 a_7950_0.n3 vss 0.0703741f
C1339 a_7950_0.t1 vss 0.0454827f
C1340 a_19434_n100.t0 vss 0.0641145f
C1341 vss.t193 vss 0.23904f
C1342 vss.t108 vss 0.36224f
C1343 vss.t106 vss 0.36224f
C1344 vss.t175 vss 0.23904f
C1345 vss.t152 vss 0.35558f
C1346 vss.t167 vss 0.34441f
C1347 vss.t44 vss 0.34441f
C1348 vss.t87 vss 0.34441f
C1349 vss.t60 vss 0.34441f
C1350 vss.t48 vss 0.34441f
C1351 vss.t78 vss 0.26763f
C1352 vss.t52 vss 0.26763f
C1353 vss.t191 vss 0.56403f
C1354 vss.t75 vss 0.11066f
C1355 vss.t73 vss 0.11066f
C1356 vss.t100 vss 0.11066f
C1357 vss.t39 vss 0.12877f
C1358 vss.t185 vss 0.1321f
C1359 vss.t8 vss 27.075f
C1360 vss.t134 vss 0.11753p
C1361 vss.t155 vss 1.60492f
C1362 vss.t104 vss 1.77861f
C1363 vss.t1 vss 1.77861f
C1364 vss.t165 vss 1.77861f
C1365 vss.t36 vss 1.77861f
C1366 vss.t149 vss 1.60492f
C1367 vss.t26 vss 0.80587f
C1368 vss.t64 vss 0.1031f
C1369 vss.t195 vss 0.19924f
C1370 vss.t16 vss 2.45041f
C1371 vss.t102 vss 0.54169f
C1372 vss.t113 vss 0.54169f
C1373 vss.t162 vss 0.54169f
C1374 vss.t160 vss 0.54599f
C1375 vss.t169 vss 0.0276f
C1376 vss.t92 vss 0.02749f
C1377 vss.t111 vss 0.03632f
C1378 vss.t201 vss 0.2123f
C1379 vss.t200 vss 0.2123f
C1380 vss.t42 vss 0.36392f
C1381 vss.t41 vss 0.36392f
C1382 vss.t206 vss 0.02946f
C1383 vss.t20 vss 0.06838f
C1384 vss.t96 vss 0.03093f
C1385 vss.t90 vss 0.03022f
C1386 vss.t198 vss 0.26993f
C1387 vss.t197 vss 0.26993f
C1388 vss.t188 vss 0.28235f
C1389 vss.t187 vss 0.28235f
C1390 vss.t210 vss 0.07518f
C1391 vss.t209 vss 0.07518f
C1392 vss.t94 vss 0.01792f
C1393 vss.t181 vss 0.04478f
C1394 vss.t183 vss 0.04469f
C1395 vss.t24 vss 0.05778f
C1396 vss.t22 vss 0.0576f
C1397 vss.t173 vss 0.06122f
C1398 vss.t34 vss 0.0776f
C1399 vss.t50 vss 0.07728f
C1400 vss.t28 vss 0.0776f
C1401 vss.t30 vss 0.07728f
C1402 vss.t179 vss 0.06122f
C1403 vss.t32 vss 0.0776f
C1404 vss.t3 vss 0.07728f
C1405 vss.t147 vss 0.07172f
C1406 vss.t5 vss 0.0776f
C1407 vss.t7 vss 0.07728f
C1408 vss.t54 vss 0.0776f
C1409 vss.t56 vss 0.07728f
C1410 vdd.t12 vss 0.128182f
C1411 vdd.n0 vss 0.339747f
C1412 vdd.n1 vss 0.357152f
C1413 vdd.n2 vss 0.333697f
C1414 vdd.t64 vss 0.440373f
C1415 vdd.n3 vss 0.144579f
C1416 vdd.t54 vss 0.527249f
C1417 vdd.n4 vss 0.184212f
C1418 vdd.t56 vss 0.527249f
C1419 vdd.n5 vss 0.186738f
C1420 vdd.n6 vss 0.162552f
C1421 vdd.t74 vss 0.440373f
C1422 vdd.n7 vss 0.144579f
C1423 vdd.t27 vss 0.093032f
C1424 vdd.n8 vss 0.253408f
C1425 vdd.t5 vss 0.0938522f
C1426 vdd.n9 vss 0.232495f
C1427 vdd.n10 vss 0.0941202f
C1428 vdd.n11 vss 0.951809f
C1429 vdd.n12 vss 1.12609f
C1430 vdd.n13 vss 0.0724602f
C1431 vdd.n14 vss 2.73255f
C1432 vdd.n15 vss 0.0319419f
C1433 vdd.n16 vss 0.0184358f
C1434 vdd.n17 vss 0.030074f
C1435 vdd.n18 vss 0.030074f
C1436 vdd.n19 vss 0.0273695f
C1437 vdd.n20 vss 0.0734023f
C1438 vdd.n21 vss 0.0839602f
C1439 vdd.n22 vss 0.111403f
C1440 vdd.n23 vss 0.0940309f
C1441 vdd.n24 vss 4.98149f
C1442 vdd.t20 vss 2.43063f
C1443 vdd.t6 vss 0.60969f
C1444 vdd.t34 vss 9.2673f
C1445 vdd.t29 vss 6.25949f
C1446 vdd.t22 vss 0.812923f
C1447 vdd.n25 vss 0.120393f
C1448 vdd.t36 vss 0.190108f
C1449 vdd.n26 vss 0.0756357f
C1450 vdd.t35 vss 0.190393f
C1451 vdd.n27 vss 0.0683344f
C1452 vdd.t8 vss 0.0672786f
C1453 vdd.n28 vss 0.0942745f
C1454 vdd.t98 vss 0.190108f
C1455 vdd.n29 vss 0.0565907f
C1456 vdd.t97 vss 0.190393f
C1457 vdd.n30 vss 0.0671893f
C1458 vdd.t17 vss 0.0619834f
C1459 vdd.n31 vss 0.0942745f
C1460 vdd.t96 vss 0.190108f
C1461 vdd.n32 vss 0.0799726f
C1462 vdd.t115 vss 0.190393f
C1463 vdd.n33 vss 0.0588729f
C1464 vdd.t7 vss 0.0619834f
C1465 vdd.n34 vss 0.0927152f
C1466 vdd.t114 vss 0.190108f
C1467 vdd.n35 vss 0.0799726f
C1468 vdd.t113 vss 0.190393f
C1469 vdd.n36 vss 0.0683344f
C1470 vdd.t18 vss 0.0619834f
C1471 vdd.n37 vss 0.0871032f
C1472 vdd.t21 vss 0.0500691f
C1473 vdd.n38 vss 0.0930644f
C1474 vdd.t70 vss 0.190108f
C1475 vdd.n39 vss 0.0799726f
C1476 vdd.t69 vss 0.190393f
C1477 vdd.n40 vss 0.0683344f
C1478 vdd.t19 vss 0.0619834f
C1479 vdd.n41 vss 0.0893935f
C1480 vdd.t93 vss 0.0739626f
C1481 vdd.n42 vss 0.0794853f
C1482 vdd.t50 vss 0.0741007f
C1483 vdd.n43 vss 0.085617f
C1484 vdd.t23 vss 0.0793391f
C1485 vdd.n44 vss 0.085617f
C1486 vdd.t24 vss 0.0794853f
C1487 vdd.n45 vss 0.085617f
C1488 vdd.t60 vss 0.0819786f
C1489 vdd.n46 vss 0.0784295f
C1490 vdd.t59 vss 0.0820598f
C1491 vdd.n47 vss 0.0657599f
C1492 vdd.t106 vss 0.0819786f
C1493 vdd.n48 vss 0.0820679f
C1494 vdd.t105 vss 0.0820598f
C1495 vdd.n49 vss 0.0820679f
C1496 vdd.t52 vss 0.0373508f
C1497 vdd.n50 vss 0.0942745f
C1498 vdd.t62 vss 0.0773656f
C1499 vdd.n51 vss 0.0966623f
C1500 vdd.t61 vss 0.0773656f
C1501 vdd.n52 vss 0.0754651f
C1502 vdd.t109 vss 0.0701293f
C1503 vdd.n53 vss 0.176245f
C1504 vdd.t30 vss 0.0454155f
C1505 vdd.n54 vss 0.183571f
C1506 vdd.t25 vss 0.0537238f
C1507 vdd.n55 vss 0.186056f
C1508 vdd.t49 vss 0.0794609f
C1509 vdd.n56 vss 0.0999515f
C1510 vdd.t108 vss 0.0499067f
C1511 vdd.n57 vss 0.173435f
C1512 vdd.t107 vss 0.0765047f
C1513 vdd.n58 vss 0.197629f
C1514 vdd.t31 vss 0.0815156f
C1515 vdd.n59 vss 0.0750022f
C1516 vdd.t82 vss 0.083944f
C1517 vdd.t42 vss 0.089694f
C1518 vdd.n60 vss 0.1262f
C1519 vdd.t10 vss 0.0857388f
C1520 vdd.n61 vss 0.141794f
C1521 vdd.t16 vss 0.0857388f
C1522 vdd.n62 vss 0.140315f
C1523 vdd.n63 vss 0.137018f
C1524 vdd.t121 vss 1.44879f
C1525 vdd.n64 vss 0.275482f
C1526 vdd.t81 vss 0.212118f
C1527 vdd.n65 vss 0.279859f
C1528 vdd.n66 vss 0.140283f
C1529 vdd.t78 vss 0.234817f
C1530 vdd.n67 vss 0.120442f
C1531 vdd.t76 vss 0.234817f
C1532 vdd.n68 vss 0.13632f
C1533 vdd.t104 vss 0.212118f
C1534 vdd.n69 vss 0.133355f
C1535 vdd.t14 vss 0.186884f
C1536 vdd.n70 vss 0.56261f
C1537 vdd.n71 vss 0.307895f
C1538 vdd.n72 vss 0.333567f
C1539 vdd.n73 vss 0.359255f
C1540 vdd.n74 vss 0.270909f
C1541 vdd.n75 vss 0.520516f
C1542 vdd.n76 vss 0.282215f
C1543 vdd.t0 vss 0.34129f
C1544 vdd.t1 vss 0.326136f
C1545 vdd.t2 vss 0.326136f
C1546 vdd.t3 vss 0.326136f
C1547 vdd.t4 vss 0.276318f
C1548 vdd.t9 vss 0.285561f
C1549 vdd.t15 vss 0.285561f
C1550 vdd.t11 vss 0.270666f
C1551 vdd.t13 vss 0.291903f
C1552 vdd.t26 vss 0.335378f
C1553 vdd.t28 vss 0.30251f
C1554 vdd.t41 vss 0.270666f
C1555 vdd.t51 vss 0.30251f
C1556 vdd.t53 vss 0.462236f
C1557 vdd.t55 vss 0.403176f
C1558 vdd.t63 vss 0.403176f
C1559 vdd.t73 vss 0.359003f
C1560 vdd.t75 vss 0.308155f
C1561 vdd.t77 vss 0.287615f
C1562 vdd.t79 vss 0.359515f
C1563 vdd.t80 vss 0.531569f
C1564 vdd.t83 vss 0.359515f
C1565 vdd.t84 vss 0.359515f
C1566 vdd.t103 vss 0.30251f
C1567 vdd.t110 vss 0.359515f
C1568 vdd.t120 vss 0.775532f
C1569 vdd.n77 vss 0.0437912f
C1570 vdd.n78 vss 3.2282f
C1571 vdd.n79 vss 1.48643f
C1572 vdd.t92 vss 2.77642f
C1573 vdd.n80 vss 2.74294f
C1574 vdd.t46 vss 2.89211f
C1575 vdd.n81 vss 0.288939f
C1576 vdd.n82 vss 0.394681f
C1577 vdd.t123 vss 2.89211f
C1578 vdd.n83 vss 0.218582f
C1579 vdd.t86 vss 2.77642f
C1580 vdd.n84 vss 0.288939f
C1581 vdd.n85 vss 0.393203f
C1582 vdd.t102 vss 1.27604f
C1583 vdd.n86 vss 0.292521f
C1584 vdd.t112 vss 1.24392f
C1585 vdd.n87 vss 0.330676f
C1586 vdd.t66 vss 1.24392f
C1587 vdd.n88 vss 0.331707f
C1588 vdd.n89 vss 0.363511f
C1589 vdd.t90 vss 1.24392f
C1590 vdd.n90 vss 0.292521f
C1591 vdd.t48 vss 1.24392f
C1592 vdd.n91 vss 0.330676f
C1593 vdd.t33 vss 1.24392f
C1594 vdd.n92 vss 0.331707f
C1595 vdd.n93 vss 0.363511f
C1596 vdd.t100 vss 0.704517f
C1597 vdd.n94 vss 0.26239f
C1598 vdd.t58 vss 1.24392f
C1599 vdd.n95 vss 0.292521f
C1600 vdd.t95 vss 1.24392f
C1601 vdd.n96 vss 0.333193f
C1602 vdd.n97 vss 0.363511f
C1603 vdd.t88 vss 1.24392f
C1604 vdd.n98 vss 0.292521f
C1605 vdd.t72 vss 1.24392f
C1606 vdd.n99 vss 0.330676f
C1607 vdd.t117 vss 1.24392f
C1608 vdd.n100 vss 0.331707f
C1609 vdd.n101 vss 0.363511f
C1610 vdd.t68 vss 1.24392f
C1611 vdd.n102 vss 0.292521f
C1612 vdd.t119 vss 1.27604f
C1613 vdd.n103 vss 0.330676f
C1614 vdd.t44 vss 1.47709f
C1615 vdd.n104 vss 0.357647f
C1616 vdd.t38 vss 0.400204f
C1617 vdd.n105 vss 0.334639f
C1618 vdd.n106 vss 0.337985f
C1619 vdd.t40 vss 0.42495f
C1620 vdd.n107 vss 2.06039f
C1621 vdd.n108 vss 3.43387f
C1622 vdd.n109 vss 3.04852f
C1623 vdd.n110 vss 2.66317f
C1624 vdd.n111 vss 2.66317f
C1625 vdd.n112 vss 2.66317f
C1626 vdd.n113 vss 2.66317f
C1627 vdd.n114 vss 2.00039f
C1628 vdd.t32 vss 3.02496f
C1629 vdd.t37 vss 2.03077f
C1630 vdd.t39 vss 2.7818f
C1631 vdd.t43 vss 2.47391f
C1632 vdd.t45 vss 4.18099f
C1633 vdd.t47 vss 3.4681f
C1634 vdd.t57 vss 3.4681f
C1635 vdd.t65 vss 3.02496f
C1636 vdd.t67 vss 3.02496f
C1637 vdd.t71 vss 3.4681f
C1638 vdd.t85 vss 4.18099f
C1639 vdd.t87 vss 3.02496f
C1640 vdd.t89 vss 3.02496f
C1641 vdd.t91 vss 4.95493f
C1642 vdd.t94 vss 3.02496f
C1643 vdd.t99 vss 3.02496f
C1644 vdd.t101 vss 3.02496f
C1645 vdd.t111 vss 3.4681f
C1646 vdd.t116 vss 3.02496f
C1647 vdd.t118 vss 3.13671f
C1648 vdd.t122 vss 4.18099f
C1649 vdd.n115 vss 2.0227f
C1650 vctrl.n0 vss 0.238827f
C1651 vctrl.n1 vss 0.133247f
C1652 vctrl.n2 vss 0.285012f
C1653 vctrl.t1 vss 0.263391f
C1654 vctrl.n3 vss 0.0445727f
C1655 vctrl.n4 vss 0.279414f
C1656 vctrl.t0 vss 0.354475f
C1657 vctrl.n5 vss 3.04635f
C1658 vctrl.t2 vss 0.130144f
C1659 vctrl.n6 vss 0.516515f
C1660 vctrl.n7 vss 0.279688f
C1661 vctrl.n8 vss 0.474216f
C1662 vctrl.n9 vss 0.387238f
C1663 vctrl.n10 vss 0.354384f
C1664 cp_trim1.n0 vss 0.867805f
C1665 cp_trim1.n1 vss 2.41276f
C1666 cp_trim0.n0 vss 1.12671f
C1667 cp_trim0.n1 vss 0.9594f
C1668 cp_trim0.n2 vss 1.81634f
C1669 pfd_dn.n0 vss 1.84607f
C1670 pfd_dn.n1 vss 2.19362f
C1671 pfd_up.n0 vss 0.90458f
C1672 pfd_up.n1 vss 2.00462f
C1673 pll_en.n0 vss 0.188946f
C1674 pll_en.n1 vss 0.48072f
C1675 pll_en.n2 vss 0.542137f
C1676 pll_en.n3 vss 0.22136f
C1677 pll_en.n4 vss 0.222867f
C1678 pll_en.n5 vss 0.961152f
C1679 pll_en.n6 vss 0.300202f
C1680 pll_en.n7 vss 1.827f
C1681 pll_en.n8 vss 0.920649f
C1682 pll_en.n9 vss 0.889672f
C1683 pll_en.n10 vss 0.0638643f
C1684 pll_en.n11 vss 0.0785472f
C1685 pll_en.n12 vss 0.119712f
C1686 pll_en.n13 vss 0.223528f
C1687 pll_en.n14 vss 0.137891f
C1688 pll_en.n15 vss 0.110471f
C1689 pll_en.n16 vss 0.113831f
C1690 pll_en.n17 vss 0.141444f
C1691 pll_en.n18 vss 0.23714f
C1692 bias_ref.t1 vss 0.0830722f
C1693 bias_ref.t0 vss 0.0426701f
C1694 bias_ref.n0 vss 1.30268f
C1695 vco_div2.t0 vss 0.0350824f
C1696 vco_div2.t2 vss 0.0351238f
C1697 vco_div2.n0 vss 0.112323f
C1698 vco_div2.t1 vss 0.0200135f
C1699 vco_div2.t3 vss 0.0200642f
C1700 vco_div2.n1 vss 0.0326929f
C1701 vco_div2.n2 vss 0.261539f
Cnode0 a_9070_n100 vss 1.01557f
Cnode1 vfilt vss 117.526f
Crb1_X0 vctrl.t2 vss.t170 2.81801f
Crb2_X0 a_400_12030 vss.t170 2.81801f
Crb1_X9 vs.t2 vss.t157 1.37733f
Crb2_X9 a_4200_12030 vss.t157 1.37733f
Crb1_X10 a_13200_19482 vss.t67 2.34466f
Crb2_X10 a_12600_12030 vss.t67 2.34466f
Crb1_X22 bias_ref.t0 vss.t97 2.34466f
Crb2_X22 a_10200_12030 vss.t97 2.34466f
Crb1_X24 a_1200_19662 vss.t203 2.81801f
Crb2_X24 a_400_12030 vss.t203 2.81801f
Crb1_X25 bias_ref.t1 vss.t153 1.92185f
Crb2_X25 a_8400_12030 vss.t153 1.92185f
Crb1_X39 a_14400_19482 vss.t14 2.34466f
Crb2_X39 a_15000_12030 vss.t14 2.34466f
Crb1_X42 vref.t1 vss.t84 1.92185f
Crb2_X42 a_6000_12030 vss.t84 1.92185f
Crb1_X52 a_12000_19482 vss.t98 2.34466f
Crb2_X52 a_11400_12030 vss.t98 2.34466f
Crb1_X58 a_1200_19662 vss.t189 2.81801f
Crb2_X58 a_2000_12030 vss.t189 2.81801f
Crb1_X95 a_7800_18162 vss.t57 1.92185f
Crb2_X95 a_7200_12030 vss.t57 1.92185f
Crb1_X106 vcl.t4 vss.t176 1.37733f
Crb2_X106 a_4200_12030 vss.t176 1.37733f
Crb1_X107 a_13200_19482 vss.t80 2.34466f
Crb2_X107 a_13800_12030 vss.t80 2.34466f
Crb1_X118 vfilt vss.t202 2.81801f
Crb2_X118 a_2000_12030 vss.t202 2.81801f
Crb1_X122 a_10800_19482 vss.t177 2.34466f
Crb2_X122 a_10200_12030 vss.t177 2.34466f
Crb1_X140 vss.t69 vss.t68 2.34466f
Crb2_X140 a_15000_12030 vss.t68 2.34466f
Crb1_X141 a_6600_18162 vss.t85 1.92185f
Crb2_X141 a_6000_12030 vss.t85 1.92185f
Crb1_X152 a_12000_19482 vss.t163 2.34466f
Crb2_X152 a_12600_12030 vss.t163 2.34466f
Crb1_X162 a_7800_18162 vss.t58 1.92185f
Crb2_X162 a_8400_12030 vss.t58 1.92185f
Crb1_X181 a_14400_19482 vss.t158 2.34466f
Crb2_X181 a_13800_12030 vss.t158 2.34466f
Crb1_X198 a_10800_19482 vss.t88 2.34466f
Crb2_X198 a_11400_12030 vss.t88 2.34466f
Crb1_X220 a_6600_18162 vss.t171 1.92185f
Crb2_X220 a_7200_12030 vss.t171 1.92185f
.ends
