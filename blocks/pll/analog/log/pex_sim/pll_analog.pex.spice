* NGSPICE file created from pll_analog.ext - technology: gf180mcuD

.subckt pll_analog vco_div2 pfd_up pfd_dn pll_en cp_trim0 cp_trim1 vctrl bias_ref
+ vdd vss
X0 vctrl.t2 a_400_12030 vss.t208 ppolyf_u r_width=2u r_length=37.5u
X1 sf.t1 dqn.t6 vdd.t100 vdd.t26 pfet_03v3 ad=0.65p pd=3.3u as=0.65p ps=3.3u w=1u l=0.28u
X2 a_4150_2036.t3 vbp_vco.t14 vdd.t68 vdd.t3 pfet_03v3 ad=1.3p pd=5.52u as=3.25p ps=11.3u w=5u l=0.5u
X3 vfilt vss.t82 cap_nmos_03v3_b c_width=35u c_length=12u
X4 vcp_n.t5 cp_trim1.t1 t2.t1 vss.t60 nfet_03v3 ad=1.22p pd=5.22u as=1.22p ps=5.22u w=2u l=0.28u
X5 en_b.t1 pll_en.t15 vdd.t109 vdd.t108 pfet_03v3 ad=1.3p pd=5.3u as=1.3p ps=5.3u w=2u l=0.28u
X6 vco_div2.t0 dqb.t3 vss.t160 vss.t159 nfet_03v3 ad=0.39p pd=2.02u as=0.915p ps=4.22u w=1.5u l=0.28u
X7 vdd.t98 clkb.t7 vdd.t97 vdd.t26 pfet_03v3 ad=0.65p pd=3.3u as=0 ps=0 w=1u l=0.45u
X8 vfilt vss.t74 cap_nmos_03v3_b c_width=35u c_length=12u
X9 vs.t0 a_4200_12030 vss.t37 ppolyf_u r_width=1u r_length=21.5u
X10 a_13200_19482 a_12600_12030 vss.t59 ppolyf_u r_width=1u r_length=36.6u
X11 vdump.t14 vbh.t6 vdd.t45 vdd.t44 pfet_03v3 ad=2.6p pd=9.3u as=2.6p ps=9.3u w=4u l=2u
X12 vss.t16 vbn_vco.t7 a_6394_0.t1 vss.t15 nfet_03v3 ad=1.22p pd=5.22u as=0.52p ps=2.52u w=2u l=0.5u
X13 m1.t3 ck.t3 mf.t2 vss.t142 nfet_03v3 ad=0.305p pd=2.22u as=0.305p ps=2.22u w=0.5u l=0.28u
X14 vss.t21 sf.t4 vss.t20 vss.t19 nfet_03v3 ad=2.44p pd=9.22u as=0 ps=0 w=4u l=1u
X15 dqb.t1 dqn.t5 vdd.t99 vdd.t0 pfet_03v3 ad=1.3p pd=5.3u as=1.3p ps=5.3u w=2u l=0.28u
X16 vbp_vco.t5 pll_en.t12 vi.t4 vss.t189 nfet_03v3 ad=3.05p pd=11.22u as=3.05p ps=11.22u w=5u l=0.28u
X17 vbt.t11 vbp.t17 vdd.t86 vdd.t85 pfet_03v3 ad=2.6p pd=9.3u as=2.6p ps=9.3u w=4u l=2u
X18 vbh.t3 vbh.t2 vdd.t58 vdd.t57 pfet_03v3 ad=2.6p pd=9.3u as=2.6p ps=9.3u w=4u l=2u
X19 vbl.t7 vbl.t6 vss.t130 vss.t129 nfet_03v3 ad=1.22p pd=5.22u as=1.22p ps=5.22u w=2u l=2u
X20 vfilt vss.t88 cap_nmos_03v3_b c_width=35u c_length=12u
X21 t2.t2 vbp.t9 vdd.t61 vdd.t60 pfet_03v3 ad=2.6p pd=9.3u as=2.6p ps=9.3u w=4u l=2u
X22 bias_ref.t0 a_10200_12030 vss.t120 ppolyf_u r_width=1u r_length=36.6u
X23 up_s.t0 vcp_p.t7 vdd.t8 vdd.t7 pfet_03v3 ad=32.5p pd=0.1013m as=32.5p ps=0.1013m w=50u l=4u
X24 a_1200_19662 a_400_12030 vss.t207 ppolyf_u r_width=2u r_length=37.5u
X25 bias_ref.t1 a_8400_12030 vss.t163 ppolyf_u r_width=1u r_length=30u
X26 vst.t3 vref.t3 vss.t94 vss.t93 nfet_03v3 ad=3.05p pd=11.22u as=3.05p ps=11.22u w=5u l=1u
X27 dqb.t0 dqn.t3 vss.t100 vss.t99 nfet_03v3 ad=0.61p pd=3.22u as=0.61p ps=3.22u w=1u l=0.28u
X28 a_5274_0.t3 r3.t4 r4.t2 vss.t138 nfet_03v3 ad=0.915p pd=4.22u as=0.39p ps=2.02u w=1.5u l=0.28u
X29 a_7950_0.t2 r4.t4 r5.t1 vss.t34 nfet_03v3 ad=0.915p pd=4.22u as=0.39p ps=2.02u w=1.5u l=0.28u
X30 vcp_p.t0 vcp_n.t15 vss.t205 vss.t204 nfet_03v3 ad=12.2p pd=41.22u as=12.2p ps=41.22u w=20u l=4u
X31 a_3034_0.t1 vbn_vco.t14 vss.t27 vss.t26 nfet_03v3 ad=0.52p pd=2.52u as=1.22p ps=5.22u w=2u l=0.5u
X32 vnt.t6 vref.t6 vss.t141 vss.t140 nfet_03v3 ad=1.22p pd=5.22u as=1.22p ps=5.22u w=2u l=2u
X33 vdd.t119 pll_en.t4 nb.t5 vdd.t0 pfet_03v3 ad=1.3p pd=5.3u as=0.52p ps=2.52u w=2u l=0.28u
X34 vcp_n.t10 vbp.t16 vdd.t74 vdd.t73 pfet_03v3 ad=2.6p pd=9.3u as=2.6p ps=9.3u w=4u l=2u
X35 vfilt vss.t80 cap_nmos_03v3_b c_width=35u c_length=12u
X36 vdump.t2 vdump.t1 vnt.t2 vss.t109 nfet_03v3 ad=3.05p pd=11.22u as=3.05p ps=11.22u w=5u l=1u
X37 vst.t1 en_b.t7 vss.t42 vss.t41 nfet_03v3 ad=0.61p pd=3.22u as=0.61p ps=3.22u w=1u l=0.28u
X38 a_14400_19482 a_15000_12030 vss.t36 ppolyf_u r_width=1u r_length=36.6u
X39 vbh.t5 vbh.t4 vdd.t52 vdd.t51 pfet_03v3 ad=2.6p pd=9.3u as=2.6p ps=9.3u w=4u l=2u
X40 vref.t1 a_6000_12030 vss.t65 ppolyf_u r_width=1u r_length=30u
X41 vcp_p.t6 pll_en.t17 vdd.t105 vdd.t104 pfet_03v3 ad=0.65p pd=3.3u as=0.65p ps=3.3u w=1u l=0.28u
X42 vcl.t0 vref.t12 vss.t40 vss.t39 nfet_03v3 ad=7.625p pd=26.22u as=7.625p ps=26.22u w=12.5u l=1u
X43 a_5270_2036.t4 pll_en.t9 vdd.t112 vdd.t26 pfet_03v3 ad=0.65p pd=3.3u as=0.65p ps=3.3u w=1u l=0.28u
X44 m2.t3 m1.t6 vdd.t101 vdd.t0 pfet_03v3 ad=1.3p pd=5.3u as=1.3p ps=5.3u w=2u l=0.28u
X45 vbt.t6 vbp.t15 vdd.t20 vdd.t19 pfet_03v3 ad=2.6p pd=9.3u as=2.6p ps=9.3u w=4u l=2u
X46 t2.t3 vbp.t13 vdd.t88 vdd.t87 pfet_03v3 ad=2.6p pd=9.3u as=2.6p ps=9.3u w=4u l=2u
X47 vcp_n.t1 vcp_n.t0 vss.t6 vss.t5 nfet_03v3 ad=12.2p pd=41.22u as=12.2p ps=41.22u w=20u l=4u
X48 a_4154_0.t2 en_b.t3 vss.t117 vss.t116 nfet_03v3 ad=0.305p pd=2.22u as=0.305p ps=2.22u w=0.5u l=0.28u
X49 vcp_n.t6 en_b.t9 vss.t158 vss.t157 nfet_03v3 ad=0.61p pd=3.22u as=0.61p ps=3.22u w=1u l=0.28u
X50 a_12000_19482 a_11400_12030 vss.t121 ppolyf_u r_width=1u r_length=36.6u
X51 a_9070_n100 r5.t4 nb.t1 vss.t2 nfet_03v3 ad=1.22p pd=5.22u as=0.52p ps=2.52u w=2u l=0.28u
X52 dn_b.t1 pfd_dn.t0 vdd.t78 vdd.t77 pfet_03v3 ad=1.3p pd=5.3u as=1.3p ps=5.3u w=2u l=0.28u
X53 s1.t5 ck.t4 sf.t3 vdd.t26 pfet_03v3 ad=0.65p pd=3.3u as=0.65p ps=3.3u w=1u l=0.28u
X54 vbl.t2 vctrl.t10 vbt.t7 vdd.t37 pfet_03v3 ad=3.25p pd=11.3u as=3.25p ps=11.3u w=5u l=1u
X55 a_4154_0.t3 r1.t5 r2.t2 vss.t134 nfet_03v3 ad=0.915p pd=4.22u as=0.39p ps=2.02u w=1.5u l=0.28u
X56 a_1200_19662 a_2000_12030 vss.t101 ppolyf_u r_width=2u r_length=37.5u
X57 vbl.t0 vctrl.t7 vbt.t10 vdd.t40 pfet_03v3 ad=3.25p pd=11.3u as=3.25p ps=11.3u w=5u l=1u
X58 t1a.t2 vbp.t12 vdd.t82 vdd.t81 pfet_03v3 ad=2.6p pd=9.3u as=2.6p ps=9.3u w=4u l=2u
X59 vbp.t4 pll_en.t16 vdd.t107 vdd.t106 pfet_03v3 ad=0.65p pd=3.3u as=0.65p ps=3.3u w=1u l=0.28u
X60 vdump.t17 vbl.t8 vss.t199 vss.t198 nfet_03v3 ad=1.22p pd=5.22u as=1.22p ps=5.22u w=2u l=2u
X61 vbn_vco.t4 en_b.t4 vss.t177 vss.t176 nfet_03v3 ad=0.61p pd=3.22u as=0.61p ps=3.22u w=1u l=0.28u
X62 vcp_n.t11 vbp.t8 vdd.t90 vdd.t89 pfet_03v3 ad=2.6p pd=9.3u as=2.6p ps=9.3u w=4u l=2u
X63 vdump.t4 vdump.t3 vnt.t5 vss.t122 nfet_03v3 ad=3.05p pd=11.22u as=3.05p ps=11.22u w=5u l=1u
X64 vcp_n.t8 vbp.t6 vdd.t63 vdd.t62 pfet_03v3 ad=2.6p pd=9.3u as=2.6p ps=9.3u w=4u l=2u
X65 up_b.t1 pfd_up.t1 vdd.t10 vdd.t9 pfet_03v3 ad=1.3p pd=5.3u as=1.3p ps=5.3u w=2u l=0.28u
X66 vbh.t0 vctrl.t6 vnt.t4 vss.t112 nfet_03v3 ad=3.05p pd=11.22u as=3.05p ps=11.22u w=5u l=1u
X67 vss.t50 nb.t6 vco_out.t1 vss.t49 nfet_03v3 ad=1.83p pd=7.22u as=0.78p ps=3.52u w=3u l=0.28u
X68 vdump.t6 vdump.t5 vbt.t4 vdd.t59 pfet_03v3 ad=3.25p pd=11.3u as=3.25p ps=11.3u w=5u l=1u
X69 vdd.t6 vbp_vco.t11 a_5270_2036.t0 vdd.t3 pfet_03v3 ad=3.25p pd=11.3u as=1.3p ps=5.52u w=5u l=0.5u
X70 vi.t1 vctrl.t3 vs.t2 vss.t115 nfet_03v3 ad=3.05p pd=11.22u as=3.05p ps=11.22u w=5u l=1u
X71 a_19434_n100 pll_en.t0 vss.t191 vss.t190 nfet_03v3 ad=1.22p pd=5.22u as=1.22p ps=5.22u w=2u l=0.28u
X72 m1.t2 ck.t5 s1.t0 vdd.t0 pfet_03v3 ad=1.3p pd=5.3u as=1.3p ps=5.3u w=2u l=0.28u
X73 vbp.t3 vbp.t2 vdd.t70 vdd.t69 pfet_03v3 ad=2.6p pd=9.3u as=2.6p ps=9.3u w=4u l=2u
X74 vbt.t0 vbp.t7 vdd.t13 vdd.t12 pfet_03v3 ad=2.6p pd=9.3u as=2.6p ps=9.3u w=4u l=2u
X75 a_9070_n100 pll_en.t2 vss.t193 vss.t192 nfet_03v3 ad=0.52p pd=2.52u as=1.22p ps=5.22u w=2u l=0.28u
X76 vdd.t95 dqb.t4 vco_div2.t1 vdd.t2 pfet_03v3 ad=1.95p pd=7.3u as=0.78p ps=3.52u w=3u l=0.28u
X77 clkb.t1 vco_out.t9 vdd.t31 vdd.t26 pfet_03v3 ad=0.65p pd=3.3u as=0.65p ps=3.3u w=1u l=0.28u
X78 vcl.t3 vref.t14 vss.t168 vss.t167 nfet_03v3 ad=7.625p pd=26.22u as=7.625p ps=26.22u w=12.5u l=1u
X79 vnt.t0 vref.t8 vss.t104 vss.t103 nfet_03v3 ad=1.22p pd=5.22u as=1.22p ps=5.22u w=2u l=2u
X80 vfilt vss.t76 cap_nmos_03v3_b c_width=35u c_length=12u
X81 vbn_vco.t2 vbp_vco.t17 vdd.t54 vdd.t53 pfet_03v3 ad=3.25p pd=11.3u as=3.25p ps=11.3u w=5u l=0.5u
X82 vdd.t4 vbp_vco.t9 a_6390_2036.t0 vdd.t3 pfet_03v3 ad=3.25p pd=11.3u as=1.3p ps=5.52u w=5u l=0.5u
X83 vcp_n.t4 cp_trim1.t0 t1c.t0 vss.t61 nfet_03v3 ad=1.22p pd=5.22u as=1.22p ps=5.22u w=2u l=0.28u
X84 a_3034_0.t3 r2.t4 r3.t3 vss.t143 nfet_03v3 ad=0.915p pd=4.22u as=0.39p ps=2.02u w=1.5u l=0.28u
X85 va.t2 vbp.t11 vdd.t47 vdd.t46 pfet_03v3 ad=2.6p pd=9.3u as=2.6p ps=9.3u w=4u l=2u
X86 t1a.t0 cp_trim0.t3 vdd.t34 vdd.t33 pfet_03v3 ad=0.65p pd=3.3u as=0.65p ps=3.3u w=1u l=0.28u
X87 dn_s.t2 vcp_n.t13 vss.t137 vss.t136 nfet_03v3 ad=12.2p pd=41.22u as=12.2p ps=41.22u w=20u l=4u
X88 vbp.t0 vst.t4 vss.t197 vss.t196 nfet_03v3 ad=0.305p pd=2.22u as=0.305p ps=2.22u w=0.5u l=4u
X89 dn_s.t0 vcp_n.t14 vss.t4 vss.t3 nfet_03v3 ad=12.2p pd=41.22u as=12.2p ps=41.22u w=20u l=4u
X90 vbp.t1 va.t3 vref.t2 vss.t118 nfet_03v3 ad=2.44p pd=9.22u as=2.44p ps=9.22u w=4u l=1u
X91 nb.t4 pll_en.t5 vdd.t118 vdd.t0 pfet_03v3 ad=0.52p pd=2.52u as=1.3p ps=5.3u w=2u l=0.28u
X92 a_7800_18162 a_7200_12030 vss.t151 ppolyf_u r_width=1u r_length=30u
X93 vref.t0 en_b.t5 vss.t179 vss.t178 nfet_03v3 ad=0.61p pd=3.22u as=0.61p ps=3.22u w=1u l=0.28u
X94 dn_b.t0 pfd_dn.t1 vss.t156 vss.t155 nfet_03v3 ad=0.61p pd=3.22u as=0.61p ps=3.22u w=1u l=0.28u
X95 vss.t1 vbn_vco.t5 a_7950_0.t0 vss.t0 nfet_03v3 ad=1.22p pd=5.22u as=0.52p ps=2.52u w=2u l=0.5u
X96 vco_out.t6 nb.t9 vdd.t93 vdd.t2 pfet_03v3 ad=0.78p pd=3.52u as=1.95p ps=7.3u w=3u l=0.28u
X97 vdd.t64 vbp_vco.t15 a_3030_2036.t2 vdd.t3 pfet_03v3 ad=3.25p pd=11.3u as=1.3p ps=5.52u w=5u l=0.5u
X98 vfilt vss.t72 cap_nmos_03v3_b c_width=35u c_length=12u
X99 s1.t1 ck.t2 m2.t1 vss.t123 nfet_03v3 ad=0.61p pd=3.22u as=0.61p ps=3.22u w=1u l=0.28u
X100 vbl.t1 vctrl.t9 vbt.t8 vdd.t38 pfet_03v3 ad=3.25p pd=11.3u as=3.25p ps=11.3u w=5u l=1u
X101 vfilt vss.t86 cap_nmos_03v3_b c_width=35u c_length=12u
X102 t1b.t2 vbp.t10 vdd.t121 vdd.t120 pfet_03v3 ad=2.6p pd=9.3u as=2.6p ps=9.3u w=4u l=2u
X103 vcl.t2 a_4200_12030 vss.t166 ppolyf_u r_width=1u r_length=21.5u
X104 a_13200_19482 a_13800_12030 vss.t149 ppolyf_u r_width=1u r_length=36.6u
X105 vdd.t27 nb.t8 vco_out.t3 vdd.t2 pfet_03v3 ad=1.95p pd=7.3u as=0.78p ps=3.52u w=3u l=0.28u
X106 vss.t25 vbn_vco.t13 a_3034_0.t0 vss.t24 nfet_03v3 ad=1.22p pd=5.22u as=0.52p ps=2.52u w=2u l=0.5u
X107 clkb.t0 vco_out.t8 vss.t64 vss.t63 nfet_03v3 ad=0.305p pd=2.22u as=0.305p ps=2.22u w=0.5u l=0.28u
X108 a_7946_2036.t1 r4.t6 r5.t2 vdd.t2 pfet_03v3 ad=1.95p pd=7.3u as=0.78p ps=3.52u w=3u l=0.28u
X109 up_s.t2 vcp_p.t8 vdd.t18 vdd.t17 pfet_03v3 ad=32.5p pd=0.1013m as=32.5p ps=0.1013m w=50u l=4u
X110 vbh.t1 vctrl.t5 vnt.t3 vss.t113 nfet_03v3 ad=3.05p pd=11.22u as=3.05p ps=11.22u w=5u l=1u
X111 vdd.t67 vbp_vco.t13 a_4150_2036.t2 vdd.t3 pfet_03v3 ad=3.25p pd=11.3u as=1.3p ps=5.52u w=5u l=0.5u
X112 vdump.t10 vdump.t9 vbt.t2 vdd.t16 pfet_03v3 ad=3.25p pd=11.3u as=3.25p ps=11.3u w=5u l=1u
X113 a_4154_0.t0 vbn_vco.t12 vss.t23 vss.t22 nfet_03v3 ad=0.52p pd=2.52u as=1.22p ps=5.22u w=2u l=0.5u
X114 vss.t175 dqb.t2 vco_div2.t3 vss.t174 nfet_03v3 ad=0.915p pd=4.22u as=0.39p ps=2.02u w=1.5u l=0.28u
X115 vfilt a_2000_12030 vss.t206 ppolyf_u r_width=2u r_length=37.5u
X116 vfilt vss.t78 cap_nmos_03v3_b c_width=35u c_length=12u
X117 vdump.t16 vbl.t9 vss.t201 vss.t200 nfet_03v3 ad=1.22p pd=5.22u as=1.22p ps=5.22u w=2u l=2u
X118 a_3030_2036.t1 r2.t6 r3.t1 vdd.t2 pfet_03v3 ad=1.95p pd=7.3u as=0.78p ps=3.52u w=3u l=0.28u
X119 a_10800_19482 a_10200_12030 vss.t91 ppolyf_u r_width=1u r_length=36.6u
X120 vbl.t5 vbl.t4 vss.t203 vss.t202 nfet_03v3 ad=1.22p pd=5.22u as=1.22p ps=5.22u w=2u l=2u
X121 vbp_vco.t4 pll_en.t13 vi.t3 vss.t188 nfet_03v3 ad=3.05p pd=11.22u as=3.05p ps=11.22u w=5u l=0.28u
X122 vcp_n.t7 cp_trim0.t1 t1a.t1 vss.t105 nfet_03v3 ad=1.22p pd=5.22u as=1.22p ps=5.22u w=2u l=0.28u
X123 ck.t0 vss.t209 vco_out.t0 vdd.t26 pfet_03v3 ad=0.65p pd=3.3u as=0.65p ps=3.3u w=1u l=0.28u
X124 vdd.t32 r5.t8 nb.t3 vdd.t0 pfet_03v3 ad=1.3p pd=5.3u as=0.52p ps=2.52u w=2u l=0.28u
X125 vfilt vss.t70 cap_nmos_03v3_b c_width=35u c_length=12u
X126 t1b.t1 cp_trim0.t2 vdd.t36 vdd.t35 pfet_03v3 ad=0.65p pd=3.3u as=0.65p ps=3.3u w=1u l=0.28u
X127 vctrl.t1 pfd_dn.t2 dn_s.t3 vss.t154 nfet_03v3 ad=1.22p pd=5.22u as=1.22p ps=5.22u w=2u l=0.5u
X128 vcl.t1 vref.t11 vss.t162 vss.t161 nfet_03v3 ad=7.625p pd=26.22u as=7.625p ps=26.22u w=12.5u l=1u
X129 ck.t1 vdd.t122 vco_out.t4 vss.t62 nfet_03v3 ad=0.305p pd=2.22u as=0.305p ps=2.22u w=0.5u l=0.28u
X130 vdd.t94 nb.t10 vco_out.t7 vdd.t2 pfet_03v3 ad=1.95p pd=7.3u as=0.78p ps=3.52u w=3u l=0.28u
X131 dqn.t2 pll_en.t3 vdd.t117 vdd.t26 pfet_03v3 ad=0.65p pd=3.3u as=0.65p ps=3.3u w=1u l=0.28u
X132 vco_out.t2 nb.t7 vss.t52 vss.t51 nfet_03v3 ad=0.78p pd=3.52u as=1.83p ps=7.22u w=3u l=0.28u
X133 r4.t3 r3.t5 a_5274_0.t4 vss.t139 nfet_03v3 ad=0.39p pd=2.02u as=0.915p ps=4.22u w=1.5u l=0.28u
X134 vfilt vss.t84 cap_nmos_03v3_b c_width=35u c_length=12u
X135 r5.t0 r4.t5 a_7950_0.t3 vss.t35 nfet_03v3 ad=0.39p pd=2.02u as=0.915p ps=4.22u w=1.5u l=0.28u
X136 a_4150_2036.t1 r1.t7 r2.t3 vdd.t2 pfet_03v3 ad=1.95p pd=7.3u as=0.78p ps=3.52u w=3u l=0.28u
X137 vss.t46 a_15000_12030 vss.t45 ppolyf_u r_width=1u r_length=36.6u
X138 vbn_vco.t3 vbp_vco.t18 vdd.t56 vdd.t55 pfet_03v3 ad=3.25p pd=11.3u as=3.25p ps=11.3u w=5u l=0.5u
X139 a_6600_18162 a_6000_12030 vss.t119 ppolyf_u r_width=1u r_length=30u
X140 vss.t185 m1.t5 vss.t184 vss.t183 nfet_03v3 ad=2.44p pd=9.22u as=0 ps=0 w=4u l=1u
X141 vss.t29 vbn_vco.t9 a_5274_0.t0 vss.t28 nfet_03v3 ad=1.22p pd=5.22u as=0.52p ps=2.52u w=2u l=0.5u
X142 vco_div2.t2 dqb.t5 vdd.t96 vdd.t2 pfet_03v3 ad=0.78p pd=3.52u as=1.95p ps=7.3u w=3u l=0.28u
X143 vcl.t4 vref.t13 vss.t173 vss.t172 nfet_03v3 ad=7.625p pd=26.22u as=7.625p ps=26.22u w=12.5u l=1u
X144 vdd.t79 vbp_vco.t7 a_7946_2036.t2 vdd.t3 pfet_03v3 ad=3.25p pd=11.3u as=1.3p ps=5.52u w=5u l=0.5u
X145 a_6394_0.t2 vbn_vco.t8 vss.t18 vss.t17 nfet_03v3 ad=0.52p pd=2.52u as=1.22p ps=5.22u w=2u l=0.5u
X146 dqn.t0 s1.t7 a_19434_n100 vss.t58 nfet_03v3 ad=1.22p pd=5.22u as=1.22p ps=5.22u w=2u l=0.28u
X147 a_5270_2036.t3 r3.t6 r4.t0 vdd.t2 pfet_03v3 ad=1.95p pd=7.3u as=0.78p ps=3.52u w=3u l=0.28u
X148 vbl.t3 vctrl.t8 vbt.t9 vdd.t39 pfet_03v3 ad=3.25p pd=11.3u as=3.25p ps=11.3u w=5u l=1u
X149 s1.t4 clkb.t2 sf.t2 vss.t182 nfet_03v3 ad=0.305p pd=2.22u as=0.305p ps=2.22u w=0.5u l=0.28u
X150 a_12000_19482 a_12600_12030 vss.t92 ppolyf_u r_width=1u r_length=36.6u
X151 vcp_n.t3 vcp_n.t2 vss.t145 vss.t144 nfet_03v3 ad=12.2p pd=41.22u as=12.2p ps=41.22u w=20u l=4u
X152 vdump.t0 pfd_up.t0 up_s.t1 vdd.t11 pfet_03v3 ad=2.6p pd=9.3u as=2.6p ps=9.3u w=4u l=0.5u
X153 mf.t0 m2.t4 vss.t54 vss.t53 nfet_03v3 ad=0.305p pd=2.22u as=0.305p ps=2.22u w=0.5u l=0.28u
X154 a_3030_2036.t4 pll_en.t11 vdd.t103 vdd.t26 pfet_03v3 ad=0.65p pd=3.3u as=0.65p ps=3.3u w=1u l=0.28u
X155 r4.t1 r3.t7 a_5270_2036.t2 vdd.t2 pfet_03v3 ad=0.78p pd=3.52u as=1.95p ps=7.3u w=3u l=0.28u
X156 vss.t57 s1.t6 vss.t56 vss.t55 nfet_03v3 ad=2.44p pd=9.22u as=0 ps=0 w=4u l=1u
X157 a_6390_2036.t3 r5.t10 r1.t1 vdd.t2 pfet_03v3 ad=1.95p pd=7.3u as=0.78p ps=3.52u w=3u l=0.28u
X158 r2.t1 r1.t6 a_4154_0.t4 vss.t135 nfet_03v3 ad=0.39p pd=2.02u as=0.915p ps=4.22u w=1.5u l=0.28u
X159 a_7800_18162 a_8400_12030 vss.t128 ppolyf_u r_width=1u r_length=30u
X160 vss.t195 pll_en.t1 a_9070_n100 vss.t194 nfet_03v3 ad=1.22p pd=5.22u as=0.52p ps=2.52u w=2u l=0.28u
X161 vnt.t1 vref.t5 vss.t108 vss.t107 nfet_03v3 ad=1.22p pd=5.22u as=1.22p ps=5.22u w=2u l=2u
X162 a_4150_2036.t4 pll_en.t10 vdd.t102 vdd.t26 pfet_03v3 ad=0.65p pd=3.3u as=0.65p ps=3.3u w=1u l=0.28u
X163 mf.t1 m2.t5 vdd.t48 vdd.t26 pfet_03v3 ad=0.65p pd=3.3u as=0.65p ps=3.3u w=1u l=0.28u
X164 r5.t3 r4.t7 a_7946_2036.t0 vdd.t2 pfet_03v3 ad=0.78p pd=3.52u as=1.95p ps=7.3u w=3u l=0.28u
X165 r1.t0 r5.t11 a_6390_2036.t2 vdd.t2 pfet_03v3 ad=0.78p pd=3.52u as=1.95p ps=7.3u w=3u l=0.28u
X166 vfilt vss.t66 cap_nmos_03v3_b c_width=35u c_length=12u
X167 vnt.t7 vref.t9 vss.t153 vss.t152 nfet_03v3 ad=1.22p pd=5.22u as=1.22p ps=5.22u w=2u l=2u
X168 s1.t3 clkb.t5 m2.t2 vdd.t0 pfet_03v3 ad=1.3p pd=5.3u as=1.3p ps=5.3u w=2u l=0.28u
X169 vbt.t1 vbp.t5 vdd.t15 vdd.t14 pfet_03v3 ad=2.6p pd=9.3u as=2.6p ps=9.3u w=4u l=2u
X170 en_b.t0 pll_en.t18 vss.t187 vss.t186 nfet_03v3 ad=0.61p pd=3.22u as=0.61p ps=3.22u w=1u l=4u
X171 vbp_vco.t6 pll_en.t14 vdd.t111 vdd.t110 pfet_03v3 ad=0.65p pd=3.3u as=0.65p ps=3.3u w=1u l=0.28u
X172 vi.t2 vref.t10 vss.t171 vss.t170 nfet_03v3 ad=1.22p pd=5.22u as=1.22p ps=5.22u w=2u l=2u
X173 vcp_p.t5 vcp_p.t4 vdd.t92 vdd.t91 pfet_03v3 ad=32.5p pd=0.1013m as=32.5p ps=0.1013m w=50u l=4u
X174 a_7950_0.t1 vbn_vco.t6 vss.t14 vss.t13 nfet_03v3 ad=0.52p pd=2.52u as=1.22p ps=5.22u w=2u l=0.5u
X175 nb.t2 r5.t5 a_9070_n100 vss.t11 nfet_03v3 ad=0.52p pd=2.52u as=1.22p ps=5.22u w=2u l=0.28u
X176 vdump.t15 dn_b.t2 dn_s.t1 vss.t148 nfet_03v3 ad=1.22p pd=5.22u as=1.22p ps=5.22u w=2u l=0.5u
X177 a_14400_19482 a_13800_12030 vss.t169 ppolyf_u r_width=1u r_length=36.6u
X178 vdump.t12 vdump.t11 vbt.t3 vdd.t21 pfet_03v3 ad=3.25p pd=11.3u as=3.25p ps=11.3u w=5u l=1u
X179 vctrl.t0 up_b.t2 up_s.t3 vdd.t43 pfet_03v3 ad=2.6p pd=9.3u as=2.6p ps=9.3u w=4u l=0.5u
X180 r3.t2 r2.t7 a_3030_2036.t0 vdd.t2 pfet_03v3 ad=0.78p pd=3.52u as=1.95p ps=7.3u w=3u l=0.28u
X181 va.t0 en_b.t6 vss.t96 vss.t95 nfet_03v3 ad=0.61p pd=3.22u as=0.61p ps=3.22u w=1u l=0.28u
X182 a_5270_2036.t1 vbp_vco.t12 vdd.t66 vdd.t3 pfet_03v3 ad=1.3p pd=5.52u as=3.25p ps=11.3u w=5u l=0.5u
X183 r1.t4 pll_en.t7 vdd.t115 vdd.t114 pfet_03v3 ad=0.325p pd=2.3u as=0.325p ps=2.3u w=0.5u l=0.28u
X184 nb.t0 r5.t9 vdd.t1 vdd.t0 pfet_03v3 ad=0.52p pd=2.52u as=1.3p ps=5.3u w=2u l=0.28u
X185 up_b.t0 pfd_up.t2 vss.t8 vss.t7 nfet_03v3 ad=0.61p pd=3.22u as=0.61p ps=3.22u w=1u l=0.28u
X186 vi.t0 vctrl.t4 vs.t1 vss.t114 nfet_03v3 ad=3.05p pd=11.22u as=3.05p ps=11.22u w=5u l=1u
X187 t2.t0 cp_trim1.t2 vdd.t30 vdd.t29 pfet_03v3 ad=0.65p pd=3.3u as=0.65p ps=3.3u w=1u l=0.28u
X188 vdump.t13 vbh.t7 vdd.t50 vdd.t49 pfet_03v3 ad=2.6p pd=9.3u as=2.6p ps=9.3u w=4u l=2u
X189 vss.t127 clkb.t4 vss.t126 vss.t125 nfet_03v3 ad=0.61p pd=3.22u as=0 ps=0 w=1u l=0.45u
X190 vco_out.t5 nb.t11 vdd.t41 vdd.t2 pfet_03v3 ad=0.78p pd=3.52u as=1.95p ps=7.3u w=3u l=0.28u
X191 vcp_p.t3 vcp_p.t2 vdd.t76 vdd.t75 pfet_03v3 ad=32.5p pd=0.1013m as=32.5p ps=0.1013m w=50u l=4u
X192 vst.t0 vref.t4 vss.t10 vss.t9 nfet_03v3 ad=3.05p pd=11.22u as=3.05p ps=11.22u w=5u l=1u
X193 a_10800_19482 a_11400_12030 vss.t150 ppolyf_u r_width=1u r_length=36.6u
X194 va.t1 vref.t7 vss.t44 vss.t43 nfet_03v3 ad=1.22p pd=5.22u as=1.22p ps=5.22u w=2u l=2u
X195 vss.t33 vbn_vco.t11 a_4154_0.t1 vss.t32 nfet_03v3 ad=1.22p pd=5.22u as=0.52p ps=2.52u w=2u l=0.5u
X196 vctrl.t11 vss.t110 cap_nmos_03v3_b c_width=43u c_length=12u
X197 vbp_vco.t1 vbp_vco.t0 vdd.t25 vdd.t24 pfet_03v3 ad=3.25p pd=11.3u as=3.25p ps=11.3u w=5u l=0.5u
X198 m1.t1 clkb.t3 s1.t2 vss.t124 nfet_03v3 ad=0.61p pd=3.22u as=0.61p ps=3.22u w=1u l=0.28u
X199 r3.t0 r2.t5 a_3034_0.t2 vss.t38 nfet_03v3 ad=0.39p pd=2.02u as=0.915p ps=4.22u w=1.5u l=0.28u
X200 r2.t0 r1.t8 a_4150_2036.t0 vdd.t2 pfet_03v3 ad=0.78p pd=3.52u as=1.95p ps=7.3u w=3u l=0.28u
X201 a_7946_2036.t3 vbp_vco.t8 vdd.t80 vdd.t3 pfet_03v3 ad=1.3p pd=5.52u as=3.25p ps=11.3u w=5u l=0.5u
X202 a_6390_2036.t1 vbp_vco.t10 vdd.t5 vdd.t3 pfet_03v3 ad=1.3p pd=5.52u as=3.25p ps=11.3u w=5u l=0.5u
X203 a_5274_0.t2 en_b.t2 vss.t48 vss.t47 nfet_03v3 ad=0.305p pd=2.22u as=0.305p ps=2.22u w=0.5u l=0.28u
X204 a_7946_2036.t4 pll_en.t6 vdd.t116 vdd.t26 pfet_03v3 ad=0.65p pd=3.3u as=0.65p ps=3.3u w=1u l=0.28u
X205 vbp_vco.t3 vbp_vco.t2 vdd.t84 vdd.t83 pfet_03v3 ad=3.25p pd=11.3u as=3.25p ps=11.3u w=5u l=0.5u
X206 a_5274_0.t1 vbn_vco.t10 vss.t31 vss.t30 nfet_03v3 ad=0.52p pd=2.52u as=1.22p ps=5.22u w=2u l=0.5u
X207 vbn_vco.t1 vbn_vco.t0 vss.t165 vss.t164 nfet_03v3 ad=2.44p pd=9.22u as=2.44p ps=9.22u w=4u l=0.5u
X208 dqn.t1 s1.t8 vdd.t28 vdd.t0 pfet_03v3 ad=1.3p pd=5.3u as=1.3p ps=5.3u w=2u l=0.28u
X209 vcp_n.t9 vbp.t14 vdd.t72 vdd.t71 pfet_03v3 ad=2.6p pd=9.3u as=2.6p ps=9.3u w=4u l=2u
X210 t1c.t1 cp_trim0.t0 t1b.t0 vss.t106 nfet_03v3 ad=1.22p pd=5.22u as=1.22p ps=5.22u w=2u l=0.28u
X211 m2.t0 m1.t4 vss.t98 vss.t97 nfet_03v3 ad=0.61p pd=3.22u as=0.61p ps=3.22u w=1u l=0.28u
X212 a_3030_2036.t3 vbp_vco.t16 vdd.t65 vdd.t3 pfet_03v3 ad=1.3p pd=5.52u as=3.25p ps=11.3u w=5u l=0.5u
X213 vcp_p.t1 vcp_n.t12 vss.t147 vss.t146 nfet_03v3 ad=12.2p pd=41.22u as=12.2p ps=41.22u w=20u l=4u
X214 vdump.t8 vdump.t7 vbt.t5 vdd.t42 pfet_03v3 ad=3.25p pd=11.3u as=3.25p ps=11.3u w=5u l=1u
X215 a_6394_0.t0 r5.t6 r1.t3 vss.t12 nfet_03v3 ad=0.915p pd=4.22u as=0.39p ps=2.02u w=1.5u l=0.28u
X216 vfilt vss.t68 cap_nmos_03v3_b c_width=35u c_length=12u
X217 vst.t2 en_b.t8 vdd.t23 vdd.t22 pfet_03v3 ad=0.325p pd=2.3u as=0.325p ps=2.3u w=0.5u l=10u
X218 a_6600_18162 a_7200_12030 vss.t90 ppolyf_u r_width=1u r_length=30u
X219 sf.t0 dqn.t4 vss.t181 vss.t180 nfet_03v3 ad=0.305p pd=2.22u as=0.305p ps=2.22u w=0.5u l=0.28u
X220 vss.t133 mf.t4 vss.t132 vss.t131 nfet_03v3 ad=2.44p pd=9.22u as=0 ps=0 w=4u l=1u
X221 r1.t2 r5.t7 a_6394_0.t3 vss.t102 nfet_03v3 ad=0.39p pd=2.02u as=0.915p ps=4.22u w=1.5u l=0.28u
X222 m1.t0 clkb.t6 mf.t3 vdd.t26 pfet_03v3 ad=0.65p pd=3.3u as=0.65p ps=3.3u w=1u l=0.28u
X223 a_6390_2036.t4 pll_en.t8 vdd.t113 vdd.t26 pfet_03v3 ad=0.65p pd=3.3u as=0.65p ps=3.3u w=1u l=0.28u
R0 vco_div2 vco_div2.n2 6.68608
R1 vco_div2.n2 vco_div2.n1 5.00509
R2 vco_div2.n1 vco_div2.t0 1.0925
R3 vco_div2.n1 vco_div2.t3 1.0925
R4 vco_div2.n2 vco_div2.n0 4.96805
R5 vco_div2.n0 vco_div2.t2 0.607167
R6 vco_div2.n0 vco_div2.t1 0.607167
R7 bias_ref bias_ref.n0 38.4912
R8 bias_ref.n0 bias_ref.t0 20.1588
R9 bias_ref.n0 bias_ref.t1 22.9937
R10 pll_en.n1 pll_en.n0 4.5005
R11 pll_en pll_en.n1 11.6495
R12 pll_en.n1 pll_en.n2 7.6775
R13 pll_en.n12 pll_en.n11 4.5005
R14 pll_en.n2 pll_en.n12 6.6485
R15 pll_en.n12 pll_en.n13 1.5185
R16 pll_en.n13 pll_en.n14 1.6505
R17 pll_en.n14 pll_en.n15 0.6245
R18 pll_en.n15 pll_en.n16 1.6505
R19 pll_en.n16 pll_en.n17 1.6505
R20 pll_en.n17 pll_en.t11 43.6029
R21 pll_en.n17 pll_en.t10 41.9529
R22 pll_en.n16 pll_en.t9 41.9529
R23 pll_en.n15 pll_en.t8 41.9529
R24 pll_en.n14 pll_en.t7 35.435
R25 pll_en.n13 pll_en.t6 41.9529
R26 pll_en.n11 pll_en.n10 6.56403
R27 pll_en.n10 pll_en.t1 45.7328
R28 pll_en.n10 pll_en.t2 45.5434
R29 pll_en.n11 pll_en.n9 4.94576
R30 pll_en.n9 pll_en.t4 45.7328
R31 pll_en.n9 pll_en.t5 45.5434
R32 pll_en.n6 pll_en.n5 4.5005
R33 pll_en.n2 pll_en.n8 10.1502
R34 pll_en.n8 pll_en.n6 3.9875
R35 pll_en.n8 pll_en.n7 13.8965
R36 pll_en.n7 pll_en.t12 95.5714
R37 pll_en.n7 pll_en.t13 94.4689
R38 pll_en.n5 pll_en.n3 0.5945
R39 pll_en.n3 pll_en.n4 0.626
R40 pll_en.n4 pll_en.t14 50.3903
R41 pll_en.n4 pll_en.t15 56.073
R42 pll_en.n3 pll_en.t16 43.2623
R43 pll_en.n5 pll_en.t17 43.2938
R44 pll_en.n6 pll_en.t18 43.3385
R45 pll_en.n0 pll_en.t0 52.1069
R46 pll_en.n0 pll_en.t3 37.4529
R47 pfd_up.n0 pfd_up.n1 0.023
R48 pfd_up pfd_up.n0 17.4425
R49 pfd_up.n1 pfd_up.t2 74.8543
R50 pfd_up.n0 pfd_up.t0 54.6402
R51 pfd_up.n1 pfd_up.t1 57.5805
R52 pfd_dn pfd_dn.n0 13.685
R53 pfd_dn.n0 pfd_dn.n1 27.5562
R54 pfd_dn.n1 pfd_dn.t1 46.7811
R55 pfd_dn.n1 pfd_dn.t2 48.975
R56 pfd_dn.n0 pfd_dn.t0 60.285
R57 cp_trim0.n1 cp_trim0.n0 10.9355
R58 cp_trim0 cp_trim0.n1 7.025
R59 cp_trim0.n1 cp_trim0.n2 22.4105
R60 cp_trim0.n2 cp_trim0.t2 54.5078
R61 cp_trim0.n2 cp_trim0.t3 53.3873
R62 cp_trim0.n0 cp_trim0.t0 60.1318
R63 cp_trim0.n0 cp_trim0.t1 61.3468
R64 cp_trim1.n1 cp_trim1.n0 0.068
R65 cp_trim1 cp_trim1.n1 17.285
R66 cp_trim1.n1 cp_trim1.t2 86.8718
R67 cp_trim1.n0 cp_trim1.t0 60.4918
R68 cp_trim1.n0 cp_trim1.t1 61.7068
R69 vctrl.n4 vctrl.n3 4.5005
R70 vctrl.n10 vctrl.n9 4.5005
R71 vctrl vctrl.n10 18.9793
R72 vctrl.n10 vctrl.n4 3.9875
R73 vctrl.n4 vctrl.n6 10.823
R74 vctrl.n6 vctrl.n5 7.03625
R75 vctrl.n9 vctrl.n7 3.686
R76 vctrl.n9 vctrl.n8 16.8395
R77 vctrl.n8 vctrl.t3 40.7877
R78 vctrl.n8 vctrl.t4 40.0182
R79 vctrl.n7 vctrl.t5 40.0182
R80 vctrl.n7 vctrl.t6 42.3267
R81 vctrl.n6 vctrl.t2 24.3534
R82 vctrl.n5 vctrl.t1 25.8641
R83 vctrl.n5 vctrl.t11 67.4552
R84 vctrl.n1 vctrl.n0 1.283
R85 vctrl.n3 vctrl.n1 2.336
R86 vctrl.n3 vctrl.n2 0.0275
R87 vctrl.n2 vctrl.t0 18.3577
R88 vctrl.n2 vctrl.t7 40.1274
R89 vctrl.n1 vctrl.t8 40.1274
R90 vctrl.n0 vctrl.t9 40.1274
R91 vctrl.n0 vctrl.t10 42.4899
R92 vdd vdd.n78 0.98975
R93 vdd.n77 vdd.n76 0.5005
R94 vdd.n78 vdd.n77 1.5035
R95 vdd.n77 vdd.n114 6.80969
R96 vdd.n80 vdd.n79 0.293
R97 vdd.n81 vdd.n80 0.30515
R98 vdd.n82 vdd.n81 0.08735
R99 vdd.n83 vdd.n82 0.2975
R100 vdd.n84 vdd.n83 0.30065
R101 vdd.n85 vdd.n84 0.08735
R102 vdd.n86 vdd.n85 0.2075
R103 vdd.n87 vdd.n86 0.203
R104 vdd.n88 vdd.n87 0.21065
R105 vdd.n89 vdd.n88 0.08735
R106 vdd.n90 vdd.n89 0.2075
R107 vdd.n91 vdd.n90 0.203
R108 vdd.n92 vdd.n91 0.21065
R109 vdd.n93 vdd.n92 0.08735
R110 vdd.n114 vdd.n93 0.11615
R111 vdd.n114 vdd.n94 0.08735
R112 vdd.n94 vdd.n95 0.2075
R113 vdd.n95 vdd.n96 0.21065
R114 vdd.n96 vdd.n97 0.08735
R115 vdd.n97 vdd.n98 0.2075
R116 vdd.n98 vdd.n99 0.203
R117 vdd.n99 vdd.n100 0.21065
R118 vdd.n100 vdd.n101 0.08735
R119 vdd.n101 vdd.n102 0.2075
R120 vdd.n102 vdd.n103 0.203
R121 vdd.n103 vdd.n104 0.1256
R122 vdd.n104 vdd.n105 0.13325
R123 vdd.n105 vdd.n106 0.08735
R124 vdd.n79 vdd.t75 113.022
R125 vdd.t75 vdd.t17 125.194
R126 vdd.n107 vdd.t17 83.7832
R127 vdd.n107 vdd.t7 83.7832
R128 vdd.t7 vdd.t91 125.194
R129 vdd.n108 vdd.t91 83.7832
R130 vdd.n108 vdd.t85 64.5228
R131 vdd.t85 vdd.t73 86.6723
R132 vdd.t19 vdd.t73 86.6723
R133 vdd.n109 vdd.t19 64.5228
R134 vdd.n109 vdd.t71 64.5228
R135 vdd.t71 vdd.t87 86.6723
R136 vdd.t81 vdd.t87 86.6723
R137 vdd.n110 vdd.t81 64.5228
R138 vdd.n110 vdd.t69 64.5228
R139 vdd.t69 vdd.t46 86.6723
R140 vdd.t46 vdd.t120 86.6723
R141 vdd.n111 vdd.t120 64.5228
R142 vdd.n111 vdd.t60 64.5228
R143 vdd.t60 vdd.t89 86.6723
R144 vdd.t89 vdd.t12 86.6723
R145 vdd.n112 vdd.t12 64.5228
R146 vdd.n112 vdd.t62 64.5228
R147 vdd.t62 vdd.t14 86.6723
R148 vdd.t14 vdd.t29 70.1084
R149 vdd.t33 vdd.t29 53.5444
R150 vdd.n113 vdd.t33 47.9589
R151 vdd.n113 vdd.t35 47.9589
R152 vdd.t35 vdd.n106 77.248
R153 vdd.n105 vdd.n113 29.1523
R154 vdd.n100 vdd.n112 29.1523
R155 vdd.n96 vdd.n111 29.1523
R156 vdd.n92 vdd.n110 29.1523
R157 vdd.n88 vdd.n109 29.1523
R158 vdd.n84 vdd.n108 29.1523
R159 vdd.n81 vdd.n107 29.1523
R160 vdd.n106 vdd.t36 24.6968
R161 vdd.n104 vdd.t34 24.6968
R162 vdd.n103 vdd.t30 24.6968
R163 vdd.n102 vdd.t15 14.696
R164 vdd.n101 vdd.t63 14.696
R165 vdd.n99 vdd.t13 14.696
R166 vdd.n98 vdd.t90 14.696
R167 vdd.n97 vdd.t61 14.696
R168 vdd.n95 vdd.t121 14.696
R169 vdd.n94 vdd.t47 14.696
R170 vdd.n93 vdd.t70 14.696
R171 vdd.n91 vdd.t82 14.696
R172 vdd.n90 vdd.t88 14.696
R173 vdd.n89 vdd.t72 14.696
R174 vdd.n87 vdd.t20 14.696
R175 vdd.n86 vdd.t74 14.696
R176 vdd.n85 vdd.t86 14.696
R177 vdd.n83 vdd.t92 8.42581
R178 vdd.n82 vdd.t8 8.42581
R179 vdd.n80 vdd.t18 8.42581
R180 vdd.n79 vdd.t76 8.42581
R181 vdd.n78 vdd.t122 36.8326
R182 vdd.n1 vdd.n11 0.15845
R183 vdd.n2 vdd.n1 0.7295
R184 vdd.n3 vdd.n2 0.08735
R185 vdd.n4 vdd.n3 0.203
R186 vdd.n5 vdd.n4 0.2075
R187 vdd.n6 vdd.n5 0.21065
R188 vdd.n7 vdd.n6 0.08735
R189 vdd.n8 vdd.n7 0.203
R190 vdd.n9 vdd.n8 0.4001
R191 vdd.n76 vdd.n9 0.13055
R192 vdd.n76 vdd.n10 0.0032
R193 vdd.n10 vdd.n60 0.08735
R194 vdd.n60 vdd.n61 0.1301
R195 vdd.n61 vdd.n62 0.1256
R196 vdd.n62 vdd.n0 0.13325
R197 vdd.n0 vdd.n63 0.08735
R198 vdd.n63 vdd.n64 0.5675
R199 vdd.n64 vdd.n65 0.14315
R200 vdd.n65 vdd.n66 0.08735
R201 vdd.n66 vdd.n67 0.14
R202 vdd.n67 vdd.n68 0.1355
R203 vdd.n68 vdd.n69 0.131
R204 vdd.n11 vdd.t37 431.449
R205 vdd.t37 vdd.t16 505.781
R206 vdd.t16 vdd.t21 505.781
R207 vdd.t38 vdd.t21 505.781
R208 vdd.n70 vdd.t38 411.851
R209 vdd.n70 vdd.t39 411.851
R210 vdd.t39 vdd.t59 505.781
R211 vdd.t59 vdd.t42 505.781
R212 vdd.t40 vdd.t42 505.781
R213 vdd.n71 vdd.t40 411.851
R214 vdd.n71 vdd.t57 484.104
R215 vdd.t57 vdd.t49 650.289
R216 vdd.t44 vdd.t49 650.289
R217 vdd.n72 vdd.t44 484.104
R218 vdd.n72 vdd.t51 484.104
R219 vdd.t51 vdd.t9 526.013
R220 vdd.t9 vdd.t43 417.63
R221 vdd.t11 vdd.t43 433.526
R222 vdd.t77 vdd.t11 417.63
R223 vdd.n73 vdd.t77 359.827
R224 vdd.n73 vdd.t104 359.827
R225 vdd.t104 vdd.t106 401.735
R226 vdd.t106 vdd.t108 401.735
R227 vdd.n74 vdd.t108 359.827
R228 vdd.n74 vdd.t22 1062.14
R229 vdd.t22 vdd.t24 1119.94
R230 vdd.n75 vdd.t24 375.724
R231 vdd.n75 vdd.t55 375.724
R232 vdd.t55 vdd.t53 433.526
R233 vdd.t53 vdd.t83 433.526
R234 vdd.t110 vdd.t83 417.63
R235 vdd.n69 vdd.t110 378.991
R236 vdd.n65 vdd.n75 19.0273
R237 vdd.n0 vdd.n74 19.0273
R238 vdd.n10 vdd.n73 19.0273
R239 vdd.n6 vdd.n72 19.0273
R240 vdd.n2 vdd.n71 19.0273
R241 vdd.n1 vdd.n70 19.0273
R242 vdd.n69 vdd.t111 14.5718
R243 vdd.n68 vdd.t84 4.15247
R244 vdd.n67 vdd.t54 4.15247
R245 vdd.n66 vdd.t56 4.15247
R246 vdd.n64 vdd.t25 4.15247
R247 vdd.n63 vdd.t23 17.5681
R248 vdd.n62 vdd.t109 7.26817
R249 vdd.n61 vdd.t107 14.5718
R250 vdd.n60 vdd.t105 14.5718
R251 vdd.n11 vdd.n12 6.87314
R252 vdd.n12 vdd.n14 2.21673
R253 vdd.n24 vdd.n13 12.6234
R254 vdd.n24 vdd.n15 12.6005
R255 vdd.n24 vdd.n16 12.6005
R256 vdd.n24 vdd.n17 12.6005
R257 vdd.n24 vdd.n18 12.6005
R258 vdd.n24 vdd.n19 12.6005
R259 vdd.n24 vdd.n20 12.6005
R260 vdd.n21 vdd.n24 6.175
R261 vdd.n24 vdd.n22 6.175
R262 vdd.n24 vdd.n23 6.175
R263 vdd.n24 vdd.n25 12.6005
R264 vdd.n13 vdd.n26 0.0956459
R265 vdd.n26 vdd.n27 0.152214
R266 vdd.n27 vdd.n28 0.0686429
R267 vdd.n28 vdd.n29 0.140643
R268 vdd.n29 vdd.n15 0.00757143
R269 vdd.n15 vdd.n30 0.145143
R270 vdd.n30 vdd.n31 0.0686429
R271 vdd.n31 vdd.n32 0.140643
R272 vdd.n32 vdd.n33 0.152214
R273 vdd.n33 vdd.n16 0.0101429
R274 vdd.n16 vdd.n34 0.059
R275 vdd.n34 vdd.n35 0.140643
R276 vdd.n35 vdd.n36 0.152214
R277 vdd.n36 vdd.n37 0.0686429
R278 vdd.n37 vdd.n17 0.0962857
R279 vdd.n17 vdd.n38 0.0448571
R280 vdd.n38 vdd.n39 0.140643
R281 vdd.n39 vdd.n40 0.152214
R282 vdd.n40 vdd.n41 0.0686429
R283 vdd.n41 vdd.n18 0.110429
R284 vdd.n18 vdd.n42 0.0307143
R285 vdd.n42 vdd.n43 0.123929
R286 vdd.n43 vdd.n44 0.0686429
R287 vdd.n44 vdd.n45 0.123929
R288 vdd.n45 vdd.n46 0.0686429
R289 vdd.n46 vdd.n19 0.101429
R290 vdd.n19 vdd.n47 0.023
R291 vdd.n47 vdd.n48 0.0686429
R292 vdd.n48 vdd.n49 0.123929
R293 vdd.n50 vdd.n49 0.0686429
R294 vdd.n51 vdd.n50 0.140643
R295 vdd.n52 vdd.n51 0.0834286
R296 vdd.n20 vdd.n52 0.0095
R297 vdd.n14 vdd.n20 0.399714
R298 vdd.n14 vdd.n21 0.368071
R299 vdd.n21 vdd.n53 0.433
R300 vdd.n53 vdd.n54 0.140643
R301 vdd.n54 vdd.n22 0.447143
R302 vdd.n22 vdd.n55 0.471571
R303 vdd.n55 vdd.n56 0.140643
R304 vdd.n56 vdd.n57 0.140643
R305 vdd.n57 vdd.n23 0.268429
R306 vdd.n23 vdd.n58 0.619429
R307 vdd.n58 vdd.n59 0.140643
R308 vdd.n59 vdd.n25 0.00821429
R309 vdd.n25 vdd.t95 4.69411
R310 vdd.n59 vdd.t96 4.57839
R311 vdd.n58 vdd.t99 5.88015
R312 vdd.n57 vdd.t100 10.9352
R313 vdd.n56 vdd.t28 5.88015
R314 vdd.n55 vdd.t117 10.9352
R315 vdd.n54 vdd.t48 10.9352
R316 vdd.n53 vdd.t101 5.88015
R317 vdd.n52 vdd.t97 10.9352
R318 vdd.n51 vdd.t98 10.9352
R319 vdd.n50 vdd.t31 10.9352
R320 vdd.n49 vdd.t27 4.57839
R321 vdd.n48 vdd.t93 4.57839
R322 vdd.n47 vdd.t94 4.57839
R323 vdd.n46 vdd.t41 4.57839
R324 vdd.n45 vdd.t119 5.88015
R325 vdd.n44 vdd.t118 5.88015
R326 vdd.n43 vdd.t32 5.88015
R327 vdd.n42 vdd.t1 5.88015
R328 vdd.n41 vdd.t116 10.9352
R329 vdd.n40 vdd.t79 2.01891
R330 vdd.n39 vdd.t80 2.01891
R331 vdd.n38 vdd.t115 13.9344
R332 vdd.n37 vdd.t113 10.9352
R333 vdd.n36 vdd.t4 2.01891
R334 vdd.n35 vdd.t5 2.01891
R335 vdd.n34 vdd.t112 10.9352
R336 vdd.n33 vdd.t6 2.01891
R337 vdd.n32 vdd.t66 2.01891
R338 vdd.n31 vdd.t102 10.9352
R339 vdd.n30 vdd.t67 2.01891
R340 vdd.n29 vdd.t68 2.01891
R341 vdd.n28 vdd.t103 10.9352
R342 vdd.n27 vdd.t64 2.01891
R343 vdd.n26 vdd.t65 2.01891
R344 vdd.t26 vdd.t114 2.28298
R345 vdd.t0 vdd.t26 4.56546
R346 vdd.t2 vdd.t0 4.56546
R347 vdd.t3 vdd.t2 65.7359
R348 vdd.n24 vdd.t3 38.3462
R349 vdd.n12 vdd.n13 0.345969
R350 vdd.n9 vdd.t78 7.26817
R351 vdd.n8 vdd.t10 7.26817
R352 vdd.n7 vdd.t52 4.57101
R353 vdd.n5 vdd.t45 4.57101
R354 vdd.n4 vdd.t50 4.57101
R355 vdd.n3 vdd.t58 4.57101
R356 vss vss.n56 1.01289
R357 vss vss.n223 0.31029
R358 vss.n1 vss.n0 10.4005
R359 vss.n3 vss.n2 10.4005
R360 vss.n5 vss.n4 10.4005
R361 vss.n7 vss.n6 10.4005
R362 vss.n9 vss.n8 10.4005
R363 vss.n11 vss.n10 10.4005
R364 vss.n13 vss.n12 10.4005
R365 vss.n15 vss.n14 10.4005
R366 vss.n17 vss.n16 10.4005
R367 vss.n19 vss.n18 10.4005
R368 vss.n21 vss.n20 10.4005
R369 vss.n23 vss.n22 10.4005
R370 vss.n25 vss.n24 10.4005
R371 vss.n222 vss.n221 0.149643
R372 vss.n221 vss.n220 0.211357
R373 vss.n220 vss.n1 0.00757143
R374 vss.n1 vss.n219 0.142571
R375 vss.n218 vss.n219 0.0712143
R376 vss.n217 vss.n218 0.140643
R377 vss.n216 vss.n217 0.149643
R378 vss.n3 vss.n216 0.0127143
R379 vss.n215 vss.n3 0.059
R380 vss.n214 vss.n215 0.140643
R381 vss.n213 vss.n214 0.149643
R382 vss.n5 vss.n213 0.167
R383 vss.n212 vss.n5 0.185
R384 vss.n211 vss.n212 0.149643
R385 vss.n7 vss.n211 0.181143
R386 vss.n210 vss.n7 0.222286
R387 vss.n209 vss.n210 0.121357
R388 vss.n208 vss.n209 0.0712143
R389 vss.n9 vss.n208 0.101429
R390 vss.n207 vss.n9 0.0204286
R391 vss.n206 vss.n207 0.262786
R392 vss.n205 vss.n206 0.140643
R393 vss.n204 vss.n205 0.0808571
R394 vss.n11 vss.n204 0.0120714
R395 vss.n223 vss.n11 0.2975
R396 vss.n223 vss.n203 0.156071
R397 vss.n203 vss.n13 0.0622143
R398 vss.n13 vss.n202 0.0545
R399 vss.n202 vss.n201 0.4595
R400 vss.n201 vss.n15 0.00178571
R401 vss.n15 vss.n200 0.114929
R402 vss.n200 vss.n199 0.0660714
R403 vss.n199 vss.n198 0.140643
R404 vss.n198 vss.n17 0.194643
R405 vss.n17 vss.n19 0.514786
R406 vss.n19 vss.n197 0.219071
R407 vss.n197 vss.n196 0.280786
R408 vss.n196 vss.n21 0.0159286
R409 vss.n21 vss.n195 0.125214
R410 vss.n195 vss.n194 0.116214
R411 vss.n194 vss.n193 0.0660714
R412 vss.n193 vss.n192 0.116214
R413 vss.n192 vss.n23 0.0930714
R414 vss.n23 vss.n191 0.366929
R415 vss.n191 vss.n190 0.140643
R416 vss.n190 vss.n25 0.00821429
R417 vss.n222 vss.t27 3.85787
R418 vss.n221 vss.t25 3.85787
R419 vss.n220 vss.t23 3.85787
R420 vss.n219 vss.t33 3.85787
R421 vss.n218 vss.t117 13.1287
R422 vss.n217 vss.t31 3.85787
R423 vss.n216 vss.t29 3.85787
R424 vss.n215 vss.t48 13.1287
R425 vss.n214 vss.t18 3.85787
R426 vss.n213 vss.t16 3.85787
R427 vss.n212 vss.t14 3.85787
R428 vss.n211 vss.t1 3.85787
R429 vss.n210 vss.t193 4.97103
R430 vss.n209 vss.t195 4.97103
R431 vss.n208 vss.t52 3.59261
R432 vss.n207 vss.t50 3.59261
R433 vss.n206 vss.t64 13.1287
R434 vss.n205 vss.t126 10.5494
R435 vss.n204 vss.t127 10.5494
R436 vss.n203 vss.t184 2.90418
R437 vss.n202 vss.t185 2.90418
R438 vss.n201 vss.t132 2.90418
R439 vss.n200 vss.t133 2.90418
R440 vss.n199 vss.t98 10.5494
R441 vss.n198 vss.t54 13.1287
R442 vss.n197 vss.t191 4.97103
R443 vss.n196 vss.t181 13.1287
R444 vss.n195 vss.t56 2.90418
R445 vss.n194 vss.t57 2.90418
R446 vss.n193 vss.t20 2.90418
R447 vss.n192 vss.t21 2.90418
R448 vss.n191 vss.t100 10.5494
R449 vss.n190 vss.t160 6.50024
R450 vss.n25 vss.t175 6.61338
R451 vss.n28 vss.n27 0.509553
R452 vss.n27 vss.n222 0.144334
R453 vss.n27 vss.n26 10.4049
R454 vss vss.n28 1.91573
R455 vss.n28 vss.n29 9.49664
R456 vss.n189 vss.n55 0.5005
R457 vss.n30 vss.n29 0.20075
R458 vss.n31 vss.n30 0.08645
R459 vss.n32 vss.n31 0.1994
R460 vss.n33 vss.n32 0.2057
R461 vss.n34 vss.n33 0.20615
R462 vss.n35 vss.n34 0.08645
R463 vss.n36 vss.n35 0.1994
R464 vss.n37 vss.n36 0.2057
R465 vss.n38 vss.n37 0.20615
R466 vss.n39 vss.n38 0.08645
R467 vss.n40 vss.n39 0.2057
R468 vss.n41 vss.n40 0.1994
R469 vss.n55 vss.n41 0.06395
R470 vss.n55 vss.n42 0.1427
R471 vss.n42 vss.n43 0.08645
R472 vss.n43 vss.n44 0.3596
R473 vss.n44 vss.n45 0.1544
R474 vss.n45 vss.n46 0.16115
R475 vss.n46 vss.n47 0.08645
R476 vss.n47 vss.n48 0.2894
R477 vss.n48 vss.n49 0.122
R478 vss.n49 vss.n50 0.122
R479 vss.n50 vss.n51 0.13505
R480 vss.n51 vss.n52 0.08645
R481 vss.n52 vss.n53 0.1319
R482 vss.n53 vss.n54 0.56435
R483 vss.n56 vss.n189 0.885071
R484 vss.n129 vss.n128 0.5005
R485 vss.n131 vss.n130 0.5005
R486 vss.n188 vss.n187 0.5005
R487 vss.n189 vss.n188 3.02154
R488 vss.n188 vss.n131 1.26365
R489 vss.n131 vss.n129 4.93858
R490 vss.n129 vss.n89 2.72418
R491 vss.n187 vss.t46 16.7666
R492 vss.n132 vss.t208 3.46717
R493 vss.n133 vss.t207 3.46717
R494 vss.n134 vss.t101 3.46717
R495 vss.n135 vss.t206 3.46717
R496 vss.n136 vss.t37 10.4005
R497 vss.n137 vss.t166 10.4005
R498 vss.t65 vss.n138 10.4005
R499 vss.n139 vss.t119 10.4005
R500 vss.n140 vss.t90 10.4005
R501 vss.n141 vss.t151 10.4005
R502 vss.n142 vss.t128 10.4005
R503 vss.n143 vss.t163 10.4005
R504 vss.n144 vss.t120 10.4005
R505 vss.n145 vss.t91 10.4005
R506 vss.n146 vss.t150 10.4005
R507 vss.n147 vss.t121 10.4005
R508 vss.n148 vss.t92 10.4005
R509 vss.n149 vss.t59 10.4005
R510 vss.n150 vss.t149 10.4005
R511 vss.n151 vss.t169 10.4005
R512 vss.n152 vss.t36 10.4005
R513 vss.n187 vss.n132 17.3635
R514 vss.n132 vss.n133 0.947868
R515 vss.n133 vss.n134 0.947868
R516 vss.n134 vss.n135 0.947868
R517 vss.n135 vss.n136 1.53997
R518 vss.n136 vss.n137 0.711026
R519 vss.n137 vss.n138 1.42155
R520 vss.n138 vss.n139 0.711026
R521 vss.n139 vss.n140 0.711026
R522 vss.n140 vss.n141 0.711026
R523 vss.n141 vss.n142 0.711026
R524 vss.n142 vss.n143 0.711026
R525 vss.n143 vss.n144 1.42155
R526 vss.n144 vss.n145 0.711026
R527 vss.n145 vss.n146 0.711026
R528 vss.n146 vss.n147 0.711026
R529 vss.n147 vss.n148 0.711026
R530 vss.n148 vss.n149 0.711026
R531 vss.n149 vss.n150 0.711026
R532 vss.n150 vss.n151 0.711026
R533 vss.n151 vss.n152 0.711026
R534 vss.n152 vss.t45 11.111
R535 vss.n161 vss.n153 20.1686
R536 vss.n164 vss.n154 20.1686
R537 vss.n167 vss.n155 20.1686
R538 vss.n168 vss.n156 20.1686
R539 vss.n173 vss.n157 20.1686
R540 vss.n159 vss.t208 111.99
R541 vss.t208 vss.t5 66.4169
R542 vss.t5 vss.t207 80.3607
R543 vss.t207 vss.t101 146.778
R544 vss.t101 vss.t204 8.44015
R545 vss.t204 vss.t206 138.338
R546 vss.t206 vss.n153 19.8153
R547 vss.n153 vss.t3 158.153
R548 vss.t37 vss.t3 60.5458
R549 vss.t37 vss.t166 110.082
R550 vss.t166 vss.t136 64.9491
R551 vss.t136 vss.t65 155.216
R552 vss.n154 vss.t65 2.93603
R553 vss.n154 vss.t119 107.147
R554 vss.t119 vss.t146 51.0054
R555 vss.t146 vss.t90 59.0781
R556 vss.t90 vss.t151 110.082
R557 vss.t151 vss.t144 66.4169
R558 vss.t128 vss.t144 43.6665
R559 vss.t128 vss.t163 110.082
R560 vss.t163 vss.t154 17.6137
R561 vss.t154 vss.n155 93.9375
R562 vss.n155 vss.t148 93.9375
R563 vss.t120 vss.t148 14.6782
R564 vss.t120 vss.t105 88.4334
R565 vss.t91 vss.t105 21.65
R566 vss.t91 vss.t60 77.4251
R567 vss.t150 vss.t60 32.6583
R568 vss.t150 vss.t106 66.4169
R569 vss.t121 vss.t106 43.6665
R570 vss.t121 vss.t61 55.4087
R571 vss.t92 vss.t61 54.6748
R572 vss.t92 vss.n156 35.2269
R573 vss.n156 vss.t59 74.8565
R574 vss.t59 vss.t7 15.0451
R575 vss.t7 vss.t149 95.0383
R576 vss.t149 vss.t155 4.03686
R577 vss.t155 vss.t157 99.0747
R578 vss.t169 vss.t157 6.97239
R579 vss.t169 vss.t36 110.082
R580 vss.t36 vss.t186 50.2715
R581 vss.t186 vss.t45 59.812
R582 vss.t45 vss.n157 98.3408
R583 vss.n157 vss.t167 103.112
R584 vss.t167 vss.t172 125.495
R585 vss.t172 vss.t39 125.495
R586 vss.t161 vss.t39 125.495
R587 vss.n158 vss.t161 103.112
R588 vss.n186 vss.n158 2883.94
R589 vss.n29 vss.t112 506.462
R590 vss.t112 vss.n185 319.43
R591 vss.n185 vss.t109 275.911
R592 vss.t109 vss.t122 595.341
R593 vss.t113 vss.t122 595.341
R594 vss.n178 vss.t113 489.154
R595 vss.n178 vss.t202 576.192
R596 vss.t202 vss.t200 769.417
R597 vss.t198 vss.t200 769.417
R598 vss.n179 vss.t198 576.192
R599 vss.n179 vss.t129 576.192
R600 vss.t129 vss.t170 769.417
R601 vss.t152 vss.t170 769.417
R602 vss.n180 vss.t152 576.192
R603 vss.n180 vss.t103 576.192
R604 vss.t103 vss.t43 769.417
R605 vss.t140 vss.t43 769.417
R606 vss.n181 vss.t140 576.192
R607 vss.n181 vss.t107 576.192
R608 vss.t107 vss.t118 682.379
R609 vss.t118 vss.t9 595.341
R610 vss.t93 vss.t9 595.341
R611 vss.n182 vss.t93 489.154
R612 vss.n182 vss.t196 750.269
R613 vss.t196 vss.t41 793.788
R614 vss.t95 vss.t41 470.005
R615 vss.t178 vss.t95 470.005
R616 vss.n183 vss.t178 426.486
R617 vss.n183 vss.t164 445.635
R618 vss.t164 vss.t176 489.154
R619 vss.t176 vss.t114 532.673
R620 vss.t114 vss.t115 595.341
R621 vss.t188 vss.t115 532.673
R622 vss.n184 vss.t188 426.486
R623 vss.n184 vss.n186 362.079
R624 vss.n186 vss.t189 64.4086
R625 vss.t189 vss.n54 443.5
R626 vss.n185 vss.n26 5288.69
R627 vss.n26 vss.t38 500.954
R628 vss.t38 vss.t26 19.4722
R629 vss.t26 vss.t143 122.141
R630 vss.t143 vss.t24 58.4155
R631 vss.t24 vss.n0 715.143
R632 vss.n0 vss.t135 76.1171
R633 vss.t135 vss.t22 19.4722
R634 vss.t22 vss.t134 122.141
R635 vss.t134 vss.t32 58.4155
R636 vss.t32 vss.t116 405.365
R637 vss.t116 vss.t139 385.894
R638 vss.t30 vss.t139 19.4722
R639 vss.t138 vss.t30 122.141
R640 vss.t28 vss.t138 58.4155
R641 vss.n2 vss.t28 148.694
R642 vss.n2 vss.t47 256.673
R643 vss.t47 vss.t102 385.894
R644 vss.t102 vss.t17 19.4722
R645 vss.t17 vss.t12 122.141
R646 vss.t15 vss.t12 58.4155
R647 vss.n4 vss.t15 573.529
R648 vss.n4 vss.t35 603.622
R649 vss.t35 vss.t13 19.4722
R650 vss.t13 vss.t34 122.141
R651 vss.t0 vss.t34 58.4155
R652 vss.n6 vss.t0 612.473
R653 vss.n6 vss.t11 178.786
R654 vss.t11 vss.t2 141.613
R655 vss.t2 vss.t192 385.894
R656 vss.t192 vss.t194 141.613
R657 vss.t51 vss.t194 385.894
R658 vss.t49 vss.t51 141.613
R659 vss.n8 vss.t49 40.714
R660 vss.n8 vss.t63 872.686
R661 vss.t125 vss.t63 400.94
R662 vss.n10 vss.t125 142.498
R663 vss.n10 vss.t62 258.442
R664 vss.t62 vss.t183 1147.06
R665 vss.n12 vss.t183 10.6214
R666 vss.n12 vss.t124 424.837
R667 vss.t124 vss.n14 991.285
R668 vss.n14 vss.t131 155.774
R669 vss.t131 vss.t97 435.459
R670 vss.t97 vss.t53 385.894
R671 vss.t142 vss.t53 385.894
R672 vss.n16 vss.t142 53.1051
R673 vss.n16 vss.t123 1030.23
R674 vss.n18 vss.t123 385.894
R675 vss.n18 vss.t190 697.441
R676 vss.t190 vss.t58 385.894
R677 vss.n20 vss.t58 332.789
R678 vss.n20 vss.t180 53.1051
R679 vss.t180 vss.t55 449.62
R680 vss.t55 vss.t19 499.183
R681 vss.n22 vss.t19 414.216
R682 vss.n22 vss.t182 21.2423
R683 vss.t182 vss.t99 1083.33
R684 vss.n24 vss.t99 311.548
R685 vss.n24 vss.t159 74.3469
R686 vss.t159 vss.t174 141.613
R687 vss.n54 vss.n184 16.7936
R688 vss.n51 vss.n183 16.7936
R689 vss.n46 vss.n182 16.7936
R690 vss.n42 vss.n181 16.7936
R691 vss.n38 vss.n180 16.7936
R692 vss.n34 vss.n179 16.7936
R693 vss.n30 vss.n178 16.7936
R694 vss.n177 vss.n158 20.3292
R695 vss.n160 vss.n159 0.2894
R696 vss.n161 vss.n160 0.30245
R697 vss.n162 vss.n161 0.08645
R698 vss.n163 vss.n162 0.2957
R699 vss.n164 vss.n163 0.29615
R700 vss.n165 vss.n164 0.08645
R701 vss.n166 vss.n165 0.2957
R702 vss.n167 vss.n166 0.42755
R703 vss.n130 vss.n167 0.4982
R704 vss.n130 vss.n168 0.2192
R705 vss.n168 vss.n169 0.08645
R706 vss.n169 vss.n170 0.122
R707 vss.n170 vss.n171 0.122
R708 vss.n171 vss.n172 0.1283
R709 vss.n172 vss.n173 0.29615
R710 vss.n173 vss.n174 0.08645
R711 vss.n174 vss.n175 0.1607
R712 vss.n175 vss.n176 0.1544
R713 vss.n176 vss.n177 0.1544
R714 vss.n177 vss.t162 5.98309
R715 vss.n176 vss.t40 5.98309
R716 vss.n175 vss.t173 5.98309
R717 vss.n174 vss.t168 5.98309
R718 vss.n172 vss.t187 18.5931
R719 vss.n171 vss.t158 19.4758
R720 vss.n170 vss.t156 19.4758
R721 vss.n169 vss.t8 18.5931
R722 vss.n166 vss.t145 5.00704
R723 vss.n165 vss.t147 5.00704
R724 vss.n163 vss.t137 5.00704
R725 vss.n162 vss.t4 5.00704
R726 vss.n160 vss.t205 5.00704
R727 vss.n159 vss.t6 5.00704
R728 vss.n91 vss.n90 0.6701
R729 vss.n92 vss.n91 0.6701
R730 vss.n93 vss.n92 0.6701
R731 vss.n128 vss.n93 0.00995
R732 vss.n128 vss.n94 0.66065
R733 vss.n96 vss.n95 0.0868014
R734 vss.n97 vss.n96 0.0868014
R735 vss.n94 vss.n97 7.65156
R736 vss.n97 vss.n127 4.57882
R737 vss.t88 vss.n127 0.0473
R738 vss.n99 vss.n98 0.0868014
R739 vss.n101 vss.n100 0.0868014
R740 vss.n103 vss.n102 0.0868014
R741 vss.n104 vss.n103 0.0868014
R742 vss.n106 vss.n105 0.0868014
R743 vss.n108 vss.n107 0.0868014
R744 vss.n109 vss.n108 0.0868014
R745 vss.n111 vss.n110 0.0868014
R746 vss.n113 vss.n112 0.0868014
R747 vss.n114 vss.n113 0.0868014
R748 vss.n116 vss.n115 0.0868014
R749 vss.n118 vss.n117 0.0868014
R750 vss.n119 vss.n118 0.0868014
R751 vss.n121 vss.n120 0.0868014
R752 vss.n123 vss.n122 0.0868014
R753 vss.n124 vss.n123 0.0868014
R754 vss.n126 vss.n125 0.0868014
R755 vss.n98 vss.n100 353.161
R756 vss.n100 vss.n102 66.5544
R757 vss.n102 vss.n105 353.075
R758 vss.n105 vss.n107 66.5544
R759 vss.n107 vss.n110 353.075
R760 vss.n110 vss.n112 66.5544
R761 vss.n112 vss.n115 353.075
R762 vss.n115 vss.n117 66.5544
R763 vss.n117 vss.n120 353.075
R764 vss.n120 vss.n122 66.5544
R765 vss.n122 vss.n125 353.075
R766 vss.n125 vss.n95 66.5544
R767 vss.n95 vss.n127 353.161
R768 vss.n126 vss.n124 4.57882
R769 vss.n94 vss.n124 6.98196
R770 vss.t86 vss.n126 0.0473
R771 vss.n123 vss.t86 0.0473
R772 vss.n121 vss.n119 4.57882
R773 vss.n93 vss.n119 6.98196
R774 vss.t84 vss.n121 0.0473
R775 vss.n118 vss.t84 0.0473
R776 vss.n116 vss.n114 4.57882
R777 vss.n92 vss.n114 6.98196
R778 vss.t82 vss.n116 0.0473
R779 vss.n113 vss.t82 0.0473
R780 vss.n111 vss.n109 4.57882
R781 vss.n91 vss.n109 6.98196
R782 vss.t80 vss.n111 0.0473
R783 vss.n108 vss.t80 0.0473
R784 vss.n106 vss.n104 4.57882
R785 vss.n90 vss.n104 6.98196
R786 vss.t78 vss.n106 0.0473
R787 vss.n103 vss.t78 0.0473
R788 vss.n101 vss.n99 4.57882
R789 vss.n90 vss.n99 7.65156
R790 vss.t76 vss.n101 0.0473
R791 vss.n98 vss.t76 0.0473
R792 vss.n96 vss.t88 0.0473
R793 vss.n58 vss.n57 0.6701
R794 vss.n59 vss.n58 0.6701
R795 vss.n60 vss.n59 0.6701
R796 vss.n89 vss.n60 0.00995
R797 vss.n62 vss.n61 0.0697308
R798 vss.n63 vss.n62 0.0697308
R799 vss.n89 vss.n63 7.99131
R800 vss.n63 vss.n88 5.26015
R801 vss.t110 vss.n88 0.038593
R802 vss.n65 vss.n64 0.0868014
R803 vss.n67 vss.n66 0.0868014
R804 vss.n69 vss.n68 0.0868014
R805 vss.n70 vss.n69 0.0868014
R806 vss.n72 vss.n71 0.0868014
R807 vss.n74 vss.n73 0.0868014
R808 vss.n75 vss.n74 0.0868014
R809 vss.n77 vss.n76 0.0868014
R810 vss.n79 vss.n78 0.0868014
R811 vss.n80 vss.n79 0.0868014
R812 vss.n82 vss.n81 0.0868014
R813 vss.n84 vss.n83 0.0868014
R814 vss.n85 vss.n84 0.0868014
R815 vss.n87 vss.n86 0.0868014
R816 vss.n64 vss.n66 288.168
R817 vss.n66 vss.n68 54.3033
R818 vss.n68 vss.n71 288.082
R819 vss.n71 vss.n73 54.3033
R820 vss.n73 vss.n76 288.082
R821 vss.n76 vss.n78 54.3033
R822 vss.n78 vss.n81 288.082
R823 vss.n81 vss.n83 54.3033
R824 vss.n83 vss.n86 288.082
R825 vss.n86 vss.n61 54.3033
R826 vss.n61 vss.n88 288.151
R827 vss.n87 vss.n85 4.57882
R828 vss.n60 vss.n85 8.78196
R829 vss.t74 vss.n87 0.0473
R830 vss.n84 vss.t74 0.0473
R831 vss.n82 vss.n80 4.57882
R832 vss.n59 vss.n80 8.78196
R833 vss.t72 vss.n82 0.0473
R834 vss.n79 vss.t72 0.0473
R835 vss.n77 vss.n75 4.57882
R836 vss.n58 vss.n75 8.78196
R837 vss.t70 vss.n77 0.0473
R838 vss.n74 vss.t70 0.0473
R839 vss.n72 vss.n70 4.57882
R840 vss.n57 vss.n70 8.78196
R841 vss.t68 vss.n72 0.0473
R842 vss.n69 vss.t68 0.0473
R843 vss.n67 vss.n65 4.57882
R844 vss.n57 vss.n65 9.45156
R845 vss.t66 vss.n67 0.0473
R846 vss.n64 vss.t66 0.0473
R847 vss.n62 vss.t110 0.038593
R848 vss.n56 vss.t209 45.7912
R849 vss.n53 vss.t177 15.2181
R850 vss.n52 vss.t165 4.5894
R851 vss.n50 vss.t179 16.1008
R852 vss.n49 vss.t96 16.1008
R853 vss.n48 vss.t42 16.1008
R854 vss.n47 vss.t197 17.7943
R855 vss.n45 vss.t94 4.15694
R856 vss.n44 vss.t10 4.15694
R857 vss.n43 vss.t108 7.39109
R858 vss.n41 vss.t141 7.39109
R859 vss.n40 vss.t44 7.39109
R860 vss.n39 vss.t104 7.39109
R861 vss.n37 vss.t153 7.39109
R862 vss.n36 vss.t171 7.39109
R863 vss.n35 vss.t130 7.39109
R864 vss.n33 vss.t199 7.39109
R865 vss.n32 vss.t201 7.39109
R866 vss.n31 vss.t203 7.39109
R867 a_7950_0.n0 a_7950_0.t1 0.8195
R868 a_7950_0.n0 a_7950_0.t0 0.8195
R869 a_7950_0.n2 a_7950_0.n0 7.36905
R870 a_7950_0.n1 a_7950_0.n2 8.17078
R871 a_7950_0 a_7950_0.n1 0.8825
R872 a_7950_0.n1 a_7950_0.t3 1.6805
R873 a_7950_0.n2 a_7950_0.t2 9.75178
R874 a_6394_0.t0 a_6394_0.n2 9.75178
R875 a_6394_0.n2 a_6394_0.n1 7.36905
R876 a_6394_0.n1 a_6394_0.t2 0.8195
R877 a_6394_0.n1 a_6394_0.t1 0.8195
R878 a_6394_0.n0 a_6394_0.n2 8.17078
R879 a_6394_0 a_6394_0.n0 0.8825
R880 a_6394_0.n0 a_6394_0.t3 1.6805
R881 a_5274_0.n0 a_5274_0.t1 0.8195
R882 a_5274_0.n0 a_5274_0.t0 0.8195
R883 a_5274_0.n3 a_5274_0.n0 7.36905
R884 a_5274_0.n3 a_5274_0.n1 0.1625
R885 a_5274_0.n2 a_5274_0.n3 8.17078
R886 a_5274_0 a_5274_0.n2 0.8825
R887 a_5274_0.n2 a_5274_0.t4 1.6805
R888 a_5274_0.n1 a_5274_0.t3 9.58978
R889 a_5274_0.n1 a_5274_0.t2 16.8058
R890 a_4154_0.t0 a_4154_0.n0 0.8195
R891 a_4154_0.n0 a_4154_0.t1 0.8195
R892 a_4154_0.n3 a_4154_0.n0 7.36905
R893 a_4154_0.n3 a_4154_0.n1 0.1625
R894 a_4154_0.n2 a_4154_0.n3 8.17078
R895 a_4154_0 a_4154_0.n2 0.8825
R896 a_4154_0.n2 a_4154_0.t4 1.6805
R897 a_4154_0.n1 a_4154_0.t3 9.58978
R898 a_4154_0.n1 a_4154_0.t2 16.8058
R899 a_3034_0.n0 a_3034_0.t1 0.8195
R900 a_3034_0.n0 a_3034_0.t0 0.8195
R901 a_3034_0.n2 a_3034_0.n0 7.36905
R902 a_3034_0.n1 a_3034_0.n2 8.17078
R903 a_3034_0 a_3034_0.n1 0.8825
R904 a_3034_0.n1 a_3034_0.t2 1.6805
R905 a_3034_0.n2 a_3034_0.t3 9.75178
R906 sf.t1 sf.n0 14.9378
R907 sf.n0 sf.t0 16.3228
R908 sf.n1 sf.n0 5.6465
R909 sf sf.n1 0.275
R910 sf sf.n2 0.542
R911 sf.n2 sf.t3 20.3167
R912 sf.n2 sf.t2 20.8228
R913 sf.n1 sf.t4 35.5733
R914 mf.t1 mf.n0 14.6978
R915 mf.n2 mf.n0 4.5005
R916 mf.n0 mf.t0 16.5628
R917 mf.n2 mf.n1 0.3005
R918 mf.n1 mf.t3 20.0768
R919 mf.n1 mf.t2 21.0628
R920 mf mf.n2 0.278
R921 mf mf.t4 37.3298
R922 m2.n0 m2.t2 14.2909
R923 m2 m2.n0 0.941
R924 m2.n2 m2.n1 4.5005
R925 m2 m2.n2 1.52
R926 m2.n2 m2.n3 4.8005
R927 m2.n3 m2.t0 15.0777
R928 m2.n3 m2.t3 8.91189
R929 m2.n1 m2.t4 32.0733
R930 m2.n1 m2.t5 37.9329
R931 m2.n0 m2.t1 19.5777
R932 dqn.t0 dqn.n0 8.76855
R933 dqn.n4 dqn.n0 4.5005
R934 dqn.n0 dqn.t1 9.87189
R935 dqn.n2 dqn.n1 4.5005
R936 dqn.n2 dqn.n4 0.3005
R937 dqn dqn.n2 1.5905
R938 dqn dqn.n3 7.0625
R939 dqn.n3 dqn.t3 37.6312
R940 dqn.n3 dqn.t5 51.9286
R941 dqn.n1 dqn.t4 31.1133
R942 dqn.n1 dqn.t6 38.8929
R943 dqn.n4 dqn.t2 19.8097
R944 s1.n6 s1.t0 14.1319
R945 s1.n0 s1.n6 5.2115
R946 s1 s1.n0 0.116
R947 s1 s1.n1 0.776
R948 s1.n3 s1.n2 4.5005
R949 s1.n1 s1.n3 1.2155
R950 s1.n3 s1.n4 1.2785
R951 s1.n4 s1.n5 1.9865
R952 s1.n5 s1.t5 19.8487
R953 s1.n5 s1.t4 21.3027
R954 s1.n4 s1.t6 36.0533
R955 s1.n2 s1.t7 50.9069
R956 s1.n2 s1.t8 51.6886
R957 s1.n1 s1.t3 14.1319
R958 s1.n0 s1.t1 18.8578
R959 s1.n6 s1.t2 19.7367
R960 clkb.t1 clkb.n0 13.9778
R961 clkb.n0 clkb.t0 17.2827
R962 clkb.n2 clkb.n1 4.5005
R963 clkb.n2 clkb.n0 4.8005
R964 clkb.n3 clkb.n2 3.9635
R965 clkb clkb.n3 3.482
R966 clkb clkb.n4 1.4
R967 clkb.n4 clkb.n5 1.8065
R968 clkb.n5 clkb.t2 41.0949
R969 clkb.n5 clkb.t5 55.9313
R970 clkb.n4 clkb.t6 42.8955
R971 clkb.n3 clkb.t3 43.0738
R972 clkb.n1 clkb.t4 29.7619
R973 clkb.n1 clkb.t7 29.7459
R974 m1.t2 m1.n4 14.6119
R975 m1 m1.n4 0.935
R976 m1.n2 m1.n1 4.5005
R977 m1 m1.n2 0.473
R978 m1.n2 m1.n3 1.6025
R979 m1.n3 m1.t0 20.3288
R980 m1.n3 m1.t3 20.8228
R981 m1.n1 m1.t4 37.3912
R982 m1.n1 m1.t6 52.1686
R983 m1.n4 m1.n0 0.8915
R984 m1.n0 m1.t5 36.7133
R985 m1.n0 m1.t1 18.3778
R986 ck.t0 ck.n3 18.7178
R987 ck.n0 ck.n3 2.9345
R988 ck.n1 ck.n0 3.0395
R989 ck ck.n1 0.632
R990 ck ck.n2 1.175
R991 ck.n2 ck.t4 49.5165
R992 ck.n2 ck.t2 42.8338
R993 ck.n1 ck.t3 36.3159
R994 ck.n0 ck.t5 56.1712
R995 ck.n3 ck.t1 22.4338
R996 vco_out.n0 vco_out.t2 0.5465
R997 vco_out.n0 vco_out.t1 0.5465
R998 vco_out.n1 vco_out.n0 3.04708
R999 vco_out.n1 vco_out.n7 3.63647
R1000 vco_out.n7 vco_out.t5 0.607167
R1001 vco_out.n7 vco_out.t7 0.607167
R1002 vco_out.n3 vco_out.n1 2.25783
R1003 vco_out.n5 vco_out.n4 1.5005
R1004 vco_out.n5 vco_out.n3 0.426
R1005 vco_out vco_out.n5 0.29125
R1006 vco_out vco_out.n6 0.88825
R1007 vco_out.n6 vco_out.t0 13.0259
R1008 vco_out.n6 vco_out.t4 14.6046
R1009 vco_out.n4 vco_out.t9 37.9372
R1010 vco_out.n4 vco_out.t8 30.729
R1011 vco_out.n3 vco_out.n2 5.01392
R1012 vco_out.n2 vco_out.t6 0.607167
R1013 vco_out.n2 vco_out.t3 0.607167
R1014 dqb.t1 dqb.n0 10.1119
R1015 dqb.n0 dqb.t0 13.8777
R1016 dqb dqb.n0 4.6505
R1017 dqb dqb.n3 4.6505
R1018 dqb.n3 dqb.n2 4.88403
R1019 dqb.n2 dqb.t2 39.215
R1020 dqb.n2 dqb.t3 39.0255
R1021 dqb.n3 dqb.n1 6.62576
R1022 dqb.n1 dqb.t4 58.7685
R1023 dqb.n1 dqb.t5 58.5791
R1024 nb.n0 nb.t4 0.9105
R1025 nb.n0 nb.t5 0.9105
R1026 nb.n9 nb.n0 5.55804
R1027 nb nb.n9 0.170303
R1028 nb nb.n7 0.0597105
R1029 nb.n7 nb.n8 7.61063
R1030 nb.n8 nb.t8 58.7685
R1031 nb.n8 nb.t9 58.5791
R1032 nb.n7 nb.n6 1.50761
R1033 nb.n6 nb.n5 4.81225
R1034 nb.n5 nb.t6 58.7685
R1035 nb.n5 nb.t7 58.5791
R1036 nb.n6 nb.n4 5.38274
R1037 nb.n4 nb.t10 58.7685
R1038 nb.n4 nb.t11 58.5791
R1039 nb.n9 nb.n1 1.49711
R1040 nb.n1 nb.n3 3.79261
R1041 nb.n3 nb.t2 0.8195
R1042 nb.n3 nb.t1 0.8195
R1043 nb.n1 nb.n2 4.33492
R1044 nb.n2 nb.t0 0.9105
R1045 nb.n2 nb.t3 0.9105
R1046 r4.n0 r4.t1 0.607167
R1047 r4.n0 r4.t0 0.607167
R1048 r4.n1 r4.n0 8.06634
R1049 r4.n1 r4.n5 8.25966
R1050 r4.n5 r4.t3 1.0925
R1051 r4.n5 r4.t2 1.0925
R1052 r4 r4.n1 6.3515
R1053 r4 r4.n4 6.3515
R1054 r4.n4 r4.n3 4.88403
R1055 r4.n3 r4.t4 39.215
R1056 r4.n3 r4.t5 39.0255
R1057 r4.n4 r4.n2 6.62576
R1058 r4.n2 r4.t6 58.7685
R1059 r4.n2 r4.t7 58.5791
R1060 r5.n0 r5.t3 0.607167
R1061 r5.n0 r5.t2 0.607167
R1062 r5.n1 r5.n0 7.82634
R1063 r5.n8 r5.n1 4.5005
R1064 r5.n1 r5.n9 8.49966
R1065 r5.n9 r5.t0 1.0925
R1066 r5.n9 r5.t1 1.0925
R1067 r5.n8 r5.n7 5.8685
R1068 r5.n7 r5.n6 5.12403
R1069 r5.n6 r5.t4 45.7328
R1070 r5.n6 r5.t5 45.5434
R1071 r5.n7 r5.n5 6.38576
R1072 r5.n5 r5.t8 45.7328
R1073 r5.n5 r5.t9 45.5434
R1074 r5 r5.n8 0.5945
R1075 r5 r5.n4 6.4925
R1076 r5.n4 r5.n3 5.12403
R1077 r5.n3 r5.t6 39.215
R1078 r5.n3 r5.t7 39.0255
R1079 r5.n4 r5.n2 6.38576
R1080 r5.n2 r5.t11 58.5791
R1081 r5.n2 r5.t10 58.7685
R1082 r3.n0 r3.t2 0.607167
R1083 r3.n0 r3.t1 0.607167
R1084 r3.n1 r3.n0 7.82634
R1085 r3.n1 r3.n5 8.49966
R1086 r3.n5 r3.t0 1.0925
R1087 r3.n5 r3.t3 1.0925
R1088 r3 r3.n1 6.0245
R1089 r3 r3.n4 6.0245
R1090 r3.n4 r3.n3 5.12403
R1091 r3.n3 r3.t4 39.215
R1092 r3.n3 r3.t5 39.0255
R1093 r3.n4 r3.n2 6.38576
R1094 r3.n2 r3.t6 58.7685
R1095 r3.n2 r3.t7 58.5791
R1096 r1.t0 r1.n0 0.607167
R1097 r1.n0 r1.t1 0.607167
R1098 r1.n1 r1.n0 7.58634
R1099 r1.n5 r1.n1 4.5005
R1100 r1.n1 r1.n6 8.73966
R1101 r1.n6 r1.t2 1.0925
R1102 r1.n6 r1.t3 1.0925
R1103 r1.n5 r1.t4 23.5268
R1104 r1 r1.n5 0.9395
R1105 r1 r1.n4 7.1735
R1106 r1.n4 r1.n3 5.36403
R1107 r1.n3 r1.t5 39.215
R1108 r1.n3 r1.t6 39.0255
R1109 r1.n4 r1.n2 6.14576
R1110 r1.n2 r1.t8 58.5791
R1111 r1.n2 r1.t7 58.7685
R1112 r2.t0 r2.n0 0.607167
R1113 r2.n0 r2.t3 0.607167
R1114 r2.n1 r2.n0 8.06634
R1115 r2.n1 r2.n5 8.25966
R1116 r2.n5 r2.t1 1.0925
R1117 r2.n5 r2.t2 1.0925
R1118 r2 r2.n1 5.4635
R1119 r2 r2.n4 5.4695
R1120 r2.n4 r2.n3 4.88403
R1121 r2.n3 r2.t4 39.215
R1122 r2.n3 r2.t5 39.0255
R1123 r2.n4 r2.n2 6.62576
R1124 r2.n2 r2.t7 58.5791
R1125 r2.n2 r2.t6 58.7685
R1126 a_7946_2036.t1 a_7946_2036.n3 6.95759
R1127 a_7946_2036.n1 a_7946_2036.n3 0.167
R1128 a_7946_2036.n3 a_7946_2036.t4 13.887
R1129 a_7946_2036.n2 a_7946_2036.n1 6.24309
R1130 a_7946_2036 a_7946_2036.n2 0.537167
R1131 a_7946_2036.n2 a_7946_2036.t0 0.9805
R1132 a_7946_2036.n1 a_7946_2036.n0 6.20245
R1133 a_7946_2036.n0 a_7946_2036.t3 0.3645
R1134 a_7946_2036.n0 a_7946_2036.t2 0.3645
R1135 a_6390_2036.t3 a_6390_2036.n3 6.95759
R1136 a_6390_2036.n1 a_6390_2036.n3 0.167
R1137 a_6390_2036.n3 a_6390_2036.t4 13.887
R1138 a_6390_2036.n2 a_6390_2036.n1 6.24309
R1139 a_6390_2036 a_6390_2036.n2 0.537167
R1140 a_6390_2036.n2 a_6390_2036.t2 0.9805
R1141 a_6390_2036.n1 a_6390_2036.n0 6.20245
R1142 a_6390_2036.n0 a_6390_2036.t1 0.3645
R1143 a_6390_2036.n0 a_6390_2036.t0 0.3645
R1144 a_5270_2036.t3 a_5270_2036.n3 6.95759
R1145 a_5270_2036.n1 a_5270_2036.n3 0.167
R1146 a_5270_2036.n3 a_5270_2036.t4 13.887
R1147 a_5270_2036.n2 a_5270_2036.n1 6.24309
R1148 a_5270_2036 a_5270_2036.n2 0.537167
R1149 a_5270_2036.n2 a_5270_2036.t2 0.9805
R1150 a_5270_2036.n1 a_5270_2036.n0 6.20245
R1151 a_5270_2036.n0 a_5270_2036.t1 0.3645
R1152 a_5270_2036.n0 a_5270_2036.t0 0.3645
R1153 a_4150_2036.t1 a_4150_2036.n3 6.95759
R1154 a_4150_2036.n1 a_4150_2036.n3 0.167
R1155 a_4150_2036.n3 a_4150_2036.t4 13.887
R1156 a_4150_2036.n2 a_4150_2036.n1 6.24309
R1157 a_4150_2036 a_4150_2036.n2 0.537167
R1158 a_4150_2036.n2 a_4150_2036.t0 0.9805
R1159 a_4150_2036.n1 a_4150_2036.n0 6.20245
R1160 a_4150_2036.n0 a_4150_2036.t3 0.3645
R1161 a_4150_2036.n0 a_4150_2036.t2 0.3645
R1162 a_3030_2036.t1 a_3030_2036.n3 6.95759
R1163 a_3030_2036.n1 a_3030_2036.n3 0.167
R1164 a_3030_2036.n3 a_3030_2036.t4 13.887
R1165 a_3030_2036.n2 a_3030_2036.n1 6.24309
R1166 a_3030_2036 a_3030_2036.n2 0.537167
R1167 a_3030_2036.n2 a_3030_2036.t0 0.9805
R1168 a_3030_2036.n1 a_3030_2036.n0 6.20245
R1169 a_3030_2036.n0 a_3030_2036.t3 0.3645
R1170 a_3030_2036.n0 a_3030_2036.t2 0.3645
R1171 vi.n2 vi.t3 11.9519
R1172 vi vi.n0 6.16325
R1173 vi.n0 vi.n1 0.77
R1174 vi.n1 vi.n2 0.365
R1175 vi.n2 vi.t4 13.0544
R1176 vi.n1 vi.t1 11.9519
R1177 vi.n0 vi.t0 11.9519
R1178 vi vi.t2 22.8266
R1179 vnt.n5 vnt.t2 11.4119
R1180 vnt.n0 vnt.n5 0.77
R1181 vnt.n1 vnt.n0 0.77
R1182 vnt vnt.n1 5.01125
R1183 vnt vnt.n2 2.35175
R1184 vnt.n2 vnt.n3 1.49
R1185 vnt.n3 vnt.n4 1.9895
R1186 vnt.n4 vnt.t1 15.3768
R1187 vnt.n4 vnt.t6 13.8873
R1188 vnt.n3 vnt.t0 13.8873
R1189 vnt.n2 vnt.t7 13.8873
R1190 vnt.n1 vnt.t3 11.4119
R1191 vnt.n0 vnt.t5 11.4119
R1192 vnt.n5 vnt.t4 12.1814
R1193 vbn_vco.t2 vbn_vco.n0 11.9857
R1194 vbn_vco.n12 vbn_vco.n0 12.8075
R1195 vbn_vco vbn_vco.n11 27.4021
R1196 vbn_vco vbn_vco.n2 9.14337
R1197 vbn_vco.n2 vbn_vco.n12 0.36725
R1198 vbn_vco.n11 vbn_vco.n5 1.5845
R1199 vbn_vco.n5 vbn_vco.n7 1.6505
R1200 vbn_vco.n7 vbn_vco.n9 1.6505
R1201 vbn_vco.n9 vbn_vco.n10 11.7621
R1202 vbn_vco.n10 vbn_vco.t5 29.8501
R1203 vbn_vco.n10 vbn_vco.t6 29.6085
R1204 vbn_vco.n9 vbn_vco.n8 9.45808
R1205 vbn_vco.n8 vbn_vco.t7 29.8501
R1206 vbn_vco.n8 vbn_vco.t8 29.6085
R1207 vbn_vco.n7 vbn_vco.n6 9.45808
R1208 vbn_vco.n6 vbn_vco.t9 29.8501
R1209 vbn_vco.n6 vbn_vco.t10 29.6085
R1210 vbn_vco.n5 vbn_vco.n4 9.45808
R1211 vbn_vco.n4 vbn_vco.t11 29.8501
R1212 vbn_vco.n4 vbn_vco.t12 29.6085
R1213 vbn_vco.n11 vbn_vco.n3 9.50758
R1214 vbn_vco.n3 vbn_vco.t13 29.8501
R1215 vbn_vco.n3 vbn_vco.t14 29.6085
R1216 vbn_vco.n12 vbn_vco.t4 20.4215
R1217 vbn_vco.n2 vbn_vco.n1 10.6768
R1218 vbn_vco.n1 vbn_vco.t1 1.88813
R1219 vbn_vco.n1 vbn_vco.t0 44.5424
R1220 vbn_vco.n0 vbn_vco.t3 12.5842
R1221 vst.t0 vst.n0 13.8014
R1222 vst vst.n0 0.88925
R1223 vst vst.n2 1.1525
R1224 vst.n2 vst.n1 0.068
R1225 vst.n2 vst.t2 34.656
R1226 vst.n1 vst.t1 21.5195
R1227 vst.n1 vst.t4 15.367
R1228 vst.n0 vst.t3 13.0319
R1229 vbh.t1 vbh.n5 11.5919
R1230 vbh vbh.n5 2.03338
R1231 vbh vbh.n4 17.1489
R1232 vbh.n4 vbh.n1 0.0275
R1233 vbh.n1 vbh.n2 1.013
R1234 vbh.n2 vbh.n3 11.3292
R1235 vbh.n3 vbh.t5 1.83599
R1236 vbh.n3 vbh.t4 12.2744
R1237 vbh.n2 vbh.t6 22.039
R1238 vbh.n1 vbh.t7 22.039
R1239 vbh.n4 vbh.n0 11.1447
R1240 vbh.n0 vbh.t3 1.83599
R1241 vbh.n0 vbh.t2 12.2744
R1242 vbh.n5 vbh.t0 13.9004
R1243 vbl.t0 vbl.n2 12.7057
R1244 vbl.n1 vbl.n0 1.283
R1245 vbl.n2 vbl.n1 1.24475
R1246 vbl.n7 vbl.n2 12.0875
R1247 vbl.n4 vbl.n7 0.059
R1248 vbl vbl.n4 0.5765
R1249 vbl vbl.n5 0.419
R1250 vbl.n5 vbl.n6 12.812
R1251 vbl.n6 vbl.t7 3.47655
R1252 vbl.n6 vbl.t6 8.58548
R1253 vbl.n5 vbl.t8 19.8463
R1254 vbl.n4 vbl.t9 19.8463
R1255 vbl.n7 vbl.n3 12.596
R1256 vbl.n3 vbl.t5 3.47655
R1257 vbl.n3 vbl.t4 8.58548
R1258 vbl.n1 vbl.t3 11.5874
R1259 vbl.n0 vbl.t1 11.5874
R1260 vbl.n0 vbl.t2 13.9499
R1261 vbp_vco.t5 vbp_vco.n0 13.4144
R1262 vbp_vco vbp_vco.n16 25.4311
R1263 vbp_vco vbp_vco.n1 8.51563
R1264 vbp_vco.n1 vbp_vco.n0 1.66775
R1265 vbp_vco.n16 vbp_vco.n10 1.3445
R1266 vbp_vco.n10 vbp_vco.n12 1.6505
R1267 vbp_vco.n12 vbp_vco.n14 1.6505
R1268 vbp_vco.n14 vbp_vco.n15 11.7638
R1269 vbp_vco.n15 vbp_vco.t7 51.8961
R1270 vbp_vco.n15 vbp_vco.t8 51.6545
R1271 vbp_vco.n14 vbp_vco.n13 9.45982
R1272 vbp_vco.n13 vbp_vco.t9 51.8961
R1273 vbp_vco.n13 vbp_vco.t10 51.6545
R1274 vbp_vco.n12 vbp_vco.n11 9.45982
R1275 vbp_vco.n11 vbp_vco.t11 51.8961
R1276 vbp_vco.n11 vbp_vco.t12 51.6545
R1277 vbp_vco.n10 vbp_vco.n9 9.45982
R1278 vbp_vco.n9 vbp_vco.t13 51.8961
R1279 vbp_vco.n9 vbp_vco.t14 51.6545
R1280 vbp_vco.n16 vbp_vco.n8 9.73582
R1281 vbp_vco.n8 vbp_vco.t15 51.8961
R1282 vbp_vco.n8 vbp_vco.t16 51.6545
R1283 vbp_vco.n1 vbp_vco.n7 12.4475
R1284 vbp_vco.n4 vbp_vco.n3 0.6755
R1285 vbp_vco.n6 vbp_vco.n4 0.50675
R1286 vbp_vco.n7 vbp_vco.n6 0.00725
R1287 vbp_vco.n7 vbp_vco.t6 19.7932
R1288 vbp_vco.n6 vbp_vco.n5 10.1233
R1289 vbp_vco.n5 vbp_vco.t3 1.6447
R1290 vbp_vco.n5 vbp_vco.t2 51.9932
R1291 vbp_vco.n4 vbp_vco.t17 61.8952
R1292 vbp_vco.n3 vbp_vco.t18 61.8952
R1293 vbp_vco.n3 vbp_vco.n2 11.462
R1294 vbp_vco.n2 vbp_vco.t1 1.6447
R1295 vbp_vco.n2 vbp_vco.t0 51.9932
R1296 vbp_vco.n0 vbp_vco.t4 12.3119
R1297 vs.n0 vs.t1 11.5919
R1298 vs.n0 vs.t0 66.8035
R1299 vs vs.n0 0.352625
R1300 vs vs.t2 12.0093
R1301 vcl.t0 vcl.n2 13.2381
R1302 vcl.n1 vcl.n0 0.02075
R1303 vcl.n1 vcl.n2 0.74975
R1304 vcl vcl.n1 21.965
R1305 vcl vcl.t2 31.285
R1306 vcl.n2 vcl.t1 14.0076
R1307 vcl.n0 vcl.t4 13.2381
R1308 vcl.n0 vcl.t3 14.0076
R1309 up_b.t1 up_b.n0 14.6644
R1310 up_b up_b.t0 55.544
R1311 up_b up_b.n0 0.3605
R1312 up_b.n0 up_b.t2 56.2039
R1313 en_b.t1 en_b.n7 14.3044
R1314 en_b.n6 en_b.n7 5.19125
R1315 en_b.n4 en_b.n6 3.0875
R1316 en_b en_b.n4 18.9553
R1317 en_b en_b.n5 5.5055
R1318 en_b.n5 en_b.t3 38.4633
R1319 en_b.n5 en_b.t2 36.8133
R1320 en_b.n4 en_b.n1 8.4155
R1321 en_b.n1 en_b.n2 0.608
R1322 en_b.n2 en_b.n3 0.608
R1323 en_b.n3 en_b.t4 46.4256
R1324 en_b.n3 en_b.t5 44.6661
R1325 en_b.n2 en_b.t6 44.6661
R1326 en_b.n1 en_b.t7 44.6661
R1327 en_b.n6 en_b.n0 22.9888
R1328 en_b.n0 en_b.t0 25.3715
R1329 en_b.n0 en_b.t9 47.861
R1330 en_b.n7 en_b.t8 16.9751
R1331 t1c t1c.t0 19.0646
R1332 t1c t1c.t1 19.0646
R1333 vdump.t0 vdump.n8 15.849
R1334 vdump.n15 vdump.n9 4.5005
R1335 vdump.n4 vdump.n2 2.858
R1336 vdump.n6 vdump.n4 0.788
R1337 vdump.n9 vdump.n6 0.02975
R1338 vdump.n9 vdump.n7 3.27875
R1339 vdump.n7 vdump.n8 1.013
R1340 vdump.n14 vdump.n15 8.4875
R1341 vdump vdump.n12 1.73975
R1342 vdump vdump.n13 1.51475
R1343 vdump.n13 vdump.n14 0.47075
R1344 vdump.n14 vdump.t17 14.9516
R1345 vdump.n13 vdump.t16 14.4273
R1346 vdump.n12 vdump.n11 10.2695
R1347 vdump.n11 vdump.t4 1.68292
R1348 vdump.n11 vdump.t3 30.1453
R1349 vdump.n12 vdump.n10 11.039
R1350 vdump.n10 vdump.t2 1.68292
R1351 vdump.n10 vdump.t1 30.1453
R1352 vdump.n15 vdump.t15 45.2343
R1353 vdump.n8 vdump.t14 12.366
R1354 vdump.n7 vdump.t13 12.366
R1355 vdump.n6 vdump.n5 10.3032
R1356 vdump.n5 vdump.t8 1.6447
R1357 vdump.n5 vdump.t7 30.2254
R1358 vdump.n4 vdump.n3 10.3032
R1359 vdump.n3 vdump.t6 1.6447
R1360 vdump.n3 vdump.t5 30.2254
R1361 vdump.n2 vdump.n1 10.3032
R1362 vdump.n1 vdump.t12 1.6447
R1363 vdump.n1 vdump.t11 30.2254
R1364 vdump.n2 vdump.n0 11.0908
R1365 vdump.n0 vdump.t10 1.6447
R1366 vdump.n0 vdump.t9 30.2254
R1367 dn_b.t1 dn_b 18.3251
R1368 dn_b dn_b.n0 23.2587
R1369 dn_b.n0 dn_b.t0 25.2095
R1370 dn_b.n0 dn_b.t2 47.6205
R1371 vref.n12 vref.t2 12.9244
R1372 vref.n1 vref.n0 1.49
R1373 vref.n2 vref.n1 0.995
R1374 vref.n3 vref.n2 0.995
R1375 vref vref.n3 1.45963
R1376 vref vref.n4 0.030875
R1377 vref.n4 vref.n12 0.19625
R1378 vref.n12 vref.n7 0.02525
R1379 vref.n7 vref.n5 1.319
R1380 vref.n5 vref.n6 0.77
R1381 vref.n7 vref.n11 19.31
R1382 vref.n11 vref.t1 35.5713
R1383 vref.n11 vref.n8 14.1552
R1384 vref.n8 vref.n9 0.77
R1385 vref.n9 vref.n10 0.77
R1386 vref.n10 vref.t11 69.8502
R1387 vref.n10 vref.t12 69.0807
R1388 vref.n9 vref.t13 69.0807
R1389 vref.n8 vref.t14 69.0807
R1390 vref.n6 vref.t0 24.134
R1391 vref.n6 vref.t3 40.7382
R1392 vref.n5 vref.t4 40.7382
R1393 vref.n4 vref.t5 19.8463
R1394 vref.n3 vref.t6 19.8463
R1395 vref.n2 vref.t7 19.8463
R1396 vref.n1 vref.t8 19.8463
R1397 vref.n0 vref.t9 19.8463
R1398 vref.n0 vref.t10 20.8408
R1399 dn_s.t0 dn_s.n0 14.0665
R1400 dn_s dn_s.n0 1.7285
R1401 dn_s dn_s.n1 2.021
R1402 dn_s.n1 dn_s.t1 18.7743
R1403 dn_s.n1 dn_s.t3 17.6223
R1404 dn_s.n0 dn_s.t2 12.622
R1405 t1b t1b.t0 20.6857
R1406 t1b t1b.n0 24.7359
R1407 t1b.n0 t1b.t1 38.3693
R1408 t1b.n0 t1b.t2 23.1052
R1409 va.t0 va 23.6143
R1410 va.n0 va.n1 0.0095
R1411 va va.n0 0.55175
R1412 va.n1 va.t2 68.535
R1413 va.n0 va.t3 36.4132
R1414 va.n1 va.t1 17.4806
R1415 t1a t1a.t1 18.5032
R1416 t1a t1a.n0 23.8134
R1417 t1a.n0 t1a.t0 39.7687
R1418 t1a.n0 t1a.t2 22.3177
R1419 t2 t2.t1 20.8094
R1420 t2 t2.n1 26.2996
R1421 t2.n1 t2.n0 0.00725
R1422 t2.n1 t2.t0 34.8233
R1423 t2.n0 t2.t2 22.671
R1424 t2.n0 t2.t3 28.7235
R1425 vcp_n.t3 vcp_n.n0 2.56676
R1426 vcp_n.n0 vcp_n.t2 20.9799
R1427 vcp_n.n13 vcp_n.n0 9.69575
R1428 vcp_n.n3 vcp_n.n2 1.94
R1429 vcp_n.n4 vcp_n.n3 1.445
R1430 vcp_n.n5 vcp_n.n4 1.94
R1431 vcp_n vcp_n.n5 0.44825
R1432 vcp_n vcp_n.n13 0.8285
R1433 vcp_n.n13 vcp_n.n9 1.77575
R1434 vcp_n.n9 vcp_n.n6 0.64175
R1435 vcp_n.n6 vcp_n.n7 0.608
R1436 vcp_n.n7 vcp_n.n8 1.2155
R1437 vcp_n.n9 vcp_n.n12 23.6525
R1438 vcp_n.n12 vcp_n.n10 0.05225
R1439 vcp_n.n12 vcp_n.n11 8.02625
R1440 vcp_n.n11 vcp_n.t8 25.011
R1441 vcp_n.n11 vcp_n.t11 22.491
R1442 vcp_n.n10 vcp_n.t9 22.491
R1443 vcp_n.n10 vcp_n.t10 25.011
R1444 vcp_n.n8 vcp_n.t6 25.1533
R1445 vcp_n.n8 vcp_n.t4 17.2623
R1446 vcp_n.n7 vcp_n.t5 17.2623
R1447 vcp_n.n6 vcp_n.t7 17.2623
R1448 vcp_n.n5 vcp_n.t12 30.5283
R1449 vcp_n.n4 vcp_n.t13 30.5283
R1450 vcp_n.n3 vcp_n.t14 30.5283
R1451 vcp_n.n2 vcp_n.t15 30.5283
R1452 vcp_n.n2 vcp_n.n1 11.309
R1453 vcp_n.n1 vcp_n.t1 2.56676
R1454 vcp_n.n1 vcp_n.t0 20.9799
R1455 vbt.n9 vbt.t5 11.4074
R1456 vbt.n1 vbt.n0 0.788
R1457 vbt.n2 vbt.n1 0.788
R1458 vbt vbt.n2 0.64175
R1459 vbt vbt.n3 0.64175
R1460 vbt.n3 vbt.n4 0.788
R1461 vbt.n4 vbt.n9 0.788
R1462 vbt.n9 vbt.n5 0.26375
R1463 vbt.n5 vbt.n6 42.9665
R1464 vbt.n6 vbt.n7 2.0255
R1465 vbt.n7 vbt.n8 10.598
R1466 vbt.n8 vbt.t1 24.831
R1467 vbt.n8 vbt.t0 22.311
R1468 vbt.n7 vbt.t6 22.311
R1469 vbt.n6 vbt.t11 22.311
R1470 vbt.n5 vbt.t10 11.9317
R1471 vbt.n4 vbt.t4 11.4074
R1472 vbt.n3 vbt.t9 11.4074
R1473 vbt.n2 vbt.t8 11.4074
R1474 vbt.n1 vbt.t3 11.4074
R1475 vbt.n0 vbt.t2 11.4074
R1476 vbt.n0 vbt.t7 12.1949
R1477 vbp.t1 vbp.n0 13.6241
R1478 vbp vbp.n0 1.22
R1479 vbp.n0 vbp.n15 7.5875
R1480 vbp.n15 vbp.n14 35.7508
R1481 vbp.n15 vbp.t4 23.7892
R1482 vbp.n2 vbp.n1 1.013
R1483 vbp.n3 vbp.n2 1.508
R1484 vbp.n4 vbp.n3 1.013
R1485 vbp.n5 vbp.n4 1.013
R1486 vbp.n7 vbp.n5 1.33925
R1487 vbp.n8 vbp.n7 1.18175
R1488 vbp.n14 vbp.n8 0.1985
R1489 vbp.n14 vbp.n9 0.815
R1490 vbp.n9 vbp.n10 1.508
R1491 vbp.n10 vbp.n11 1.013
R1492 vbp.n11 vbp.n12 1.013
R1493 vbp.n12 vbp.n13 1.508
R1494 vbp.n13 vbp.t5 33.1765
R1495 vbp.n13 vbp.t6 32.164
R1496 vbp.n12 vbp.t7 32.164
R1497 vbp.n11 vbp.t8 32.164
R1498 vbp.n10 vbp.t9 32.164
R1499 vbp.n9 vbp.t10 32.164
R1500 vbp.n8 vbp.t11 32.164
R1501 vbp.n7 vbp.n6 20.1155
R1502 vbp.n6 vbp.t3 1.83599
R1503 vbp.n6 vbp.t2 12.2744
R1504 vbp.n5 vbp.t12 32.164
R1505 vbp.n4 vbp.t13 32.164
R1506 vbp.n3 vbp.t14 32.164
R1507 vbp.n2 vbp.t15 32.164
R1508 vbp.n1 vbp.t16 32.164
R1509 vbp.n1 vbp.t17 33.1765
R1510 vbp vbp.t0 25.0362
R1511 up_s.t0 up_s.n1 15.8608
R1512 up_s.n0 up_s.n1 48.785
R1513 up_s up_s.n0 0.29525
R1514 up_s up_s.t1 12.1635
R1515 up_s.n0 up_s.t3 11.8687
R1516 up_s.n1 up_s.t2 17.8183
R1517 vcp_p.t5 vcp_p.n0 5.96191
R1518 vcp_p.n0 vcp_p.t4 48.3696
R1519 vcp_p.n4 vcp_p.n0 10.9276
R1520 vcp_p.n3 vcp_p.n2 1.958
R1521 vcp_p.n4 vcp_p.n3 0.086
R1522 vcp_p.n6 vcp_p.n5 4.5005
R1523 vcp_p.n6 vcp_p.n4 18.4325
R1524 vcp_p vcp_p.n6 26.6686
R1525 vcp_p vcp_p.t6 24.7444
R1526 vcp_p.n5 vcp_p.t1 15.5223
R1527 vcp_p.n5 vcp_p.t0 14.6853
R1528 vcp_p.n3 vcp_p.t7 57.9578
R1529 vcp_p.n2 vcp_p.t8 57.9578
R1530 vcp_p.n2 vcp_p.n1 11.3506
R1531 vcp_p.n1 vcp_p.t3 5.96191
R1532 vcp_p.n1 vcp_p.t2 48.3696
C0 pfd_dn t1a 0.36183f
C1 a_13800_12030 vref 0.00808f
C2 vdump a_400_12030 0
C3 vbn_vco r4 0.11395f
C4 va vcp_n 0.12988f
C5 vbn_vco r1 0.03796f
C6 t1b vbt 0.09995f
C7 t1c t1b 0.91825f
C8 en_b va 4.37665f
C9 pfd_dn vcp_p 0.18241f
C10 pll_en a_5270_2036 0.03683f
C11 r2 r4 0.00641f
C12 r2 r1 0.46234f
C13 a_13800_12030 a_12600_12030 0.00585f
C14 vnt vbp_vco 0.0425f
C15 pfd_up up_s 0.42282f
C16 vi vref 0.84329f
C17 nb vdd 1.43755f
C18 cp_trim0 t1a 2.47471f
C19 a_12000_19482 a_10800_19482 0.00585f
C20 vctrl dn_s 0.67761f
C21 a_7946_2036 r4 0.09942f
C22 vdump pfd_up 0.42417f
C23 dn_b pll_en 0.12005f
C24 s1 dqn 1.16744f
C25 vs a_14400_19482 0.00168f
C26 a_7946_2036 r1 0.01161f
C27 m1 s1 0.57846f
C28 nb vco_out 1.51394f
C29 vnt bias_ref 0.09245f
C30 mf ck 0.17626f
C31 pfd_dn t1b 0.03173f
C32 a_7950_0 en_b 0
C33 cp_trim1 vbp 0.17454f
C34 vi vbn_vco 2.5123f
C35 en_b a_14400_19482 0.00958f
C36 vbp_vco r3 0.03332f
C37 up_b a_7800_18162 0.00138f
C38 vctrl vst 0.13997f
C39 vbh vdd 5.75774f
C40 a_7950_0 r5 0.12206f
C41 a_6390_2036 vdd 1.07019f
C42 vnt va 0.49711f
C43 a_6394_0 en_b 0.00158f
C44 cp_trim0 t1b 2.27605f
C45 vctrl up_b 0.44052f
C46 pll_en sf 0.09209f
C47 a_10800_19482 vref 0.00106f
C48 vs vbt 0.03937f
C49 t1c vs 0
C50 a_3030_2036 a_4150_2036 0.09903f
C51 cp_trim1 vdd 5.01814f
C52 vdump up_s 0.25077f
C53 dn_b vbp 0.03008f
C54 vbl vbp_vco 0.84564f
C55 a_6394_0 r5 0.07005f
C56 vbh vref 0.14046f
C57 vbt vcp_n 2.90941f
C58 a_5270_2036 vdd 0.97704f
C59 a_13800_12030 vcp_p 0
C60 t1c vcp_n 0.66125f
C61 dn_b a_12000_19482 0.00284f
C62 pll_en vbp 0.6978f
C63 en_b m1 0.01066f
C64 a_10200_12030 a_8400_12030 0.00234f
C65 vctrl vbp_vco 0.21294f
C66 pfd_up vst 0.23995f
C67 cp_trim1 vref 0.01212f
C68 vi vcp_p 0
C69 nb a_7946_2036 0.02328f
C70 bias_ref a_7800_18162 0.00948f
C71 clkb dqn 0.1328f
C72 dn_b vdd 3.94571f
C73 dqb ck 0.00113f
C74 m1 clkb 0.4232f
C75 vfilt vctrl 6.27092f
C76 pfd_dn vs 0.13846f
C77 vcl a_10800_19482 0.00132f
C78 vbh vbn_vco 0.11461f
C79 pfd_up up_b 1.40285f
C80 dqb vco_div2 0.55309f
C81 m2 s1 0.35403f
C82 up_s dn_s 0.00854f
C83 vctrl bias_ref 0.11786f
C84 pll_en vdd 8.84735f
C85 pfd_dn vcp_n 1.18138f
C86 pfd_dn en_b 0.34289f
C87 dn_b vref 0.18961f
C88 vdump dn_s 1.55454f
C89 cp_trim0 vs 0.00101f
C90 pll_en vco_out 0.28488f
C91 en_b a_15000_12030 0
C92 dn_b a_12600_12030 0.01151f
C93 cp_trim1 vcl 0.00205f
C94 a_5274_0 a_6394_0 0.06004f
C95 pfd_up vbp_vco 0.81225f
C96 a_5270_2036 r2 0
C97 a_6390_2036 a_7946_2036 0.02632f
C98 pll_en vref 2.29556f
C99 cp_trim0 vcp_n 0.94079f
C100 sf vdd 0.2201f
C101 cp_trim0 en_b 0.1122f
C102 vctrl va 1.44134f
C103 pfd_up t2 0.23452f
C104 a_6394_0 r3 0
C105 up_s up_b 0.34837f
C106 dn_b vbn_vco 0
C107 pfd_up bias_ref 0.00772f
C108 dn_b a_13200_19482 0
C109 vbh vcp_p 0.00553f
C110 vbp vdd 46.0855f
C111 vdump up_b 0.28572f
C112 dn_b vcl 0.04248f
C113 pll_en vbn_vco 0.2616f
C114 en_b r4 0.17656f
C115 pll_en a_13200_19482 0.00194f
C116 a_12000_19482 vdd 0
C117 en_b r1 0.32185f
C118 en_b m2 0
C119 pll_en r2 0.07323f
C120 cp_trim1 t1a 1.08985f
C121 a_7950_0 vctrl 0
C122 a_4150_2036 vbp_vco 0.41367f
C123 pll_en vcl 0.07894f
C124 up_s vbp_vco 0
C125 mf m1 0.83048f
C126 r5 r4 0.77138f
C127 vbp vref 0.98094f
C128 m2 clkb 0.64549f
C129 pfd_up va 0.03832f
C130 r1 r5 0.72005f
C131 up_s t2 0.25835f
C132 vfilt up_s 0.05371f
C133 pll_en a_7946_2036 0.03702f
C134 a_12000_19482 vref 0.00106f
C135 en_b a_13800_12030 0.01082f
C136 vdump vbp_vco 0.09756f
C137 vi vs 0.49461f
C138 a_6600_18162 vref 0.00948f
C139 a_6394_0 vctrl 0.0342f
C140 a_3030_2036 vbp_vco 0.45398f
C141 up_s bias_ref 0.34081f
C142 vbl vbt 2.05293f
C143 vco_out vdd 1.7699f
C144 vdump t2 0.0032f
C145 dn_b t1a 0.79411f
C146 up_b dn_s 0.18288f
C147 vdump vfilt 0.09325f
C148 dn_b vcp_p 0.05682f
C149 vfilt a_1200_19662 0.00928f
C150 en_b vi 0.22449f
C151 vbp vbn_vco 0.08074f
C152 vdd vref 3.71994f
C153 cp_trim1 t1b 2.28634f
C154 vdump bias_ref 0.06209f
C155 vctrl vbt 1.41992f
C156 pll_en vcp_p 0.37978f
C157 a_12600_12030 vdd 0.02393f
C158 vbp vcl 0.05166f
C159 a_12000_19482 a_13200_19482 0.00585f
C160 vcp_p a_8400_12030 0.00353f
C161 a_12000_19482 vcl 0.00132f
C162 en_b nb 0.34565f
C163 vbn_vco vdd 2.13975f
C164 a_19434_n100 ck 0
C165 vdd a_13200_19482 0.03701f
C166 dn_b t1b 0.51245f
C167 a_5274_0 r4 0.13493f
C168 dqb dqn 0.2408f
C169 a_12600_12030 vref 0
C170 a_5274_0 r1 0.0129f
C171 r2 vdd 0.38745f
C172 nb clkb 0.00195f
C173 vfilt dn_s 0.05361f
C174 vs a_10800_19482 0.00168f
C175 nb r5 0.59886f
C176 vcl vdd 0.10915f
C177 bias_ref dn_s 0.00202f
C178 pll_en t1b 0.0016f
C179 pfd_dn vctrl 0.92283f
C180 r3 r4 0.39123f
C181 a_6000_12030 a_4200_12030 0.00234f
C182 r1 r3 0.32275f
C183 vbp t1a 4.27593f
C184 m2 mf 0.35977f
C185 t1c pfd_up 0.07192f
C186 vst vbp_vco 0.16277f
C187 a_4154_0 r4 0.01031f
C188 vnt vi 0.03911f
C189 vcp_p vbp 0.02752f
C190 vbn_vco vref 0.41621f
C191 a_4154_0 r1 0.07128f
C192 vref a_13200_19482 0.0141f
C193 a_7946_2036 vdd 1.10603f
C194 vcp_p a_10200_12030 0
C195 pll_en s1 0.28098f
C196 up_b vbp_vco 0
C197 vcl vref 5.14018f
C198 en_b a_6390_2036 0.00139f
C199 cp_trim1 vs 0.00101f
C200 vco_out a_7946_2036 0
C201 up_b t2 0.05572f
C202 vdd t1a 4.68857f
C203 a_9070_n100 bias_ref 0.01945f
C204 cp_trim1 vcp_n 1.88173f
C205 en_b cp_trim1 0.40766f
C206 a_6390_2036 r5 0.10254f
C207 up_b bias_ref 0.68204f
C208 vco_div2 ck 0
C209 vcp_p vdd 20.5658f
C210 sf s1 0.47236f
C211 r2 vbn_vco 0.21171f
C212 pfd_dn pfd_up 0.54147f
C213 en_b a_5270_2036 0.00139f
C214 vbp t1b 3.35215f
C215 vcp_p a_6000_12030 0.00353f
C216 up_s vbt 1.39825f
C217 vctrl r4 0.06992f
C218 t1c up_s 0.00229f
C219 vcl a_13200_19482 0.00132f
C220 vctrl r1 0.08911f
C221 dn_b vs 0.04645f
C222 va vst 0.16091f
C223 a_15000_12030 pfd_up 0
C224 vref t1a 0.00602f
C225 a_5270_2036 r5 0.00645f
C226 vcp_p vref 0.11152f
C227 cp_trim0 pfd_up 0.02536f
C228 vdump vbt 4.9792f
C229 dn_b vcp_n 0.13739f
C230 pll_en vs 0.31859f
C231 dn_b en_b 0.04506f
C232 vfilt t2 0.02118f
C233 bias_ref vbp_vco 0.05372f
C234 a_12600_12030 vcp_p 0.00216f
C235 vnt vbh 1.9816f
C236 vi vbl 0.01838f
C237 t1b vdd 5.51706f
C238 pll_en vcp_n 0.03594f
C239 en_b pll_en 4.27157f
C240 pfd_dn up_s 0.04178f
C241 vdd s1 0.5526f
C242 pll_en clkb 0.65905f
C243 vcp_p vbn_vco 0
C244 vi vctrl 3.65471f
C245 pll_en r5 0.22857f
C246 va vbp_vco 0.03058f
C247 a_7950_0 a_9070_n100 0.01912f
C248 vcl t1a 0
C249 t1b vref 0.0064f
C250 vcp_p a_4200_12030 0.01578f
C251 vdump pfd_dn 0.08449f
C252 vcp_p vcl 0.1141f
C253 vco_out s1 0.00538f
C254 va t2 0.12917f
C255 vbt dn_s 0.06708f
C256 a_11400_12030 a_10200_12030 0.00585f
C257 vfilt va 0.00802f
C258 cp_trim0 up_s 0.07859f
C259 vbp vs 0.04866f
C260 a_6390_2036 r3 0
C261 sf clkb 0.18664f
C262 va bias_ref 0.00875f
C263 a_13800_12030 pfd_up 0
C264 a_12000_19482 vs 0.00168f
C265 vbp vcp_n 9.05131f
C266 en_b vbp 4.7509f
C267 vdump cp_trim0 0
C268 a_19434_n100 dqn 0.0773f
C269 a_5270_2036 r3 0.09942f
C270 a_4150_2036 r4 0.01183f
C271 pll_en vnt 0.00499f
C272 pfd_up vi 0
C273 a_4150_2036 r1 0.09967f
C274 vbl vbh 0.19431f
C275 vcl t1b 0
C276 vs vdd 0.41208f
C277 pfd_dn dn_s 0.22459f
C278 t1c up_b 0.07486f
C279 vcp_n vdd 8.88903f
C280 en_b vdd 5.75542f
C281 a_5274_0 pll_en 0
C282 vbh vctrl 2.66101f
C283 a_3030_2036 r1 0.00645f
C284 a_6390_2036 vctrl 0.05595f
C285 clkb vdd 1.15559f
C286 a_5270_2036 vbl 0
C287 a_11400_12030 a_12600_12030 0.00585f
C288 vs vref 0.11514f
C289 pll_en r3 0.11467f
C290 en_b vco_out 0.29669f
C291 vdd r5 0.75365f
C292 pll_en mf 0.08586f
C293 pfd_dn vst 0
C294 vbt vbp_vco 0.00234f
C295 a_4154_0 pll_en 0
C296 vcp_n vref 0.18977f
C297 t1b t1a 0.19091f
C298 ck dqn 0.2334f
C299 en_b vref 1.04536f
C300 vco_out clkb 0.5187f
C301 vi up_s 0
C302 vnt vbp 0.00172f
C303 ck m1 0.5064f
C304 pfd_dn up_b 0.15902f
C305 a_5270_2036 vctrl 0.05307f
C306 vco_div2 dqn 0.00542f
C307 vbt t2 0.26147f
C308 vco_out r5 0
C309 t1c t2 0.0696f
C310 va a_14400_19482 0
C311 vfilt vbt 0.31939f
C312 vs vbn_vco 0.32435f
C313 a_3034_0 r1 0
C314 vdump vi 0
C315 vs a_13200_19482 0.00168f
C316 pfd_up vbh 0.0087f
C317 cp_trim0 up_b 0.55981f
C318 vs vcl 2.759f
C319 dn_b vctrl 0.00356f
C320 en_b vbn_vco 0.74632f
C321 en_b a_13200_19482 0
C322 vnt vdd 0.39588f
C323 en_b r2 0.06225f
C324 pfd_dn vbp_vco 0.12142f
C325 vcl vcp_n 0.05999f
C326 pll_en vctrl 0.47722f
C327 pfd_up cp_trim1 0.14767f
C328 en_b vcl 0.0478f
C329 pfd_dn t2 0.07501f
C330 vbn_vco r5 0.02255f
C331 vctrl a_8400_12030 0
C332 va vbt 0.09992f
C333 a_5274_0 vdd 0
C334 a_8400_12030 a_7200_12030 0.00585f
C335 a_9070_n100 r4 0
C336 up_s a_10800_19482 0.00919f
C337 pfd_dn bias_ref 0
C338 en_b a_7946_2036 0.00139f
C339 vnt vref 1.62716f
C340 pll_en dqb 0.1032f
C341 a_11400_12030 vcp_p 0.00121f
C342 a_6394_0 a_7950_0 0.01441f
C343 cp_trim0 t2 1.98411f
C344 r3 vdd 0.38394f
C345 vs t1a 0
C346 vbh up_s 0.01329f
C347 mf vdd 0.19048f
C348 a_7946_2036 r5 0.25376f
C349 vcp_p vs 0.12674f
C350 dn_b pfd_up 1.33455f
C351 a_4154_0 vdd 0
C352 vcp_n t1a 0.73828f
C353 vcp_p vcp_n 3.15736f
C354 dqb sf 0.00334f
C355 vdump vbh 0.96545f
C356 m2 ck 0.12665f
C357 en_b vcp_p 0.00834f
C358 pfd_dn va 0.11676f
C359 pfd_up pll_en 1.53565f
C360 vi vst 0.14014f
C361 cp_trim1 up_s 0.19872f
C362 vctrl vbp 0.1243f
C363 vnt vbn_vco 0.03937f
C364 a_6600_18162 a_7800_18162 0.00585f
C365 vbp_vco r4 0.01988f
C366 vbp_vco r1 0.02886f
C367 a_5270_2036 a_4150_2036 0.09903f
C368 vctrl a_10200_12030 0
C369 vbl vdd 1.94154f
C370 vi up_b 0
C371 vctrl a_6600_18162 0.00648f
C372 vbl a_6000_12030 0
C373 a_5274_0 vbn_vco 0.30737f
C374 cp_trim0 va 0.02926f
C375 vs t1b 0
C376 a_5274_0 r2 0
C377 vctrl vdd 5.53662f
C378 dn_b up_s 0.07292f
C379 a_4200_12030 a_2000_12030 0.00234f
C380 t1b vcp_n 0.17251f
C381 vbn_vco r3 0.1194f
C382 en_b t1b 0.18362f
C383 a_9070_n100 nb 0.31943f
C384 vbl vref 0.02984f
C385 pfd_dn a_14400_19482 0.00273f
C386 vctrl a_6000_12030 0.01456f
C387 r2 r3 0.67669f
C388 pll_en a_4150_2036 0.03681f
C389 a_4154_0 vbn_vco 0.3124f
C390 vi vbp_vco 1.02453f
C391 pfd_up vbp 0.12089f
C392 a_6000_12030 a_7200_12030 0.00585f
C393 a_4154_0 r2 0.12529f
C394 dn_b vdump 0.99137f
C395 dqb vdd 0.57298f
C396 en_b s1 0.0215f
C397 vctrl vref 0.59475f
C398 a_12000_19482 pfd_up 0.01405f
C399 vdump pll_en 0
C400 pll_en a_3030_2036 0.01853f
C401 vi bias_ref 0.05372f
C402 clkb s1 0.57292f
C403 vdump a_8400_12030 0
C404 vbl vbn_vco 0.20194f
C405 pfd_up vdd 2.24647f
C406 vcp_p a_2000_12030 0
C407 vbl a_4200_12030 0
C408 vbh up_b 0.01639f
C409 a_13800_12030 va 0.00822f
C410 pfd_dn t1c 0.0696f
C411 vctrl vbn_vco 0.53075f
C412 dn_b dn_s 0.03228f
C413 a_7950_0 r4 0.0725f
C414 nb bias_ref 0.18778f
C415 a_7950_0 r1 0
C416 up_s vbp 1.13572f
C417 vi va 0.0334f
C418 up_s a_10200_12030 0.00295f
C419 vctrl a_4200_12030 0
C420 cp_trim1 up_b 0.50793f
C421 vctrl vcl 0.09988f
C422 pfd_up vref 0.21781f
C423 cp_trim0 vbt 0.03026f
C424 a_12000_19482 up_s 0
C425 vs vcp_n 0.01347f
C426 cp_trim0 t1c 1.84562f
C427 en_b vs 0.30382f
C428 vdump vbp 0
C429 a_6394_0 r4 0.01261f
C430 vbh vbp_vco 0.10759f
C431 a_12600_12030 pfd_up 0.00487f
C432 vdump a_10200_12030 0
C433 vctrl a_7946_2036 0
C434 a_6394_0 r1 0.11445f
C435 a_19434_n100 pll_en 0.01495f
C436 a_6390_2036 vbp_vco 0.40557f
C437 en_b vcp_n 1.05507f
C438 bias_ref a_10800_19482 0.01549f
C439 a_4150_2036 vdd 0.97689f
C440 up_s vdd 6.57914f
C441 vbl vcp_p 0.00207f
C442 en_b clkb 0.34732f
C443 dn_b up_b 0.27667f
C444 vbh bias_ref 0.1458f
C445 pfd_up vbn_vco 0.12249f
C446 pll_en vst 0.23846f
C447 pfd_dn a_15000_12030 0.01298f
C448 en_b r5 0.24773f
C449 cp_trim1 t2 4.15236f
C450 a_9070_n100 pll_en 0.09165f
C451 vdump vdd 4.18707f
C452 a_5270_2036 vbp_vco 0.4083f
C453 cp_trim0 pfd_dn 0.065f
C454 vcp_p vctrl 0.49598f
C455 vfilt cp_trim1 0.04531f
C456 a_3030_2036 vdd 1.00205f
C457 a_19434_n100 sf 0
C458 pll_en up_b 0.0041f
C459 pfd_up vcl 0.04783f
C460 vdump a_6000_12030 0.00304f
C461 mf s1 0.43955f
C462 m2 dqn 0
C463 up_b a_8400_12030 0.00454f
C464 vbp dn_s 0
C465 m2 m1 0.39614f
C466 up_s vref 0.05808f
C467 vcp_p a_7200_12030 0.00353f
C468 a_7950_0 nb 0.00696f
C469 dn_b vbp_vco 0
C470 vdump vref 0.04695f
C471 pll_en ck 0.20659f
C472 dn_b t2 0.08888f
C473 pll_en vco_div2 0.07512f
C474 a_4150_2036 vbn_vco 0.00819f
C475 pll_en vbp_vco 1.25046f
C476 en_b vnt 0
C477 a_3034_0 vdd 0
C478 vbp vst 0.75192f
C479 up_s vbn_vco 0
C480 r2 a_4150_2036 0.24979f
C481 cp_trim1 va 0.18546f
C482 vdd dn_s 0.00516f
C483 pll_en t2 0.08149f
C484 dn_b bias_ref 0
C485 pfd_up t1a 0.01691f
C486 pfd_up vcp_p 0.23624f
C487 up_s vcl 0.04166f
C488 vbp up_b 0.01037f
C489 sf ck 0.08075f
C490 vdump vbn_vco 0.6759f
C491 a_19434_n100 vdd 0
C492 a_10200_12030 up_b 0.00727f
C493 pll_en bias_ref 0.06863f
C494 a_3030_2036 vbn_vco 0.07013f
C495 a_5274_0 en_b 0.01502f
C496 vco_div2 sf 0
C497 pfd_dn a_13800_12030 0.00557f
C498 r2 a_3030_2036 0.11202f
C499 dn_s vref 0.01204f
C500 vdump a_4200_12030 0.00235f
C501 vdump vcl 0.06857f
C502 vst vdd 1.24969f
C503 en_b r3 0.16562f
C504 dn_b va 0.01547f
C505 a_5274_0 r5 0.0029f
C506 dqb s1 0.0125f
C507 a_15000_12030 a_13800_12030 0.00585f
C508 pfd_dn vi 0
C509 a_9070_n100 vdd 0
C510 a_4154_0 en_b 0.01355f
C511 up_b vdd 1.27424f
C512 vbp vbp_vco 0.08159f
C513 mf clkb 0.08644f
C514 pll_en va 4.87073f
C515 pfd_up t1b 0
C516 r1 r4 0.3206f
C517 r3 r5 0.00322f
C518 vbp t2 4.66024f
C519 up_s t1a 0.1329f
C520 a_9070_n100 vco_out 0.01023f
C521 a_3034_0 vbn_vco 0.30995f
C522 vst vref 1.11672f
C523 vcp_p up_s 4.63699f
C524 vfilt vbp 0.54035f
C525 a_3034_0 r2 0.08212f
C526 a_11400_12030 vctrl 0
C527 vbh vbt 0
C528 ck vdd 1.03623f
C529 vdump t1a 0.0417f
C530 vcl dn_s 0.00743f
C531 up_b vref 0.07501f
C532 a_10200_12030 bias_ref 0.01425f
C533 vctrl vs 0.68186f
C534 vdump vcp_p 1.64689f
C535 vco_div2 vdd 0.39567f
C536 vbp_vco vdd 8.70473f
C537 vdd t2 7.41233f
C538 vco_out ck 0.38582f
C539 vctrl vcp_n 0.36217f
C540 cp_trim1 vbt 0.06657f
C541 en_b vctrl 0.31772f
C542 t1c cp_trim1 0.17106f
C543 a_7950_0 pll_en 0
C544 vst vbn_vco 0.1404f
C545 vfilt vdd 1.54943f
C546 pll_en a_14400_19482 0
C547 vbp va 4.04887f
C548 up_s t1b 0.02759f
C549 bias_ref vdd 0.97344f
C550 up_b vbn_vco 0
C551 vctrl r5 0.06543f
C552 vbp_vco vref 2.50371f
C553 a_6394_0 pll_en 0
C554 a_11400_12030 pfd_up 0.00139f
C555 dn_s t1a 0.00468f
C556 vref t2 0.56341f
C557 bias_ref vco_out 0.26657f
C558 up_b vcl 0.05472f
C559 a_5274_0 r3 0.07237f
C560 dqb clkb 0
C561 vcp_p dn_s 0.83394f
C562 vfilt vref 0.111f
C563 pfd_up vs 0.0931f
C564 nb r4 0.00636f
C565 dn_b t1c 0.08054f
C566 nb r1 0
C567 a_4154_0 a_5274_0 0.06051f
C568 bias_ref vref 0.1592f
C569 pfd_dn cp_trim1 0.07834f
C570 vnt vbl 0.1714f
C571 va vdd 3.5761f
C572 pfd_up vcp_n 0.22512f
C573 en_b pfd_up 0.15698f
C574 vbn_vco vbp_vco 5.34864f
C575 a_4154_0 r3 0.01385f
C576 vbp a_14400_19482 0.01393f
C577 r2 vbp_vco 0.02798f
C578 pll_en dqn 0.33469f
C579 pll_en m1 0.12664f
C580 vnt vctrl 0.71263f
C581 vbl a_2000_12030 0
C582 cp_trim0 cp_trim1 1.21829f
C583 va vref 0.78902f
C584 vcl t2 0
C585 up_b t1a 0.0891f
C586 bias_ref vbn_vco 0.05372f
C587 a_11400_12030 up_s 0.01047f
C588 dn_b pfd_dn 1.39095f
C589 vcp_p up_b 0.53252f
C590 vfilt vcl 0.09853f
C591 a_7946_2036 vbp_vco 0.27897f
C592 a_6390_2036 r4 0.0033f
C593 vcl bias_ref 0.00215f
C594 a_7950_0 vdd 0
C595 up_s vs 0.04908f
C596 a_5274_0 vctrl 0.03536f
C597 vctrl a_2000_12030 0
C598 a_6390_2036 r1 0.25367f
C599 sf dqn 0.66999f
C600 pfd_dn pll_en 0.4113f
C601 a_11400_12030 vdump 0
C602 en_b a_4150_2036 0
C603 up_s vcp_n 0.66639f
C604 vbp vbt 8.50563f
C605 t1c vbp 0.00917f
C606 bias_ref a_7946_2036 0.002f
C607 vctrl r3 0.01436f
C608 dn_b cp_trim0 0.11891f
C609 vdump vs 0.04046f
C610 a_2000_12030 a_400_12030 0.00585f
C611 va vbn_vco 0.03168f
C612 a_19434_n100 s1 0.05093f
C613 va a_13200_19482 0
C614 a_5270_2036 r4 0.24986f
C615 a_4154_0 vctrl 0.00223f
C616 vcp_p vbp_vco 0
C617 a_5270_2036 r1 0.01216f
C618 a_6394_0 vdd 0
C619 t2 t1a 0.48848f
C620 cp_trim0 pll_en 0.45486f
C621 vdump vcp_n 0.28206f
C622 a_1200_19662 vcp_n 0.00456f
C623 vcl va 0.0396f
C624 up_b t1b 0.03206f
C625 vfilt t1a 0
C626 vfilt vcp_p 0.17141f
C627 vi vbh 0.09001f
C628 vbt vdd 11.393f
C629 vcp_p bias_ref 0.05346f
C630 t1c vdd 0.02838f
C631 vbl vctrl 2.77609f
C632 vbt a_6000_12030 0
C633 vctrl a_7800_18162 0
C634 pfd_dn vbp 0.53893f
C635 vdd dqn 0.76023f
C636 a_7950_0 vbn_vco 0.18732f
C637 m1 vdd 0.56978f
C638 vs dn_s 0.00568f
C639 pll_en r4 0.11728f
C640 pll_en r1 0.259f
C641 a_14400_19482 a_13200_19482 0.00585f
C642 pll_en m2 0.37963f
C643 vbl a_400_12030 0
C644 a_15000_12030 vbp 0.00602f
C645 en_b a_3034_0 0
C646 vcp_n dn_s 2.57217f
C647 va t1a 0.09992f
C648 ck s1 2.06719f
C649 t1b t2 0.50193f
C650 vbt vref 0.00828f
C651 t1c vref 0.01204f
C652 vcl a_14400_19482 0.00132f
C653 vco_out m1 0.01504f
C654 vcp_p va 0.00593f
C655 vctrl a_7200_12030 0.00329f
C656 cp_trim0 vbp 0.08966f
C657 vfilt t1b 0.14717f
C658 vco_div2 s1 0
C659 a_6394_0 vbn_vco 0.26815f
C660 pfd_dn vdd 1.49225f
C661 vctrl a_400_12030 0.00176f
C662 a_13800_12030 pll_en 0.01003f
C663 vdump vnt 0.94832f
C664 dn_b vi 0
C665 a_11400_12030 up_b 0.00337f
C666 a_15000_12030 vdd 0
C667 a_19434_n100 clkb 0
C668 vs up_b 0.05979f
C669 vbt vbn_vco 0
C670 en_b vst 2.14235f
C671 pll_en vi 0.38476f
C672 a_4150_2036 r3 0.00705f
C673 cp_trim0 vdd 6.608f
C674 a_9070_n100 en_b 0
C675 vdump a_2000_12030 0.00517f
C676 pfd_dn vref 0.59528f
C677 vbt a_4200_12030 0.00288f
C678 va t1b 0.13556f
C679 up_b vcp_n 0.33729f
C680 vcl vbt 0.11308f
C681 pfd_up vctrl 0.15525f
C682 t1c vcl 0
C683 pfd_dn a_12600_12030 0.00255f
C684 a_9070_n100 r5 0.10153f
C685 a_3030_2036 r3 0.25117f
C686 pll_en nb 0.86356f
C687 vs vbp_vco 0.756f
C688 cp_trim0 vref 0.28895f
C689 a_13800_12030 vbp 0.00178f
C690 en_b ck 0.03669f
C691 vdd r4 0.36951f
C692 a_5270_2036 a_6390_2036 0.09903f
C693 pfd_dn vbn_vco 0.04998f
C694 r1 vdd 0.45062f
C695 vs t2 0
C696 m2 vdd 0.54694f
C697 a_11400_12030 bias_ref 0.00104f
C698 vfilt vs 0.71378f
C699 en_b vbp_vco 0.43339f
C700 vi vbp 0.08039f
C701 ck clkb 1.86148f
C702 vs bias_ref 0.15601f
C703 vcp_n t2 2.65097f
C704 pfd_dn vcl 0.09059f
C705 vbt t1a 1.78734f
C706 t1c t1a 0.11815f
C707 en_b t2 0.11755f
C708 vco_div2 clkb 0
C709 vdump vbl 1.68883f
C710 vctrl a_4150_2036 0.00335f
C711 vfilt vcp_n 0.64645f
C712 vcp_p vbt 2.61783f
C713 vnt vst 0
C714 vctrl up_s 0.40216f
C715 vbp_vco r5 0.02143f
C716 a_3034_0 r3 0.11453f
C717 en_b bias_ref 0.05259f
C718 a_13800_12030 vdd 0.00127f
C719 a_4154_0 a_3034_0 0.02242f
C720 pll_en a_6390_2036 0.03805f
C721 cp_trim0 vcl 0.00301f
C722 vdump vctrl 5.30889f
C723 dn_b cp_trim1 0.72893f
C724 vctrl a_1200_19662 0.01597f
C725 bias_ref clkb 0
C726 vi vdd 0.25725f
C727 bias_ref r5 0.00651f
C728 vs va 0.0366f
C729 vdump a_7200_12030 0
C730 pll_en cp_trim1 0.38453f
C731 vco_div2 vss 0.485771f
C732 bias_ref vss 4.52229f
C733 pll_en vss 3.61953f
C734 pfd_up vss 2.52396f
C735 pfd_dn vss 5.15414f
C736 cp_trim0 vss 1.23288f
C737 cp_trim1 vss 1.55386f
C738 vctrl vss 22.0003f
C739 vdd vss 847.548f
C742 a_7950_0 vss 0.213954f
C743 a_6394_0 vss 0.167215f
C744 a_5274_0 vss 0.324552f
C745 a_4154_0 vss 0.34278f
C746 a_3034_0 vss 0.208386f
C747 sf vss 0.854472f
C748 mf vss 0.68318f
C749 m2 vss 0.354401f
C750 dqn vss 0.626714f
C751 s1 vss 0.682556f
C752 clkb vss 1.40359f
C753 m1 vss 1.02947f
C754 ck vss 0.686692f
C755 vco_out vss 1.26297f
C756 dqb vss 0.404189f
C757 nb vss 0.489506f
C758 r4 vss 0.408491f
C759 r5 vss 0.700483f
C760 r3 vss 0.440337f
C761 r1 vss 0.507843f
C762 r2 vss 0.459433f
C763 a_7946_2036 vss 0.00920987f
C764 a_6390_2036 vss 0.00456495f
C765 a_5270_2036 vss 0.00457761f
C766 a_4150_2036 vss 0.00461133f
C767 a_3030_2036 vss 0.0147003f
C768 vi vss 1.12649f
C769 vnt vss 3.19627f
C770 vbn_vco vss 4.37451f
C771 vst vss 1.94276f
C772 vbh vss 0.979737f
C773 vbl vss 3.37032f
C774 vbp_vco vss 1.83991f
C775 a_15000_12030 vss 0.66425f
C776 a_14400_19482 vss 0.71032f
C777 a_13800_12030 vss 0.65668f
C778 a_13200_19482 vss 0.70084f
C779 a_12600_12030 vss 0.65668f
C780 a_12000_19482 vss 0.71633f
C781 a_11400_12030 vss 0.69463f
C782 a_10800_19482 vss 0.70278f
C783 a_10200_12030 vss 0.6626f
C784 a_8400_12030 vss 0.6626f
C785 a_7800_18162 vss 0.66397f
C786 a_7200_12030 vss 0.65668f
C787 a_6600_18162 vss 0.66397f
C788 a_6000_12030 vss 0.6626f
C789 a_4200_12030 vss 0.66852f
C790 vs vss 4.12356f
C791 a_2000_12030 vss 1.06033f
C792 a_1200_19662 vss 1.15121f
C793 a_400_12030 vss 1.07671f
C794 vcl vss 5.34855f
C795 up_b vss 4.38977f
C796 en_b vss 3.79211f
C797 t1c vss 1.17646f
C798 vdump vss 2.11438f
C799 dn_b vss 1.88352f
C800 vref vss 12.8258f
C801 dn_s vss 1.55007f
C802 t1b vss 1.20831f
C803 va vss 0.691754f
C804 t1a vss 1.5489f
C805 t2 vss 0.827788f
C806 vcp_n vss 12.3799f
C807 vbt vss 0.304809f
C808 vbp vss 0.741631f
C809 up_s vss 2.39202f
C810 vcp_p vss 3.67798f
C811 vcp_p.t5 vss 1.2985f
C812 vcp_p.n0 vss 0.610919f
C813 vcp_p.t3 vss 1.2985f
C814 vcp_p.n1 vss 0.612143f
C815 vcp_p.n2 vss 0.519153f
C816 vcp_p.n3 vss 0.484397f
C817 vcp_p.n4 vss 0.128887f
C818 vcp_p.t0 vss 0.772477f
C819 vcp_p.t1 vss 0.775818f
C820 vcp_p.n5 vss 0.120604f
C821 vcp_p.n6 vss 0.389065f
C822 vcp_p.t6 vss 0.0645566f
C823 up_s.t0 vss 1.95249f
C824 up_s.t2 vss 1.96578f
C825 up_s.t3 vss 0.14578f
C826 up_s.t1 vss 0.151645f
C827 up_s.n0 vss 0.869326f
C828 up_s.n1 vss 1.11644f
C829 vbp.t1 vss 0.12799f
C830 vbp.t0 vss 0.0898685f
C831 vbp.n0 vss 0.0930893f
C832 vbp.n1 vss 0.518474f
C833 vbp.n2 vss 0.277019f
C834 vbp.n3 vss 0.277019f
C835 vbp.n4 vss 0.26984f
C836 vbp.n5 vss 0.274572f
C837 vbp.t3 vss 0.0981068f
C838 vbp.n6 vss 0.249214f
C839 vbp.n7 vss 0.19905f
C840 vbp.n8 vss 0.260475f
C841 vbp.n9 vss 0.274148f
C842 vbp.n10 vss 0.277019f
C843 vbp.n11 vss 0.26984f
C844 vbp.n12 vss 0.277019f
C845 vbp.n13 vss 0.525653f
C846 vbp.n14 vss 0.411991f
C847 vbp.t4 vss 0.0470161f
C848 vbp.n15 vss 0.624439f
C849 vbt.t5 vss 0.0849562f
C850 vbt.t7 vss 0.0707046f
C851 vbt.t2 vss 0.0849562f
C852 vbt.n0 vss 0.0523701f
C853 vbt.t3 vss 0.0849562f
C854 vbt.n1 vss 0.0306231f
C855 vbt.t8 vss 0.0688893f
C856 vbt.n2 vss 0.0290769f
C857 vbt.t9 vss 0.0688893f
C858 vbt.n3 vss 0.0290769f
C859 vbt.t4 vss 0.0849562f
C860 vbt.n4 vss 0.0306231f
C861 vbt.t10 vss 0.0697884f
C862 vbt.n5 vss 0.38365f
C863 vbt.t11 vss 0.261705f
C864 vbt.n6 vss 0.520924f
C865 vbt.t6 vss 0.258643f
C866 vbt.n7 vss 0.267603f
C867 vbt.t0 vss 0.258643f
C868 vbt.n8 vss 0.418159f
C869 vbt.t1 vss 0.278119f
C870 vbt.n9 vss 0.0250799f
C871 vcp_n.t3 vss 1.17958f
C872 vcp_n.n0 vss 0.614096f
C873 vcp_n.t1 vss 1.17958f
C874 vcp_n.n1 vss 0.62172f
C875 vcp_n.n2 vss 0.503414f
C876 vcp_n.n3 vss 0.453993f
C877 vcp_n.n4 vss 0.453993f
C878 vcp_n.n5 vss 0.4326f
C879 vcp_n.t7 vss 0.206693f
C880 vcp_n.n6 vss 0.156554f
C881 vcp_n.t5 vss 0.212114f
C882 vcp_n.n7 vss 0.168866f
C883 vcp_n.t4 vss 0.203728f
C884 vcp_n.n8 vss 0.392698f
C885 vcp_n.t6 vss 0.198939f
C886 vcp_n.n9 vss 0.368311f
C887 vcp_n.t10 vss 0.989997f
C888 vcp_n.t9 vss 0.956509f
C889 vcp_n.n10 vss 0.630347f
C890 vcp_n.t11 vss 0.956509f
C891 vcp_n.n11 vss 0.801513f
C892 vcp_n.t8 vss 0.989997f
C893 vcp_n.n12 vss 0.489824f
C894 vcp_n.n13 vss 0.0727333f
C895 t2.t1 vss 0.139652f
C896 t2.t3 vss 0.444065f
C897 t2.t2 vss 0.379956f
C898 t2.n0 vss 0.543048f
C899 t2.t0 vss 0.389076f
C900 t2.n1 vss 0.630567f
C901 t1a.t1 vss 0.21415f
C902 t1a.t2 vss 0.673088f
C903 t1a.t0 vss 0.543275f
C904 t1a.n0 vss 1.62688f
C905 va.t0 vss 0.0770435f
C906 va.t1 vss 0.131934f
C907 va.n0 vss 0.0782637f
C908 va.n1 vss 1.28986f
C909 va.t2 vss 1.20394f
C910 t1b.t0 vss 0.200361f
C911 t1b.t2 vss 0.562206f
C912 t1b.t1 vss 0.415261f
C913 t1b.n0 vss 1.25063f
C914 dn_s.t0 vss 1.0685f
C915 dn_s.t2 vss 1.06022f
C916 dn_s.n0 vss 0.189764f
C917 dn_s.t3 vss 0.201673f
C918 dn_s.n1 vss 0.378969f
C919 dn_s.t1 vss 0.242824f
C920 vref.t2 vss 0.507135f
C921 vref.n0 vss 0.574905f
C922 vref.n1 vss 0.326425f
C923 vref.n2 vss 0.303262f
C924 vref.n3 vss 0.325004f
C925 vref.n4 vss 0.220765f
C926 vref.n5 vss 0.312184f
C927 vref.n6 vss 0.730538f
C928 vref.t0 vss 0.228968f
C929 vref.n7 vss 0.597601f
C930 vref.n8 vss 0.853559f
C931 vref.n9 vss 0.466454f
C932 vref.n10 vss 0.896328f
C933 vref.t1 vss 0.397543f
C934 vref.n11 vss 2.09832f
C935 vref.n12 vss 0.137302f
C936 dn_b.t1 vss 0.153379f
C937 dn_b.t0 vss 0.218458f
C938 dn_b.n0 vss 1.52286f
C939 vdump.t0 vss 0.214272f
C940 vdump.t10 vss 0.152409f
C941 vdump.n0 vss 0.167471f
C942 vdump.t12 vss 0.152409f
C943 vdump.n1 vss 0.163276f
C944 vdump.n2 vss 0.185949f
C945 vdump.t6 vss 0.152409f
C946 vdump.n3 vss 0.163276f
C947 vdump.n4 vss 0.131075f
C948 vdump.t8 vss 0.152409f
C949 vdump.n5 vss 0.163276f
C950 vdump.n6 vss 0.0574887f
C951 vdump.t13 vss 0.284703f
C952 vdump.n7 vss 0.168026f
C953 vdump.t14 vss 0.284703f
C954 vdump.n8 vss 0.289882f
C955 vdump.n9 vss 0.0860575f
C956 vdump.t15 vss 0.675714f
C957 vdump.t2 vss 0.151245f
C958 vdump.n10 vss 0.160936f
C959 vdump.t4 vss 0.151245f
C960 vdump.n11 vss 0.156913f
C961 vdump.n12 vss 0.154332f
C962 vdump.t16 vss 0.174969f
C963 vdump.n13 vss 0.123345f
C964 vdump.t17 vss 0.178043f
C965 vdump.n14 vss 0.160327f
C966 vdump.n15 vss 1.09438f
C967 t1c.t0 vss 0.329672f
C968 t1c.t1 vss 0.326679f
C969 en_b.t1 vss 0.176899f
C970 en_b.n0 vss 1.63343f
C971 en_b.t0 vss 0.914275f
C972 en_b.n1 vss 0.548553f
C973 en_b.n2 vss 0.308277f
C974 en_b.n3 vss 0.682581f
C975 en_b.n4 vss 0.808594f
C976 en_b.n5 vss 0.419117f
C977 en_b.n6 vss 1.1117f
C978 en_b.n7 vss 0.578161f
C979 up_b.t1 vss 0.196827f
C980 up_b.t0 vss 1.35708f
C981 up_b.n0 vss 0.420053f
C982 vcl.t0 vss 0.725849f
C983 vcl.t3 vss 0.732979f
C984 vcl.t4 vss 0.725849f
C985 vcl.n0 vss 0.250207f
C986 vcl.t1 vss 0.734845f
C987 vcl.n1 vss 0.346074f
C988 vcl.t2 vss 0.214449f
C989 vcl.n2 vss 0.273273f
C990 vs.t1 vss 0.280107f
C991 vs.t2 vss 0.283425f
C992 vs.t0 vss 1.31868f
C993 vs.n0 vss 1.97782f
C994 vbp_vco.t5 vss 0.21456f
C995 vbp_vco.t4 vss 0.20607f
C996 vbp_vco.n0 vss 0.227303f
C997 vbp_vco.n1 vss 0.380704f
C998 vbp_vco.t1 vss 0.123769f
C999 vbp_vco.n2 vss 0.158954f
C1000 vbp_vco.n3 vss 0.208248f
C1001 vbp_vco.n4 vss 0.120408f
C1002 vbp_vco.t3 vss 0.123769f
C1003 vbp_vco.n5 vss 0.150393f
C1004 vbp_vco.n6 vss 0.0478884f
C1005 vbp_vco.t6 vss 0.098643f
C1006 vbp_vco.n7 vss 0.219912f
C1007 vbp_vco.n8 vss 0.0777772f
C1008 vbp_vco.n9 vss 0.0773105f
C1009 vbp_vco.n10 vss 0.0574846f
C1010 vbp_vco.n11 vss 0.0773105f
C1011 vbp_vco.n12 vss 0.0622616f
C1012 vbp_vco.n13 vss 0.0773105f
C1013 vbp_vco.n14 vss 0.111164f
C1014 vbp_vco.n15 vss 0.0867358f
C1015 vbp_vco.n16 vss 0.393299f
C1016 vbl.t0 vss 0.295877f
C1017 vbl.t2 vss 0.315481f
C1018 vbl.t1 vss 0.286043f
C1019 vbl.n0 vss 0.346676f
C1020 vbl.t3 vss 0.286043f
C1021 vbl.n1 vss 0.165736f
C1022 vbl.n2 vss 0.328793f
C1023 vbl.t5 vss 0.153918f
C1024 vbl.n3 vss 0.272142f
C1025 vbl.n4 vss 0.209961f
C1026 vbl.n5 vss 0.401848f
C1027 vbl.t7 vss 0.153918f
C1028 vbl.n6 vss 0.27543f
C1029 vbl.n7 vss 0.318857f
C1030 vbh.t1 vss 0.165901f
C1031 vbh.t0 vss 0.182966f
C1032 vbh.t3 vss 0.170191f
C1033 vbh.n0 vss 0.183648f
C1034 vbh.n1 vss 0.11146f
C1035 vbh.n2 vss 0.200119f
C1036 vbh.t5 vss 0.170191f
C1037 vbh.n3 vss 0.18505f
C1038 vbh.n4 vss 0.233225f
C1039 vbh.n5 vss 0.227143f
C1040 vst.t0 vss 0.393829f
C1041 vst.t3 vss 0.385139f
C1042 vst.n0 vss 0.335011f
C1043 vst.n1 vss 0.412624f
C1044 vst.t1 vss 0.154433f
C1045 vst.n2 vss 0.367557f
C1046 vst.t2 vss 0.855714f
C1047 vbn_vco.t2 vss 0.353081f
C1048 vbn_vco.t3 vss 0.358568f
C1049 vbn_vco.n0 vss 0.393321f
C1050 vbn_vco.t1 vss 0.146805f
C1051 vbn_vco.n1 vss 0.229321f
C1052 vbn_vco.n2 vss 0.486531f
C1053 vbn_vco.t4 vss 0.141326f
C1054 vbn_vco.n3 vss 0.0834798f
C1055 vbn_vco.n4 vss 0.0833816f
C1056 vbn_vco.n5 vss 0.0952678f
C1057 vbn_vco.n6 vss 0.0833816f
C1058 vbn_vco.n7 vss 0.0968713f
C1059 vbn_vco.n8 vss 0.0833816f
C1060 vbn_vco.n9 vss 0.172955f
C1061 vbn_vco.n10 vss 0.0980494f
C1062 vbn_vco.n11 vss 0.724033f
C1063 vbn_vco.n12 vss 0.364287f
C1064 vnt.t2 vss 0.33627f
C1065 vnt.t4 vss 0.252131f
C1066 vnt.t5 vss 0.33627f
C1067 vnt.n0 vss 0.104036f
C1068 vnt.t3 vss 0.245447f
C1069 vnt.n1 vss 0.261341f
C1070 vnt.t7 vss 0.250045f
C1071 vnt.n2 vss 0.220667f
C1072 vnt.t0 vss 0.250045f
C1073 vnt.n3 vss 0.207232f
C1074 vnt.t6 vss 0.250045f
C1075 vnt.n4 vss 0.330775f
C1076 vnt.t1 vss 0.263296f
C1077 vnt.n5 vss 0.177889f
C1078 vi.t3 vss 0.194784f
C1079 vi.t2 vss 0.271837f
C1080 vi.t0 vss 0.185234f
C1081 vi.n0 vss 0.240946f
C1082 vi.t1 vss 0.185432f
C1083 vi.n1 vss 0.0820811f
C1084 vi.t4 vss 0.202474f
C1085 vi.n2 vss 0.16782f
C1086 a_3030_2036.t1 vss 0.0239446f
C1087 a_3030_2036.t3 vss 0.0169878f
C1088 a_3030_2036.t2 vss 0.0170115f
C1089 a_3030_2036.n0 vss 0.0235865f
C1090 a_3030_2036.n1 vss 0.021452f
C1091 a_3030_2036.t0 vss 0.00925286f
C1092 a_3030_2036.n2 vss 0.0145802f
C1093 a_3030_2036.t4 vss 0.00987667f
C1094 a_3030_2036.n3 vss 0.0286277f
C1095 a_4150_2036.t1 vss 0.0126377f
C1096 a_4150_2036.t3 vss 0.00887668f
C1097 a_4150_2036.t2 vss 0.00888875f
C1098 a_4150_2036.n0 vss 0.0122934f
C1099 a_4150_2036.n1 vss 0.011181f
C1100 a_4150_2036.t0 vss 0.00498009f
C1101 a_4150_2036.n2 vss 0.00759932f
C1102 a_4150_2036.t4 vss 0.00494352f
C1103 a_4150_2036.n3 vss 0.0149206f
C1104 a_5270_2036.t3 vss 0.0126252f
C1105 a_5270_2036.t1 vss 0.00881041f
C1106 a_5270_2036.t0 vss 0.00882232f
C1107 a_5270_2036.n0 vss 0.0123573f
C1108 a_5270_2036.n1 vss 0.0112391f
C1109 a_5270_2036.t2 vss 0.00492788f
C1110 a_5270_2036.n2 vss 0.00763877f
C1111 a_5270_2036.t4 vss 0.00493571f
C1112 a_5270_2036.n3 vss 0.0149981f
C1113 a_6390_2036.t3 vss 0.0126311f
C1114 a_6390_2036.t1 vss 0.0087857f
C1115 a_6390_2036.t0 vss 0.00879756f
C1116 a_6390_2036.n0 vss 0.0123746f
C1117 a_6390_2036.n1 vss 0.0112547f
C1118 a_6390_2036.t2 vss 0.00492303f
C1119 a_6390_2036.n2 vss 0.00764946f
C1120 a_6390_2036.t4 vss 0.00493184f
C1121 a_6390_2036.n3 vss 0.0150194f
C1122 a_7946_2036.t1 vss 0.0182111f
C1123 a_7946_2036.t3 vss 0.0133414f
C1124 a_7946_2036.t2 vss 0.01336f
C1125 a_7946_2036.n0 vss 0.0174011f
C1126 a_7946_2036.n1 vss 0.0158268f
C1127 a_7946_2036.t0 vss 0.00737055f
C1128 a_7946_2036.n2 vss 0.010757f
C1129 a_7946_2036.t4 vss 0.00722845f
C1130 a_7946_2036.n3 vss 0.0211207f
C1131 r2.t0 vss 0.0407549f
C1132 r2.n0 vss 0.0947896f
C1133 r2.n1 vss 0.152927f
C1134 r2.n2 vss 0.080784f
C1135 r2.n3 vss 0.052727f
C1136 r2.n4 vss 0.1135f
C1137 r2.t1 vss 0.023006f
C1138 r2.t2 vss 0.0230615f
C1139 r2.n5 vss 0.0308032f
C1140 r2.t3 vss 0.0408039f
C1141 r1.t0 vss 0.0362336f
C1142 r1.n0 vss 0.0824254f
C1143 r1.n1 vss 0.140155f
C1144 r1.n2 vss 0.0695259f
C1145 r1.n3 vss 0.0514021f
C1146 r1.n4 vss 0.128095f
C1147 r1.t4 vss 0.0591536f
C1148 r1.n5 vss 0.172378f
C1149 r1.t2 vss 0.0203617f
C1150 r1.t3 vss 0.0204099f
C1151 r1.n6 vss 0.0311226f
C1152 r1.t1 vss 0.0362733f
C1153 r3.t1 vss 0.0361371f
C1154 r3.n0 vss 0.0863867f
C1155 r3.n1 vss 0.151126f
C1156 r3.n2 vss 0.0732247f
C1157 r3.n3 vss 0.0507147f
C1158 r3.n4 vss 0.114074f
C1159 r3.t0 vss 0.020249f
C1160 r3.t3 vss 0.0202929f
C1161 r3.n5 vss 0.030179f
C1162 r3.t2 vss 0.036099f
C1163 r5.t2 vss 0.0430689f
C1164 r5.n0 vss 0.0990599f
C1165 r5.n1 vss 0.161579f
C1166 r5.n2 vss 0.0839697f
C1167 r5.n3 vss 0.0581558f
C1168 r5.n4 vss 0.137105f
C1169 r5.n5 vss 0.0762721f
C1170 r5.n6 vss 0.0620297f
C1171 r5.n7 vss 0.128939f
C1172 r5.n8 vss 0.0878637f
C1173 r5.t0 vss 0.0242288f
C1174 r5.t1 vss 0.0242824f
C1175 r5.n9 vss 0.0346106f
C1176 r5.t3 vss 0.043022f
C1177 r4.t0 vss 0.0342291f
C1178 r4.n0 vss 0.083425f
C1179 r4.n1 vss 0.143079f
C1180 r4.n2 vss 0.0711007f
C1181 r4.n3 vss 0.0464067f
C1182 r4.n4 vss 0.10838f
C1183 r4.t3 vss 0.0192064f
C1184 r4.t2 vss 0.019249f
C1185 r4.n5 vss 0.0271097f
C1186 r4.t1 vss 0.0341918f
C1187 nb.t5 vss 0.0217529f
C1188 nb.n0 vss 0.0981985f
C1189 nb.n1 vss 0.293048f
C1190 nb.t0 vss 0.0202555f
C1191 nb.t3 vss 0.0202976f
C1192 nb.n2 vss 0.0632981f
C1193 nb.t2 vss 0.0201976f
C1194 nb.t1 vss 0.0202371f
C1195 nb.n3 vss 0.0238924f
C1196 nb.n4 vss 0.0471374f
C1197 nb.n5 vss 0.0371373f
C1198 nb.n6 vss 0.176492f
C1199 nb.n7 vss 0.155397f
C1200 nb.n8 vss 0.0883958f
C1201 nb.n9 vss 0.215539f
C1202 nb.t4 vss 0.0217082f
C1203 dqb.t1 vss 0.103613f
C1204 dqb.n0 vss 0.147791f
C1205 dqb.n1 vss 0.0733076f
C1206 dqb.n2 vss 0.0478469f
C1207 dqb.n3 vss 0.0985522f
C1208 dqb.t0 vss 0.0421548f
C1209 vco_out.t1 vss 0.0308545f
C1210 vco_out.n0 vss 0.0610367f
C1211 vco_out.n1 vss 0.338338f
C1212 vco_out.t6 vss 0.030866f
C1213 vco_out.t3 vss 0.0309042f
C1214 vco_out.n2 vss 0.164992f
C1215 vco_out.n3 vss 0.253143f
C1216 vco_out.n4 vss 0.242584f
C1217 vco_out.n5 vss 0.0490379f
C1218 vco_out.t4 vss 0.0286427f
C1219 vco_out.n6 vss 0.464067f
C1220 vco_out.t0 vss 0.0952605f
C1221 vco_out.t5 vss 0.030866f
C1222 vco_out.t7 vss 0.0309042f
C1223 vco_out.n7 vss 0.103581f
C1224 vco_out.t2 vss 0.0308201f
C1225 ck.t0 vss 0.071633f
C1226 ck.t1 vss 0.0468453f
C1227 ck.n0 vss 0.316496f
C1228 ck.n1 vss 0.215598f
C1229 ck.n2 vss 0.619681f
C1230 ck.n3 vss 0.311075f
C1231 m1.t2 vss 0.184547f
C1232 m1.t1 vss 0.0764967f
C1233 m1.n0 vss 0.211937f
C1234 m1.n1 vss 0.189269f
C1235 m1.n2 vss 0.0596135f
C1236 m1.t3 vss 0.0597639f
C1237 m1.n3 vss 0.236078f
C1238 m1.t0 vss 0.112347f
C1239 m1.n4 vss 0.147622f
C1240 clkb.t1 vss 0.0565897f
C1241 clkb.n0 vss 0.222419f
C1242 clkb.n1 vss 0.234142f
C1243 clkb.n2 vss 0.165235f
C1244 clkb.n3 vss 0.387053f
C1245 clkb.n4 vss 0.234473f
C1246 clkb.n5 vss 0.604307f
C1247 clkb.t0 vss 0.0315875f
C1248 s1.t0 vss 0.135867f
C1249 s1.t2 vss 0.0669401f
C1250 s1.t1 vss 0.0666464f
C1251 s1.n0 vss 0.169085f
C1252 s1.t3 vss 0.130492f
C1253 s1.n1 vss 0.113505f
C1254 s1.n2 vss 0.161105f
C1255 s1.n3 vss 0.0588192f
C1256 s1.n4 vss 0.16149f
C1257 s1.t4 vss 0.057988f
C1258 s1.n5 vss 0.206243f
C1259 s1.t5 vss 0.105677f
C1260 s1.n6 vss 0.273967f
C1261 dqn.t0 vss 0.0860229f
C1262 dqn.n0 vss 0.162453f
C1263 dqn.t2 vss 0.0784551f
C1264 dqn.n1 vss 0.156514f
C1265 dqn.n2 vss 0.0471385f
C1266 dqn.n3 vss 0.186879f
C1267 dqn.n4 vss 0.122755f
C1268 dqn.t1 vss 0.100288f
C1269 m2.t2 vss 0.108505f
C1270 m2.t1 vss 0.0690201f
C1271 m2.n0 vss 0.156962f
C1272 m2.n1 vss 0.130549f
C1273 m2.n2 vss 0.0475691f
C1274 m2.t3 vss 0.0740346f
C1275 m2.t0 vss 0.036365f
C1276 m2.n3 vss 0.134485f
C1277 mf.t1 vss 0.0526708f
C1278 mf.n0 vss 0.156264f
C1279 mf.t2 vss 0.0581572f
C1280 mf.n1 vss 0.18024f
C1281 mf.t3 vss 0.0980372f
C1282 mf.n2 vss 0.0171498f
C1283 mf.t0 vss 0.0277509f
C1284 sf.t1 vss 0.0605106f
C1285 sf.n0 vss 0.16163f
C1286 sf.n1 vss 0.136679f
C1287 sf.t2 vss 0.0793329f
C1288 sf.n2 vss 0.184616f
C1289 sf.t3 vss 0.154999f
C1290 sf.t0 vss 0.0292808f
C1291 a_3034_0.t0 vss 0.0384773f
C1292 a_3034_0.n0 vss 0.0285794f
C1293 a_3034_0.t3 vss 0.0452002f
C1294 a_3034_0.t2 vss 0.02435f
C1295 a_3034_0.n1 vss 0.0207981f
C1296 a_3034_0.n2 vss 0.103999f
C1297 a_3034_0.t1 vss 0.0383491f
C1298 a_4154_0.t0 vss 0.0418915f
C1299 a_4154_0.n0 vss 0.0288841f
C1300 a_4154_0.t2 vss 0.0427884f
C1301 a_4154_0.t3 vss 0.0480003f
C1302 a_4154_0.n1 vss 0.0855411f
C1303 a_4154_0.t4 vss 0.0273892f
C1304 a_4154_0.n2 vss 0.0210216f
C1305 a_4154_0.n3 vss 0.0772458f
C1306 a_4154_0.t1 vss 0.0420387f
C1307 a_5274_0.t0 vss 0.0411409f
C1308 a_5274_0.n0 vss 0.0307497f
C1309 a_5274_0.t2 vss 0.0376272f
C1310 a_5274_0.t3 vss 0.0488786f
C1311 a_5274_0.n1 vss 0.0910765f
C1312 a_5274_0.t4 vss 0.0269408f
C1313 a_5274_0.n2 vss 0.0223786f
C1314 a_5274_0.n3 vss 0.0822389f
C1315 a_5274_0.t1 vss 0.0410039f
C1316 a_6394_0.t0 vss 0.0435386f
C1317 a_6394_0.t3 vss 0.0232368f
C1318 a_6394_0.n0 vss 0.0202551f
C1319 a_6394_0.t2 vss 0.0349306f
C1320 a_6394_0.t1 vss 0.0350454f
C1321 a_6394_0.n1 vss 0.0278297f
C1322 a_6394_0.n2 vss 0.101272f
C1323 a_7950_0.t0 vss 0.0393433f
C1324 a_7950_0.n0 vss 0.0243482f
C1325 a_7950_0.t2 vss 0.0431187f
C1326 a_7950_0.t3 vss 0.0253391f
C1327 a_7950_0.n1 vss 0.0177198f
C1328 a_7950_0.n2 vss 0.088595f
C1329 a_7950_0.t1 vss 0.0392023f
C1330 vss.t203 vss 0.23906f
C1331 vss.t201 vss 0.36227f
C1332 vss.t199 vss 0.36227f
C1333 vss.t130 vss 0.23906f
C1334 vss.t171 vss 0.33863f
C1335 vss.t153 vss 0.32799f
C1336 vss.t104 vss 0.32799f
C1337 vss.t44 vss 0.32799f
C1338 vss.t141 vss 0.32799f
C1339 vss.t108 vss 0.32799f
C1340 vss.t10 vss 0.25487f
C1341 vss.t94 vss 0.25487f
C1342 vss.t197 vss 0.55734f
C1343 vss.t42 vss 0.11139f
C1344 vss.t96 vss 0.11139f
C1345 vss.t179 vss 0.11139f
C1346 vss.t165 vss 0.12728f
C1347 vss.t177 vss 0.13298f
C1348 vss.t110 vss 27.068f
C1349 vss.t82 vss 0.11753p
C1350 vss.t6 vss 1.60535f
C1351 vss.t205 vss 1.77909f
C1352 vss.t4 vss 1.77909f
C1353 vss.t137 vss 1.77909f
C1354 vss.t147 vss 1.77909f
C1355 vss.t145 vss 1.60535f
C1356 vss.t8 vss 0.8027f
C1357 vss.t156 vss 0.10173f
C1358 vss.t158 vss 0.20056f
C1359 vss.t187 vss 2.30648f
C1360 vss.t168 vss 0.51588f
C1361 vss.t173 vss 0.51588f
C1362 vss.t40 vss 0.51588f
C1363 vss.t162 vss 0.51997f
C1364 vss.t175 vss 0.0276f
C1365 vss.t160 vss 0.02749f
C1366 vss.t100 vss 0.03632f
C1367 vss.t21 vss 0.2123f
C1368 vss.t20 vss 0.2123f
C1369 vss.t57 vss 0.36392f
C1370 vss.t56 vss 0.36392f
C1371 vss.t181 vss 0.02946f
C1372 vss.t191 vss 0.06436f
C1373 vss.t54 vss 0.03093f
C1374 vss.t98 vss 0.03022f
C1375 vss.t133 vss 0.26993f
C1376 vss.t132 vss 0.26993f
C1377 vss.t185 vss 0.28235f
C1378 vss.t184 vss 0.28235f
C1379 vss.t127 vss 0.07518f
C1380 vss.t126 vss 0.07518f
C1381 vss.t64 vss 0.01792f
C1382 vss.t50 vss 0.04459f
C1383 vss.t52 vss 0.0445f
C1384 vss.t195 vss 0.05439f
C1385 vss.t193 vss 0.05422f
C1386 vss.t1 vss 0.07671f
C1387 vss.t14 vss 0.07638f
C1388 vss.t16 vss 0.07671f
C1389 vss.t18 vss 0.07638f
C1390 vss.t48 vss 0.06162f
C1391 vss.t29 vss 0.07671f
C1392 vss.t31 vss 0.07638f
C1393 vss.t117 vss 0.0722f
C1394 vss.t33 vss 0.07671f
C1395 vss.t23 vss 0.07638f
C1396 vss.t25 vss 0.07671f
C1397 vss.t27 vss 0.07638f
C1398 vdd.n0 vss 0.352507f
C1399 vdd.n1 vss 0.358665f
C1400 vdd.n2 vss 0.335112f
C1401 vdd.t58 vss 0.44026f
C1402 vdd.n3 vss 0.145196f
C1403 vdd.t50 vss 0.527057f
C1404 vdd.n4 vss 0.184991f
C1405 vdd.t45 vss 0.527057f
C1406 vdd.n5 vss 0.187531f
C1407 vdd.n6 vss 0.16324f
C1408 vdd.t52 vss 0.44026f
C1409 vdd.n7 vss 0.145196f
C1410 vdd.t10 vss 0.0928487f
C1411 vdd.n8 vss 0.254482f
C1412 vdd.t78 vss 0.0958506f
C1413 vdd.n9 vss 0.230483f
C1414 vdd.n10 vss 0.09452f
C1415 vdd.n11 vss 0.955853f
C1416 vdd.n12 vss 1.13087f
C1417 vdd.n13 vss 0.0727682f
C1418 vdd.n14 vss 2.74415f
C1419 vdd.n15 vss 0.03208f
C1420 vdd.n16 vss 0.0185146f
C1421 vdd.n17 vss 0.0301977f
C1422 vdd.n18 vss 0.0301977f
C1423 vdd.n19 vss 0.0274879f
C1424 vdd.n20 vss 0.0737175f
C1425 vdd.n21 vss 0.0843216f
C1426 vdd.n22 vss 0.111874f
C1427 vdd.n23 vss 0.0944308f
C1428 vdd.n24 vss 5.00265f
C1429 vdd.t3 vss 9.30661f
C1430 vdd.t2 vss 6.28606f
C1431 vdd.t0 vss 0.816369f
C1432 vdd.t114 vss 2.44095f
C1433 vdd.t26 vss 0.612279f
C1434 vdd.n25 vss 0.120904f
C1435 vdd.t65 vss 0.191961f
C1436 vdd.n26 vss 0.0759568f
C1437 vdd.t64 vss 0.192253f
C1438 vdd.n27 vss 0.0686223f
C1439 vdd.t103 vss 0.0643304f
C1440 vdd.n28 vss 0.0946742f
C1441 vdd.t68 vss 0.191961f
C1442 vdd.n29 vss 0.0568337f
C1443 vdd.t67 vss 0.192253f
C1444 vdd.n30 vss 0.0674703f
C1445 vdd.t102 vss 0.0593488f
C1446 vdd.n31 vss 0.0946742f
C1447 vdd.t66 vss 0.191961f
C1448 vdd.n32 vss 0.0803055f
C1449 vdd.t6 vss 0.192253f
C1450 vdd.n33 vss 0.0591298f
C1451 vdd.t112 vss 0.0593488f
C1452 vdd.n34 vss 0.0931083f
C1453 vdd.t5 vss 0.191961f
C1454 vdd.n35 vss 0.0803055f
C1455 vdd.t4 vss 0.192253f
C1456 vdd.n36 vss 0.0686223f
C1457 vdd.t113 vss 0.0593488f
C1458 vdd.n37 vss 0.0874777f
C1459 vdd.t115 vss 0.0477549f
C1460 vdd.n38 vss 0.0934572f
C1461 vdd.t80 vss 0.191961f
C1462 vdd.n39 vss 0.0803055f
C1463 vdd.t79 vss 0.192253f
C1464 vdd.n40 vss 0.0686223f
C1465 vdd.t116 vss 0.0593488f
C1466 vdd.n41 vss 0.0897656f
C1467 vdd.t1 vss 0.0721922f
C1468 vdd.n42 vss 0.0798187f
C1469 vdd.t32 vss 0.0723139f
C1470 vdd.n43 vss 0.0859767f
C1471 vdd.t118 vss 0.0766707f
C1472 vdd.n44 vss 0.0859767f
C1473 vdd.t119 vss 0.0768087f
C1474 vdd.n45 vss 0.0859767f
C1475 vdd.t41 vss 0.0819768f
C1476 vdd.n46 vss 0.078764f
C1477 vdd.t94 vss 0.082058f
C1478 vdd.n47 vss 0.0660342f
C1479 vdd.t93 vss 0.0819768f
C1480 vdd.n48 vss 0.082415f
C1481 vdd.t27 vss 0.082058f
C1482 vdd.n49 vss 0.082415f
C1483 vdd.t31 vss 0.0374023f
C1484 vdd.n50 vss 0.0946742f
C1485 vdd.t98 vss 0.0773766f
C1486 vdd.n51 vss 0.0970757f
C1487 vdd.t97 vss 0.0773766f
C1488 vdd.n52 vss 0.0757864f
C1489 vdd.t101 vss 0.0702288f
C1490 vdd.n53 vss 0.176992f
C1491 vdd.t48 vss 0.0454589f
C1492 vdd.n54 vss 0.184351f
C1493 vdd.t117 vss 0.0515844f
C1494 vdd.n55 vss 0.186849f
C1495 vdd.t28 vss 0.079551f
C1496 vdd.n56 vss 0.100378f
C1497 vdd.t100 vss 0.0499455f
C1498 vdd.n57 vss 0.174176f
C1499 vdd.t99 vss 0.0765896f
C1500 vdd.n58 vss 0.198468f
C1501 vdd.t96 vss 0.0816767f
C1502 vdd.n59 vss 0.0753239f
C1503 vdd.t95 vss 0.0841106f
C1504 vdd.t105 vss 0.0816685f
C1505 vdd.n60 vss 0.129732f
C1506 vdd.t107 vss 0.0815063f
C1507 vdd.n61 vss 0.142397f
C1508 vdd.t109 vss 0.100783f
C1509 vdd.n62 vss 0.140449f
C1510 vdd.t23 vss 1.45688f
C1511 vdd.n63 vss 0.276656f
C1512 vdd.t25 vss 0.21407f
C1513 vdd.n64 vss 0.281053f
C1514 vdd.n65 vss 0.140879f
C1515 vdd.t56 vss 0.23703f
C1516 vdd.n66 vss 0.120953f
C1517 vdd.t54 vss 0.23703f
C1518 vdd.n67 vss 0.136904f
C1519 vdd.t84 vss 0.21407f
C1520 vdd.n68 vss 0.133918f
C1521 vdd.t111 vss 0.176619f
C1522 vdd.n69 vss 0.565003f
C1523 vdd.n70 vss 0.309198f
C1524 vdd.n71 vss 0.33499f
C1525 vdd.n72 vss 0.360774f
C1526 vdd.n73 vss 0.272063f
C1527 vdd.n74 vss 0.531551f
C1528 vdd.n75 vss 0.283414f
C1529 vdd.t9 vss 0.3368f
C1530 vdd.t11 vss 0.303795f
C1531 vdd.t16 vss 0.361042f
C1532 vdd.t21 vss 0.361042f
C1533 vdd.t22 vss 0.778821f
C1534 vdd.t24 vss 0.533831f
C1535 vdd.t37 vss 0.342738f
C1536 vdd.t38 vss 0.327518f
C1537 vdd.t39 vss 0.327518f
C1538 vdd.t40 vss 0.327518f
C1539 vdd.t42 vss 0.361042f
C1540 vdd.t43 vss 0.303795f
C1541 vdd.t44 vss 0.404886f
C1542 vdd.t49 vss 0.464195f
C1543 vdd.t51 vss 0.360523f
C1544 vdd.t53 vss 0.309466f
C1545 vdd.t55 vss 0.288834f
C1546 vdd.t57 vss 0.404886f
C1547 vdd.t59 vss 0.361042f
C1548 vdd.t77 vss 0.277491f
C1549 vdd.t83 vss 0.303795f
C1550 vdd.t104 vss 0.271812f
C1551 vdd.t106 vss 0.286773f
C1552 vdd.t108 vss 0.271812f
C1553 vdd.t110 vss 0.293142f
C1554 vdd.n76 vss 0.0439741f
C1555 vdd.n77 vss 3.24191f
C1556 vdd.n78 vss 1.49274f
C1557 vdd.t76 vss 2.81599f
C1558 vdd.n79 vss 2.75458f
C1559 vdd.t18 vss 2.93373f
C1560 vdd.n80 vss 0.290172f
C1561 vdd.n81 vss 0.396359f
C1562 vdd.t8 vss 2.93373f
C1563 vdd.n82 vss 0.219514f
C1564 vdd.t92 vss 2.81599f
C1565 vdd.n83 vss 0.290172f
C1566 vdd.n84 vss 0.394866f
C1567 vdd.t86 vss 1.2774f
C1568 vdd.n85 vss 0.293767f
C1569 vdd.t74 vss 1.24527f
C1570 vdd.n86 vss 0.332078f
C1571 vdd.t20 vss 1.24527f
C1572 vdd.n87 vss 0.333116f
C1573 vdd.n88 vss 0.365058f
C1574 vdd.t72 vss 1.24527f
C1575 vdd.n89 vss 0.293767f
C1576 vdd.t88 vss 1.24527f
C1577 vdd.n90 vss 0.332078f
C1578 vdd.t82 vss 1.24527f
C1579 vdd.n91 vss 0.333116f
C1580 vdd.n92 vss 0.365058f
C1581 vdd.t70 vss 0.705557f
C1582 vdd.n93 vss 0.263504f
C1583 vdd.t47 vss 1.24527f
C1584 vdd.n94 vss 0.293767f
C1585 vdd.t121 vss 1.24527f
C1586 vdd.n95 vss 0.334609f
C1587 vdd.n96 vss 0.365058f
C1588 vdd.t61 vss 1.24527f
C1589 vdd.n97 vss 0.293767f
C1590 vdd.t90 vss 1.24527f
C1591 vdd.n98 vss 0.332078f
C1592 vdd.t13 vss 1.24527f
C1593 vdd.n99 vss 0.333116f
C1594 vdd.n100 vss 0.365058f
C1595 vdd.t63 vss 1.24527f
C1596 vdd.n101 vss 0.293767f
C1597 vdd.t15 vss 1.2774f
C1598 vdd.n102 vss 0.332078f
C1599 vdd.t30 vss 1.47668f
C1600 vdd.n103 vss 0.359168f
C1601 vdd.t34 vss 0.400205f
C1602 vdd.n104 vss 0.336061f
C1603 vdd.n105 vss 0.33942f
C1604 vdd.t36 vss 0.424926f
C1605 vdd.n106 vss 2.06914f
C1606 vdd.n107 vss 3.44845f
C1607 vdd.n108 vss 3.06147f
C1608 vdd.n109 vss 2.67449f
C1609 vdd.n110 vss 2.67449f
C1610 vdd.n111 vss 2.67449f
C1611 vdd.n112 vss 2.67449f
C1612 vdd.n113 vss 2.00888f
C1613 vdd.t7 vss 4.19874f
C1614 vdd.t12 vss 3.0378f
C1615 vdd.t14 vss 3.15002f
C1616 vdd.t17 vss 4.19874f
C1617 vdd.t19 vss 3.0378f
C1618 vdd.t29 vss 2.48442f
C1619 vdd.t33 vss 2.03939f
C1620 vdd.t35 vss 2.79361f
C1621 vdd.t46 vss 3.48283f
C1622 vdd.t60 vss 3.0378f
C1623 vdd.t62 vss 3.0378f
C1624 vdd.t69 vss 3.0378f
C1625 vdd.t71 vss 3.0378f
C1626 vdd.t73 vss 3.48283f
C1627 vdd.t75 vss 4.97596f
C1628 vdd.t81 vss 3.0378f
C1629 vdd.t85 vss 3.0378f
C1630 vdd.t87 vss 3.48283f
C1631 vdd.t89 vss 3.48283f
C1632 vdd.t91 vss 4.19874f
C1633 vdd.t120 vss 3.0378f
C1634 vdd.n114 vss 2.03128f
C1635 vctrl.n0 vss 0.238829f
C1636 vctrl.n1 vss 0.133244f
C1637 vctrl.n2 vss 0.285011f
C1638 vctrl.t0 vss 0.259665f
C1639 vctrl.n3 vss 0.044577f
C1640 vctrl.n4 vss 0.279413f
C1641 vctrl.t1 vss 0.352341f
C1642 vctrl.n5 vss 3.04637f
C1643 vctrl.t2 vss 0.130148f
C1644 vctrl.n6 vss 0.516523f
C1645 vctrl.n7 vss 0.279687f
C1646 vctrl.n8 vss 0.47422f
C1647 vctrl.n9 vss 0.387242f
C1648 vctrl.n10 vss 0.354387f
C1649 cp_trim1.n0 vss 0.867788f
C1650 cp_trim1.n1 vss 2.41271f
C1651 cp_trim0.n0 vss 1.12666f
C1652 cp_trim0.n1 vss 0.959358f
C1653 cp_trim0.n2 vss 1.81626f
C1654 pfd_dn.n0 vss 1.94779f
C1655 pfd_dn.n1 vss 2.19952f
C1656 pfd_up.n0 vss 0.901484f
C1657 pfd_up.n1 vss 1.99776f
C1658 pll_en.n0 vss 0.19185f
C1659 pll_en.n1 vss 0.488106f
C1660 pll_en.n2 vss 0.550465f
C1661 pll_en.n3 vss 0.224761f
C1662 pll_en.n4 vss 0.97592f
C1663 pll_en.n5 vss 0.201681f
C1664 pll_en.n6 vss 1.85507f
C1665 pll_en.n7 vss 0.934797f
C1666 pll_en.n8 vss 0.903344f
C1667 pll_en.n9 vss 0.0648438f
C1668 pll_en.n10 vss 0.0797545f
C1669 pll_en.n11 vss 0.121553f
C1670 pll_en.n12 vss 0.226963f
C1671 pll_en.n13 vss 0.140008f
C1672 pll_en.n14 vss 0.112167f
C1673 pll_en.n15 vss 0.11558f
C1674 pll_en.n16 vss 0.143617f
C1675 pll_en.n17 vss 0.240783f
C1676 bias_ref.t1 vss 0.0830447f
C1677 bias_ref.t0 vss 0.0426582f
C1678 bias_ref.n0 vss 1.30231f
C1679 vco_div2.t2 vss 0.0350824f
C1680 vco_div2.t1 vss 0.0351238f
C1681 vco_div2.n0 vss 0.112323f
C1682 vco_div2.t0 vss 0.0200135f
C1683 vco_div2.t3 vss 0.0200642f
C1684 vco_div2.n1 vss 0.0326929f
C1685 vco_div2.n2 vss 0.261539f
Cnode0 a_19434_n100 vss 0.270948f
Cnode1 a_9070_n100 vss 1.03694f
Cnode2 vfilt vss 117.526f
Crb1_X0 vctrl.t2 vss.t208 2.81801f
Crb2_X0 a_400_12030 vss.t208 2.81801f
Crb1_X9 vs.t0 vss.t37 1.37733f
Crb2_X9 a_4200_12030 vss.t37 1.37733f
Crb1_X10 a_13200_19482 vss.t59 2.34466f
Crb2_X10 a_12600_12030 vss.t59 2.34466f
Crb1_X22 bias_ref.t0 vss.t120 2.34466f
Crb2_X22 a_10200_12030 vss.t120 2.34466f
Crb1_X24 a_1200_19662 vss.t207 2.81801f
Crb2_X24 a_400_12030 vss.t207 2.81801f
Crb1_X25 bias_ref.t1 vss.t163 1.92185f
Crb2_X25 a_8400_12030 vss.t163 1.92185f
Crb1_X38 a_14400_19482 vss.t36 2.34466f
Crb2_X38 a_15000_12030 vss.t36 2.34466f
Crb1_X40 vref.t1 vss.t65 1.92185f
Crb2_X40 a_6000_12030 vss.t65 1.92185f
Crb1_X50 a_12000_19482 vss.t121 2.34466f
Crb2_X50 a_11400_12030 vss.t121 2.34466f
Crb1_X56 a_1200_19662 vss.t101 2.81801f
Crb2_X56 a_2000_12030 vss.t101 2.81801f
Crb1_X92 a_7800_18162 vss.t151 1.92185f
Crb2_X92 a_7200_12030 vss.t151 1.92185f
Crb1_X103 vcl.t2 vss.t166 1.37733f
Crb2_X103 a_4200_12030 vss.t166 1.37733f
Crb1_X104 a_13200_19482 vss.t149 2.34466f
Crb2_X104 a_13800_12030 vss.t149 2.34466f
Crb1_X115 vfilt vss.t206 2.81801f
Crb2_X115 a_2000_12030 vss.t206 2.81801f
Crb1_X119 a_10800_19482 vss.t91 2.34466f
Crb2_X119 a_10200_12030 vss.t91 2.34466f
Crb1_X137 vss.t46 vss.t45 2.34466f
Crb2_X137 a_15000_12030 vss.t45 2.34466f
Crb1_X139 a_6600_18162 vss.t119 1.92185f
Crb2_X139 a_6000_12030 vss.t119 1.92185f
Crb1_X150 a_12000_19482 vss.t92 2.34466f
Crb2_X150 a_12600_12030 vss.t92 2.34466f
Crb1_X159 a_7800_18162 vss.t128 1.92185f
Crb2_X159 a_8400_12030 vss.t128 1.92185f
Crb1_X177 a_14400_19482 vss.t169 2.34466f
Crb2_X177 a_13800_12030 vss.t169 2.34466f
Crb1_X193 a_10800_19482 vss.t150 2.34466f
Crb2_X193 a_11400_12030 vss.t150 2.34466f
Crb1_X218 a_6600_18162 vss.t90 1.92185f
Crb2_X218 a_7200_12030 vss.t90 1.92185f
.ends
