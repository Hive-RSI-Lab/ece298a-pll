* NGSPICE file created from pll_analog.ext - technology: gf180mcuD

.subckt pll_analog vco_out pfd_up pfd_dn pll_en cp_trim0 cp_trim1 vctrl bias_ref vdd
+ vss
X0 vcp_p.t5 vcp_n.t12 vss.t121 vss.t120 nfet_03v3 ad=6.1p pd=21.22u as=6.1p ps=21.22u w=10u l=2u
X1 vbl.t6 vctrl.t8 vbt.t9 vdd.t72 pfet_03v3 ad=3.25p pd=11.3u as=3.25p ps=11.3u w=5u l=1u
X2 vbl.t3 vbl.t2 vss.t67 vss.t66 nfet_03v3 ad=1.22p pd=5.22u as=1.22p ps=5.22u w=2u l=2u
X3 vfilt vss.t38 cap_nmos_03v3_b c_width=35u c_length=12u
X4 up_s.t3 vcp_p.t7 vdd.t103 vdd.t102 pfet_03v3 ad=16.25p pd=51.3u as=16.25p ps=51.3u w=25u l=2u
X5 vst.t3 vref.t3 vss.t164 vss.t163 nfet_03v3 ad=3.05p pd=11.22u as=3.05p ps=11.22u w=5u l=1u
X6 vst.t0 en_b.t6 vdd.t24 vdd.t23 pfet_03v3 ad=0.325p pd=2.3u as=0.325p ps=2.3u w=0.5u l=10u
X7 vcp_n.t5 vbp.t14 vdd.t51 vdd.t50 pfet_03v3 ad=2.6p pd=9.3u as=2.6p ps=9.3u w=4u l=2u
X8 vfilt a_2000_10658 vss.t135 ppolyf_u r_width=2u r_length=37.5u
X9 a_20880_0.t3 vbn_vco.t6 vss.t97 vss.t96 nfet_03v3 ad=0.52p pd=2.52u as=1.22p ps=5.22u w=2u l=0.5u
X10 a_10800_18110 a_10200_10658 vss.t145 ppolyf_u r_width=1u r_length=36.6u
X11 vnt.t7 vref.t6 vss.t160 vss.t159 nfet_03v3 ad=1.22p pd=5.22u as=1.22p ps=5.22u w=2u l=2u
X12 vcp_n.t8 vbp.t6 vdd.t63 vdd.t62 pfet_03v3 ad=2.6p pd=9.3u as=2.6p ps=9.3u w=4u l=2u
X13 vdd.t113 pll_en.t2 nb.t5 vdd.t112 pfet_03v3 ad=1.3p pd=5.3u as=0.52p ps=2.52u w=2u l=0.28u
X14 a_20192_1144.t1 r5.t10 r1.t2 vdd.t10 pfet_03v3 ad=1.95p pd=7.3u as=0.78p ps=3.52u w=3u l=0.28u
X15 vcp_n.t7 cp_trim1.t0 t1c.t0 vss.t87 nfet_03v3 ad=1.22p pd=5.22u as=1.22p ps=5.22u w=2u l=0.28u
X16 vst.t1 en_b.t5 vss.t75 vss.t74 nfet_03v3 ad=0.61p pd=3.22u as=0.61p ps=3.22u w=1u l=0.28u
X17 vdump.t7 vdump.t6 vnt.t0 vss.t60 nfet_03v3 ad=3.05p pd=11.22u as=3.05p ps=11.22u w=5u l=1u
X18 vfilt vss.t44 cap_nmos_03v3_b c_width=35u c_length=12u
X19 vcp_p.t3 vcp_p.t2 vdd.t7 vdd.t6 pfet_03v3 ad=16.25p pd=51.3u as=16.25p ps=51.3u w=25u l=2u
X20 vbp.t3 vbp.t2 vdd.t33 vdd.t32 pfet_03v3 ad=2.6p pd=9.3u as=2.6p ps=9.3u w=4u l=2u
X21 t2.t2 vbp.t13 vdd.t67 vdd.t66 pfet_03v3 ad=2.6p pd=9.3u as=2.6p ps=9.3u w=4u l=2u
X22 vbn_vco.t4 vbp_vco.t18 vdd.t119 vdd.t118 pfet_03v3 ad=3.25p pd=11.3u as=3.25p ps=11.3u w=5u l=0.5u
X23 vcp_n.t4 vcp_n.t3 vss.t1 vss.t0 nfet_03v3 ad=6.1p pd=21.22u as=6.1p ps=21.22u w=10u l=2u
X24 vss.t83 vbn_vco.t7 a_20196_0.t2 vss.t82 nfet_03v3 ad=1.22p pd=5.22u as=0.52p ps=2.52u w=2u l=0.5u
X25 a_21564_n100.t2 pll_en.t1 vss.t141 vss.t140 nfet_03v3 ad=0.52p pd=2.52u as=1.22p ps=5.22u w=2u l=0.28u
X26 r1.t3 r5.t11 a_20192_1144.t0 vdd.t89 pfet_03v3 ad=0.78p pd=3.52u as=1.95p ps=7.3u w=3u l=0.28u
X27 vss.t162 a_15000_10658 vss.t161 ppolyf_u r_width=1u r_length=36.6u
X28 t1b.t0 vbp.t10 vdd.t53 vdd.t52 pfet_03v3 ad=2.6p pd=9.3u as=2.6p ps=9.3u w=4u l=2u
X29 a_6600_16790 a_6000_10658 vss.t32 ppolyf_u r_width=1u r_length=30u
X30 vbp_vco.t2 pll_en.t6 vdd.t111 vdd.t110 pfet_03v3 ad=0.65p pd=3.3u as=0.65p ps=3.3u w=1u l=0.28u
X31 vfilt vss.t46 cap_nmos_03v3_b c_width=35u c_length=12u
X32 vbt.t1 vbp.t5 vdd.t30 vdd.t29 pfet_03v3 ad=2.6p pd=9.3u as=2.6p ps=9.3u w=4u l=2u
X33 dn_b.t1 pfd_dn.t0 vdd.t49 vdd.t48 pfet_03v3 ad=1.3p pd=5.3u as=1.3p ps=5.3u w=2u l=0.28u
X34 vdump.t13 vdump.t12 vbt.t4 vdd.t61 pfet_03v3 ad=3.25p pd=11.3u as=3.25p ps=11.3u w=5u l=1u
X35 vbt.t2 vbp.t17 vdd.t35 vdd.t34 pfet_03v3 ad=2.6p pd=9.3u as=2.6p ps=9.3u w=4u l=2u
X36 vcl.t3 vref.t14 vss.t21 vss.t20 nfet_03v3 ad=6.1p pd=21.22u as=6.1p ps=21.22u w=10u l=2u
X37 va.t1 vbp.t11 vdd.t69 vdd.t68 pfet_03v3 ad=2.6p pd=9.3u as=2.6p ps=9.3u w=4u l=2u
X38 vcl.t2 vref.t13 vss.t19 vss.t18 nfet_03v3 ad=6.1p pd=21.22u as=6.1p ps=21.22u w=10u l=2u
X39 t2.t0 vbp.t9 vdd.t14 vdd.t13 pfet_03v3 ad=2.6p pd=9.3u as=2.6p ps=9.3u w=4u l=2u
X40 a_12000_18110 a_12600_10658 vss.t27 ppolyf_u r_width=1u r_length=36.6u
X41 vdd.t20 vbp_vco.t7 a_20876_1144.t0 vdd.t19 pfet_03v3 ad=3.25p pd=11.3u as=1.3p ps=5.52u w=5u l=0.5u
X42 vdump.t1 vbl.t8 vss.t114 vss.t113 nfet_03v3 ad=1.22p pd=5.22u as=1.22p ps=5.22u w=2u l=2u
X43 vdump.t2 vbh.t7 vdd.t16 vdd.t15 pfet_03v3 ad=2.6p pd=9.3u as=2.6p ps=9.3u w=4u l=2u
X44 vss.t134 vbn_vco.t13 a_18144_0.t2 vss.t133 nfet_03v3 ad=1.22p pd=5.22u as=0.52p ps=2.52u w=2u l=0.5u
X45 vbn_vco.t0 en_b.t2 vss.t85 vss.t84 nfet_03v3 ad=0.61p pd=3.22u as=0.61p ps=3.22u w=1u l=0.28u
X46 dn_b.t0 pfd_dn.t1 vss.t73 vss.t72 nfet_03v3 ad=0.61p pd=3.22u as=0.61p ps=3.22u w=1u l=0.28u
X47 vdump.t9 vdump.t8 vnt.t5 vss.t117 nfet_03v3 ad=3.05p pd=11.22u as=3.05p ps=11.22u w=5u l=1u
X48 vbp_vco.t4 vbp_vco.t3 vdd.t22 vdd.t21 pfet_03v3 ad=3.25p pd=11.3u as=3.25p ps=11.3u w=5u l=0.5u
X49 vcp_n.t10 vbp.t16 vdd.t101 vdd.t100 pfet_03v3 ad=2.6p pd=9.3u as=2.6p ps=9.3u w=4u l=2u
X50 a_20192_1144.t2 vbp_vco.t10 vdd.t45 vdd.t44 pfet_03v3 ad=1.3p pd=5.52u as=3.25p ps=11.3u w=5u l=0.5u
X51 vcp_n.t2 vcp_n.t1 vss.t7 vss.t6 nfet_03v3 ad=6.1p pd=21.22u as=6.1p ps=21.22u w=10u l=2u
X52 a_18828_0.t1 vbn_vco.t12 vss.t132 vss.t131 nfet_03v3 ad=0.52p pd=2.52u as=1.22p ps=5.22u w=2u l=0.5u
X53 vcp_p.t6 pll_en.t9 vdd.t105 vdd.t104 pfet_03v3 ad=0.65p pd=3.3u as=0.65p ps=3.3u w=1u l=0.28u
X54 vfilt vss.t56 cap_nmos_03v3_b c_width=35u c_length=12u
X55 vbh.t4 vctrl.t6 vnt.t3 vss.t90 nfet_03v3 ad=3.05p pd=11.22u as=3.05p ps=11.22u w=5u l=1u
X56 vbp_vco.t6 vbp_vco.t5 vdd.t121 vdd.t120 pfet_03v3 ad=3.25p pd=11.3u as=3.25p ps=11.3u w=5u l=0.5u
X57 vcp_n.t9 cp_trim0.t1 t1a.t1 vss.t127 nfet_03v3 ad=1.22p pd=5.22u as=1.22p ps=5.22u w=2u l=0.28u
X58 vi.t1 vctrl.t3 vs.t2 vss.t93 nfet_03v3 ad=3.05p pd=11.22u as=3.05p ps=11.22u w=5u l=1u
X59 a_7800_16790 a_8400_10658 vss.t144 ppolyf_u r_width=1u r_length=30u
X60 vdump.t15 vdump.t14 vbt.t6 vdd.t116 pfet_03v3 ad=3.25p pd=11.3u as=3.25p ps=11.3u w=5u l=1u
X61 vdd.t98 nb.t8 vco_out.t5 vdd.t97 pfet_03v3 ad=1.95p pd=7.3u as=0.78p ps=3.52u w=3u l=0.28u
X62 vdd.t84 vbp_vco.t15 a_18140_1144.t1 vdd.t83 pfet_03v3 ad=3.25p pd=11.3u as=1.3p ps=5.52u w=5u l=0.5u
X63 vcl.t1 vref.t12 vss.t17 vss.t16 nfet_03v3 ad=6.1p pd=21.22u as=6.1p ps=21.22u w=10u l=2u
X64 a_20876_1144.t2 r4.t6 r5.t1 vdd.t2 pfet_03v3 ad=1.95p pd=7.3u as=0.78p ps=3.52u w=3u l=0.28u
X65 vnt.t4 vref.t8 vss.t116 vss.t115 nfet_03v3 ad=1.22p pd=5.22u as=1.22p ps=5.22u w=2u l=2u
X66 t1c.t1 cp_trim0.t0 t1b.t1 vss.t128 nfet_03v3 ad=1.22p pd=5.22u as=1.22p ps=5.22u w=2u l=0.28u
X67 r3.t1 r2.t5 a_18144_0.t1 vss.t129 nfet_03v3 ad=0.39p pd=2.02u as=0.915p ps=4.22u w=1.5u l=0.28u
X68 a_21564_n100.t1 r5.t4 nb.t3 vss.t126 nfet_03v3 ad=1.22p pd=5.22u as=0.52p ps=2.52u w=2u l=0.28u
X69 vfilt vss.t48 cap_nmos_03v3_b c_width=35u c_length=12u
X70 r5.t0 r4.t7 a_20876_1144.t1 vdd.t3 pfet_03v3 ad=0.78p pd=3.52u as=1.95p ps=7.3u w=3u l=0.28u
X71 a_14400_18110 a_13800_10658 vss.t8 ppolyf_u r_width=1u r_length=36.6u
X72 vbp.t0 vst.t4 vss.t158 vss.t157 nfet_03v3 ad=0.305p pd=2.22u as=0.305p ps=2.22u w=0.5u l=4u
X73 vdump.t17 pfd_up.t0 up_s.t1 vdd.t96 pfet_03v3 ad=2.6p pd=9.3u as=2.6p ps=9.3u w=4u l=0.5u
X74 vbp.t1 va.t3 vref.t1 vss.t31 nfet_03v3 ad=2.44p pd=9.22u as=2.44p ps=9.22u w=4u l=1u
X75 vdump.t3 vbh.t6 vdd.t43 vdd.t42 pfet_03v3 ad=2.6p pd=9.3u as=2.6p ps=9.3u w=4u l=2u
X76 nb.t4 pll_en.t3 vdd.t115 vdd.t114 pfet_03v3 ad=0.52p pd=2.52u as=1.3p ps=5.3u w=2u l=0.28u
X77 vref.t2 en_b.t3 vss.t63 vss.t62 nfet_03v3 ad=0.61p pd=3.22u as=0.61p ps=3.22u w=1u l=0.28u
X78 a_18140_1144.t3 r2.t6 r3.t2 vdd.t99 pfet_03v3 ad=1.95p pd=7.3u as=0.78p ps=3.52u w=3u l=0.28u
X79 vfilt vss.t54 cap_nmos_03v3_b c_width=35u c_length=12u
X80 vcp_n.t0 vbp.t8 vdd.t1 vdd.t0 pfet_03v3 ad=2.6p pd=9.3u as=2.6p ps=9.3u w=4u l=2u
X81 vbh.t1 vbh.t0 vdd.t41 vdd.t40 pfet_03v3 ad=2.6p pd=9.3u as=2.6p ps=9.3u w=4u l=2u
X82 a_10800_18110 a_11400_10658 vss.t77 ppolyf_u r_width=1u r_length=36.6u
X83 vss.t25 vbn_vco.t9 a_19512_0.t1 vss.t24 nfet_03v3 ad=1.22p pd=5.22u as=0.52p ps=2.52u w=2u l=0.5u
X84 vdd.t5 r5.t8 nb.t0 vdd.t4 pfet_03v3 ad=1.3p pd=5.3u as=0.52p ps=2.52u w=2u l=0.28u
X85 r2.t0 r1.t5 a_18828_0.t3 vss.t150 nfet_03v3 ad=0.39p pd=2.02u as=0.915p ps=4.22u w=1.5u l=0.28u
X86 vbh.t5 vctrl.t5 vnt.t2 vss.t91 nfet_03v3 ad=3.05p pd=11.22u as=3.05p ps=11.22u w=5u l=1u
X87 a_19512_0.t2 r3.t4 r4.t2 vss.t108 nfet_03v3 ad=0.915p pd=4.22u as=0.39p ps=2.02u w=1.5u l=0.28u
X88 a_20876_1144.t3 vbp_vco.t8 vdd.t91 vdd.t90 pfet_03v3 ad=1.3p pd=5.52u as=3.25p ps=11.3u w=5u l=0.5u
X89 vdump.t0 vbl.t9 vss.t112 vss.t111 nfet_03v3 ad=1.22p pd=5.22u as=1.22p ps=5.22u w=2u l=2u
X90 vctrl.t1 pfd_dn.t2 dn_s.t0 vss.t71 nfet_03v3 ad=1.22p pd=5.22u as=1.22p ps=5.22u w=2u l=0.5u
X91 a_6600_16790 a_7200_10658 vss.t105 ppolyf_u r_width=1u r_length=30u
X92 r4.t3 r3.t5 a_19512_0.t3 vss.t109 nfet_03v3 ad=0.39p pd=2.02u as=0.915p ps=4.22u w=1.5u l=0.28u
X93 vbp_vco.t0 pll_en.t5 vi.t2 vss.t138 nfet_03v3 ad=3.05p pd=11.22u as=3.05p ps=11.22u w=5u l=0.28u
X94 vbl.t1 vbl.t0 vss.t3 vss.t2 nfet_03v3 ad=1.22p pd=5.22u as=1.22p ps=5.22u w=2u l=2u
X95 vbh.t3 vbh.t2 vdd.t55 vdd.t54 pfet_03v3 ad=2.6p pd=9.3u as=2.6p ps=9.3u w=4u l=2u
X96 vdd.t60 vbp_vco.t13 a_18824_1144.t2 vdd.t59 pfet_03v3 ad=3.25p pd=11.3u as=1.3p ps=5.52u w=5u l=0.5u
X97 vfilt vss.t42 cap_nmos_03v3_b c_width=35u c_length=12u
X98 vdump.t16 dn_b.t2 dn_s.t3 vss.t106 nfet_03v3 ad=1.22p pd=5.22u as=1.22p ps=5.22u w=2u l=0.5u
X99 vcp_p.t4 vcp_n.t15 vss.t156 vss.t155 nfet_03v3 ad=6.1p pd=21.22u as=6.1p ps=21.22u w=10u l=2u
X100 vctrl.t2 a_400_10658 vss.t110 ppolyf_u r_width=2u r_length=37.5u
X101 a_13200_18110 a_12600_10658 vss.t33 ppolyf_u r_width=1u r_length=36.6u
X102 vss.t143 pll_en.t0 a_21564_n100.t3 vss.t142 nfet_03v3 ad=1.22p pd=5.22u as=0.52p ps=2.52u w=2u l=0.28u
X103 r2.t2 r1.t7 a_18824_1144.t0 vdd.t80 pfet_03v3 ad=0.78p pd=3.52u as=1.95p ps=7.3u w=3u l=0.28u
X104 vs.t0 a_4200_10658 vss.t4 ppolyf_u r_width=1u r_length=17.5u
X105 vco_out.t0 nb.t9 vdd.t37 vdd.t36 pfet_03v3 ad=0.78p pd=3.52u as=1.95p ps=7.3u w=3u l=0.28u
X106 vbl.t5 vctrl.t10 vbt.t7 vdd.t70 pfet_03v3 ad=3.25p pd=11.3u as=3.25p ps=11.3u w=5u l=1u
X107 vbl.t7 vctrl.t7 vbt.t10 vdd.t73 pfet_03v3 ad=3.25p pd=11.3u as=3.25p ps=11.3u w=5u l=1u
X108 en_b.t0 pll_en.t10 vss.t137 vss.t136 nfet_03v3 ad=0.61p pd=3.22u as=0.61p ps=3.22u w=1u l=0.28u
X109 a_18824_1144.t1 r1.t6 r2.t3 vdd.t56 pfet_03v3 ad=1.95p pd=7.3u as=0.78p ps=3.52u w=3u l=0.28u
X110 bias_ref.t1 a_10200_10658 vss.t76 ppolyf_u r_width=1u r_length=36.6u
X111 a_1200_18290 a_400_10658 vss.t107 ppolyf_u r_width=2u r_length=37.5u
X112 bias_ref.t0 a_8400_10658 vss.t9 ppolyf_u r_width=1u r_length=30u
X113 vdd.t47 vbp_vco.t11 a_19508_1144.t2 vdd.t46 pfet_03v3 ad=3.25p pd=11.3u as=1.3p ps=5.52u w=5u l=0.5u
X114 dn_s.t2 vcp_n.t14 vss.t99 vss.t98 nfet_03v3 ad=6.1p pd=21.22u as=6.1p ps=21.22u w=10u l=2u
X115 vdump.t11 vdump.t10 vbt.t5 vdd.t26 pfet_03v3 ad=3.25p pd=11.3u as=3.25p ps=11.3u w=5u l=1u
X116 up_b.t1 pfd_up.t1 vdd.t95 vdd.t94 pfet_03v3 ad=1.3p pd=5.3u as=1.3p ps=5.3u w=2u l=0.28u
X117 vfilt vss.t40 cap_nmos_03v3_b c_width=35u c_length=12u
X118 vcl.t0 vref.t11 vss.t15 vss.t14 nfet_03v3 ad=6.1p pd=21.22u as=6.1p ps=21.22u w=10u l=2u
X119 vbn_vco.t1 vbp_vco.t17 vdd.t79 vdd.t78 pfet_03v3 ad=3.25p pd=11.3u as=3.25p ps=11.3u w=5u l=0.5u
X120 dn_s.t1 vcp_n.t13 vss.t95 vss.t94 nfet_03v3 ad=6.1p pd=21.22u as=6.1p ps=21.22u w=10u l=2u
X121 vss.t35 vbn_vco.t5 a_20880_0.t2 vss.t34 nfet_03v3 ad=1.22p pd=5.22u as=0.52p ps=2.52u w=2u l=0.5u
X122 vco_out.t4 nb.t7 vss.t123 vss.t122 nfet_03v3 ad=0.78p pd=3.52u as=1.83p ps=7.22u w=3u l=0.28u
X123 r3.t0 r2.t7 a_18140_1144.t2 vdd.t25 pfet_03v3 ad=0.78p pd=3.52u as=1.95p ps=7.3u w=3u l=0.28u
X124 a_18824_1144.t3 vbp_vco.t14 vdd.t82 vdd.t81 pfet_03v3 ad=1.3p pd=5.52u as=3.25p ps=11.3u w=5u l=0.5u
X125 a_14400_18110 a_15000_10658 vss.t26 ppolyf_u r_width=1u r_length=36.6u
X126 vref.t0 a_6000_10658 vss.t30 ppolyf_u r_width=1u r_length=30u
X127 vss.t101 nb.t6 vco_out.t2 vss.t100 nfet_03v3 ad=1.83p pd=7.22u as=0.78p ps=3.52u w=3u l=0.28u
X128 nb.t1 r5.t9 vdd.t9 vdd.t8 pfet_03v3 ad=0.52p pd=2.52u as=1.3p ps=5.3u w=2u l=0.28u
X129 vnt.t1 vref.t5 vss.t81 vss.t80 nfet_03v3 ad=1.22p pd=5.22u as=1.22p ps=5.22u w=2u l=2u
X130 a_19508_1144.t1 r3.t6 r4.t0 vdd.t17 pfet_03v3 ad=1.95p pd=7.3u as=0.78p ps=3.52u w=3u l=0.28u
X131 vnt.t6 vref.t9 vss.t152 vss.t151 nfet_03v3 ad=1.22p pd=5.22u as=1.22p ps=5.22u w=2u l=2u
X132 vcp_n.t6 cp_trim1.t1 t2.t1 vss.t86 nfet_03v3 ad=1.22p pd=5.22u as=1.22p ps=5.22u w=2u l=0.28u
X133 vdd.t93 vbp_vco.t9 a_20192_1144.t3 vdd.t92 pfet_03v3 ad=3.25p pd=11.3u as=1.3p ps=5.52u w=5u l=0.5u
X134 a_12000_18110 a_11400_10658 vss.t104 ppolyf_u r_width=1u r_length=36.6u
X135 vi.t4 vref.t10 vss.t154 vss.t153 nfet_03v3 ad=1.22p pd=5.22u as=1.22p ps=5.22u w=2u l=2u
X136 a_20196_0.t1 vbn_vco.t8 vss.t23 vss.t22 nfet_03v3 ad=0.52p pd=2.52u as=1.22p ps=5.22u w=2u l=0.5u
X137 vss.t13 vbn_vco.t11 a_18828_0.t0 vss.t12 nfet_03v3 ad=1.22p pd=5.22u as=0.52p ps=2.52u w=2u l=0.5u
X138 a_20196_0.t3 r5.t6 r1.t1 vss.t103 nfet_03v3 ad=0.915p pd=4.22u as=0.39p ps=2.02u w=1.5u l=0.28u
X139 up_b.t0 pfd_up.t2 vss.t119 vss.t118 nfet_03v3 ad=0.61p pd=3.22u as=0.61p ps=3.22u w=1u l=0.28u
X140 r4.t1 r3.t7 a_19508_1144.t0 vdd.t18 pfet_03v3 ad=0.78p pd=3.52u as=1.95p ps=7.3u w=3u l=0.28u
X141 va.t2 en_b.t4 vss.t166 vss.t165 nfet_03v3 ad=0.61p pd=3.22u as=0.61p ps=3.22u w=1u l=0.28u
X142 a_1200_18290 a_2000_10658 vss.t130 ppolyf_u r_width=2u r_length=37.5u
X143 a_19512_0.t0 vbn_vco.t10 vss.t11 vss.t10 nfet_03v3 ad=0.52p pd=2.52u as=1.22p ps=5.22u w=2u l=0.5u
X144 vcp_n.t11 en_b.t7 vss.t65 vss.t64 nfet_03v3 ad=0.61p pd=3.22u as=0.61p ps=3.22u w=1u l=0.28u
X145 vbl.t4 vctrl.t9 vbt.t8 vdd.t71 pfet_03v3 ad=3.25p pd=11.3u as=3.25p ps=11.3u w=5u l=1u
X146 r1.t0 r5.t7 a_20196_0.t0 vss.t5 nfet_03v3 ad=0.39p pd=2.02u as=0.915p ps=4.22u w=1.5u l=0.28u
X147 a_18140_1144.t0 vbp_vco.t16 vdd.t77 vdd.t76 pfet_03v3 ad=1.3p pd=5.52u as=3.25p ps=11.3u w=5u l=0.5u
X148 vfilt vss.t52 cap_nmos_03v3_b c_width=35u c_length=12u
X149 a_18144_0.t3 r2.t4 r3.t3 vss.t167 nfet_03v3 ad=0.915p pd=4.22u as=0.39p ps=2.02u w=1.5u l=0.28u
X150 vi.t0 vctrl.t4 vs.t1 vss.t92 nfet_03v3 ad=3.05p pd=11.22u as=3.05p ps=11.22u w=5u l=1u
X151 vctrl.t0 up_b.t2 up_s.t2 vdd.t31 pfet_03v3 ad=2.6p pd=9.3u as=2.6p ps=9.3u w=4u l=0.5u
X152 vst.t2 vref.t4 vss.t147 vss.t146 nfet_03v3 ad=3.05p pd=11.22u as=3.05p ps=11.22u w=5u l=1u
X153 va.t0 vref.t7 vss.t125 vss.t124 nfet_03v3 ad=1.22p pd=5.22u as=1.22p ps=5.22u w=2u l=2u
X154 t1a.t0 vbp.t12 vdd.t65 vdd.t64 pfet_03v3 ad=2.6p pd=9.3u as=2.6p ps=9.3u w=4u l=2u
X155 a_18144_0.t0 vbn_vco.t14 vss.t69 vss.t68 nfet_03v3 ad=0.52p pd=2.52u as=1.22p ps=5.22u w=2u l=0.5u
X156 a_20880_0.t0 r4.t4 r5.t3 vss.t28 nfet_03v3 ad=0.915p pd=4.22u as=0.39p ps=2.02u w=1.5u l=0.28u
X157 vdump.t5 vdump.t4 vbt.t3 vdd.t117 pfet_03v3 ad=3.25p pd=11.3u as=3.25p ps=11.3u w=5u l=1u
X158 vfilt vss.t36 cap_nmos_03v3_b c_width=35u c_length=12u
X159 vfilt vss.t58 cap_nmos_03v3_b c_width=35u c_length=12u
X160 vbn_vco.t3 vbn_vco.t2 vss.t79 vss.t78 nfet_03v3 ad=2.44p pd=9.22u as=2.44p ps=9.22u w=4u l=0.5u
X161 nb.t2 r5.t5 a_21564_n100.t0 vss.t102 nfet_03v3 ad=0.52p pd=2.52u as=1.22p ps=5.22u w=2u l=0.28u
X162 a_19508_1144.t3 vbp_vco.t12 vdd.t58 vdd.t57 pfet_03v3 ad=1.3p pd=5.52u as=3.25p ps=11.3u w=5u l=0.5u
X163 r5.t2 r4.t5 a_20880_0.t1 vss.t29 nfet_03v3 ad=0.39p pd=2.02u as=0.915p ps=4.22u w=1.5u l=0.28u
X164 a_18828_0.t2 r1.t4 r2.t1 vss.t149 nfet_03v3 ad=0.915p pd=4.22u as=0.39p ps=2.02u w=1.5u l=0.28u
X165 vco_out.t3 nb.t11 vdd.t86 vdd.t85 pfet_03v3 ad=0.78p pd=3.52u as=1.95p ps=7.3u w=3u l=0.28u
X166 vfilt vss.t50 cap_nmos_03v3_b c_width=35u c_length=12u
X167 a_7800_16790 a_7200_10658 vss.t70 ppolyf_u r_width=1u r_length=30u
X168 en_b.t1 pll_en.t7 vdd.t109 vdd.t108 pfet_03v3 ad=1.3p pd=5.3u as=1.3p ps=5.3u w=2u l=0.28u
X169 up_s.t0 vcp_p.t8 vdd.t75 vdd.t74 pfet_03v3 ad=16.25p pd=51.3u as=16.25p ps=51.3u w=25u l=2u
X170 vctrl.t11 vss.t88 cap_nmos_03v3_b c_width=43u c_length=12u
X171 vcp_p.t1 vcp_p.t0 vdd.t12 vdd.t11 pfet_03v3 ad=16.25p pd=51.3u as=16.25p ps=51.3u w=25u l=2u
X172 vbt.t11 vbp.t15 vdd.t88 vdd.t87 pfet_03v3 ad=2.6p pd=9.3u as=2.6p ps=9.3u w=4u l=2u
X173 vdd.t39 nb.t10 vco_out.t1 vdd.t38 pfet_03v3 ad=1.95p pd=7.3u as=0.78p ps=3.52u w=3u l=0.28u
X174 a_13200_18110 a_13800_10658 vss.t61 ppolyf_u r_width=1u r_length=36.6u
X175 vbp_vco.t1 pll_en.t4 vi.t3 vss.t139 nfet_03v3 ad=3.05p pd=11.22u as=3.05p ps=11.22u w=5u l=0.28u
X176 vbt.t0 vbp.t7 vdd.t28 vdd.t27 pfet_03v3 ad=2.6p pd=9.3u as=2.6p ps=9.3u w=4u l=2u
X177 vcl.t4 a_4200_10658 vss.t148 ppolyf_u r_width=1u r_length=17.5u
X178 vbp.t4 pll_en.t8 vdd.t107 vdd.t106 pfet_03v3 ad=0.65p pd=3.3u as=0.65p ps=3.3u w=1u l=0.28u
R0 vco_out vco_out.n1 5.2175
R1 vco_out.n1 vco_out.n4 5.3705
R2 vco_out.n4 vco_out.n3 6.71734
R3 vco_out.n3 vco_out.t4 0.5465
R4 vco_out.n3 vco_out.t2 0.5465
R5 vco_out.n4 vco_out.n2 6.55734
R6 vco_out.n2 vco_out.t3 0.607167
R7 vco_out.n2 vco_out.t1 0.607167
R8 vco_out.n1 vco_out.n0 11.0573
R9 vco_out.n0 vco_out.t0 0.607167
R10 vco_out.n0 vco_out.t5 0.607167
R11 bias_ref bias_ref.n0 36.7678
R12 bias_ref.n0 bias_ref.t1 20.1588
R13 bias_ref.n0 bias_ref.t0 22.9937
R14 pll_en.n3 pll_en.n2 4.5005
R15 pll_en pll_en.n3 7.2935
R16 pll_en.n3 pll_en.n9 11.6315
R17 pll_en.n7 pll_en.n6 4.5005
R18 pll_en.n9 pll_en.n7 3.2675
R19 pll_en.n9 pll_en.n8 5.6165
R20 pll_en.n8 pll_en.t4 95.7514
R21 pll_en.n8 pll_en.t5 94.6489
R22 pll_en.n5 pll_en.n4 1.121
R23 pll_en.n6 pll_en.n5 8.411
R24 pll_en.n6 pll_en.t6 43.3298
R25 pll_en.n5 pll_en.t7 56.073
R26 pll_en.n4 pll_en.t8 43.2623
R27 pll_en.n4 pll_en.t9 43.8878
R28 pll_en.n7 pll_en.t10 74.3368
R29 pll_en.n2 pll_en.n1 4.81503
R30 pll_en.n1 pll_en.t0 45.7328
R31 pll_en.n1 pll_en.t1 45.5434
R32 pll_en.n2 pll_en.n0 5.35676
R33 pll_en.n0 pll_en.t2 45.7328
R34 pll_en.n0 pll_en.t3 45.5434
R35 pfd_up.n0 pfd_up.n1 7.5875
R36 pfd_up pfd_up.n0 11.138
R37 pfd_up.n1 pfd_up.t2 70.0393
R38 pfd_up.n0 pfd_up.t0 55.5402
R39 pfd_up.n1 pfd_up.t1 57.2205
R40 cp_trim1 cp_trim1.n0 20.5475
R41 cp_trim1.n0 cp_trim1.t0 58.2418
R42 cp_trim1.n0 cp_trim1.t1 59.4568
R43 cp_trim0 cp_trim0.n0 21.155
R44 cp_trim0.n0 cp_trim0.t0 57.7018
R45 cp_trim0.n0 cp_trim0.t1 58.9168
R46 pfd_dn.n0 pfd_dn.n1 24.8067
R47 pfd_dn pfd_dn.n0 18.167
R48 pfd_dn.n1 pfd_dn.t1 45.1386
R49 pfd_dn.n1 pfd_dn.t2 47.1975
R50 pfd_dn.n0 pfd_dn.t0 56.973
R51 vctrl.n4 vctrl.n3 4.5005
R52 vctrl.n10 vctrl.n9 4.5005
R53 vctrl vctrl.n10 17.9758
R54 vctrl.n10 vctrl.n4 3.4475
R55 vctrl.n4 vctrl.n6 10.823
R56 vctrl.n6 vctrl.n5 4.60625
R57 vctrl.n9 vctrl.n7 3.686
R58 vctrl.n9 vctrl.n8 16.8395
R59 vctrl.n8 vctrl.t3 40.7877
R60 vctrl.n8 vctrl.t4 40.0182
R61 vctrl.n7 vctrl.t5 40.0182
R62 vctrl.n7 vctrl.t6 42.3267
R63 vctrl.n6 vctrl.t2 24.3534
R64 vctrl.n5 vctrl.t1 20.2391
R65 vctrl.n5 vctrl.t11 61.6502
R66 vctrl.n1 vctrl.n0 1.283
R67 vctrl.n3 vctrl.n1 2.336
R68 vctrl.n3 vctrl.n2 0.0275
R69 vctrl.n2 vctrl.t0 24.6622
R70 vctrl.n2 vctrl.t7 40.1274
R71 vctrl.n1 vctrl.t8 40.1274
R72 vctrl.n0 vctrl.t9 40.1274
R73 vctrl.n0 vctrl.t10 42.4899
R74 vdd.n82 vdd.n81 4.5005
R75 vdd vdd.n82 20.8827
R76 vdd.n82 vdd.n28 28.0558
R77 vdd.n30 vdd.n29 3.6455
R78 vdd.n31 vdd.n30 0.43475
R79 vdd.n32 vdd.n31 1.013
R80 vdd.n33 vdd.n32 1.013
R81 vdd.n34 vdd.n33 1.07375
R82 vdd.n35 vdd.n34 0.43475
R83 vdd.n36 vdd.n35 1.013
R84 vdd.n37 vdd.n36 0.626
R85 vdd.n81 vdd.n37 0.22325
R86 vdd.n81 vdd.n38 0.40325
R87 vdd.n38 vdd.n39 0.626
R88 vdd.n39 vdd.n40 0.68675
R89 vdd.n40 vdd.n41 0.43475
R90 vdd.n41 vdd.n42 0.626
R91 vdd.n42 vdd.n43 2.87375
R92 vdd.n43 vdd.n56 1.013
R93 vdd.n56 vdd.n44 0.77225
R94 vdd.n44 vdd.n45 0.6755
R95 vdd.n45 vdd.n46 0.6755
R96 vdd.n46 vdd.n47 0.73625
R97 vdd.n47 vdd.n48 0.43475
R98 vdd.n48 vdd.n49 0.6755
R99 vdd.n56 vdd.n57 23.7493
R100 vdd.n57 vdd.n64 0.344
R101 vdd.n64 vdd.n65 0.3545
R102 vdd.n65 vdd.n66 0.1595
R103 vdd.n66 vdd.n59 0.344
R104 vdd.n59 vdd.n67 0.011
R105 vdd.n67 vdd.n68 0.1595
R106 vdd.n68 vdd.n69 0.3545
R107 vdd.n69 vdd.n70 0.1595
R108 vdd.n70 vdd.n71 0.3545
R109 vdd.n71 vdd.n72 0.1595
R110 vdd.n72 vdd.n61 0.005
R111 vdd.n61 vdd.n73 0.35
R112 vdd.n73 vdd.n74 0.1595
R113 vdd.n74 vdd.n75 0.2885
R114 vdd.n75 vdd.n76 0.1595
R115 vdd.n76 vdd.n63 0.245
R116 vdd.n63 vdd.n77 0.044
R117 vdd.n77 vdd.n78 0.1595
R118 vdd.n78 vdd.n79 0.2885
R119 vdd.n79 vdd.n80 0.1595
R120 vdd.n80 vdd.t98 4.86639
R121 vdd.n80 vdd.t37 4.57839
R122 vdd.n79 vdd.t39 4.57839
R123 vdd.n78 vdd.t86 4.57839
R124 vdd.n77 vdd.t113 5.88015
R125 vdd.n76 vdd.t115 5.88015
R126 vdd.n75 vdd.t5 5.88015
R127 vdd.n74 vdd.t9 5.88015
R128 vdd.n73 vdd.t20 2.01891
R129 vdd.n72 vdd.t91 2.01891
R130 vdd.n71 vdd.t93 2.01891
R131 vdd.n70 vdd.t45 2.01891
R132 vdd.n69 vdd.t47 2.01891
R133 vdd.n68 vdd.t58 2.01891
R134 vdd.n67 vdd.t60 2.01891
R135 vdd.n66 vdd.t82 2.01891
R136 vdd.n65 vdd.t84 2.01891
R137 vdd.n64 vdd.t77 2.01891
R138 vdd.n59 vdd.n58 12.6005
R139 vdd.n61 vdd.n60 12.6005
R140 vdd.n63 vdd.n62 12.6005
R141 vdd.n57 vdd.t25 203.619
R142 vdd.t25 vdd.t76 7.37315
R143 vdd.t76 vdd.t99 46.2471
R144 vdd.t99 vdd.t83 22.1185
R145 vdd.t83 vdd.t80 153.486
R146 vdd.t81 vdd.t80 7.37315
R147 vdd.t56 vdd.t81 46.2471
R148 vdd.t59 vdd.t56 22.1185
R149 vdd.n58 vdd.t59 40.215
R150 vdd.n58 vdd.t18 113.272
R151 vdd.t18 vdd.t57 7.37315
R152 vdd.t57 vdd.t17 46.2471
R153 vdd.t17 vdd.t46 22.1185
R154 vdd.t46 vdd.t89 153.486
R155 vdd.t44 vdd.t89 7.37315
R156 vdd.t10 vdd.t44 46.2471
R157 vdd.t92 vdd.t10 22.1185
R158 vdd.n60 vdd.t92 117.963
R159 vdd.n60 vdd.t3 35.5233
R160 vdd.t3 vdd.t90 7.37315
R161 vdd.t90 vdd.t2 46.2471
R162 vdd.t2 vdd.t19 22.1185
R163 vdd.t19 vdd.t8 153.486
R164 vdd.t8 vdd.t4 53.6198
R165 vdd.t114 vdd.t4 146.113
R166 vdd.t112 vdd.t114 53.6198
R167 vdd.n62 vdd.t112 18.097
R168 vdd.n62 vdd.t85 128.017
R169 vdd.t85 vdd.t38 53.6198
R170 vdd.t38 vdd.t36 146.113
R171 vdd.t36 vdd.t97 53.6198
R172 vdd.n29 vdd.t70 438.584
R173 vdd.t70 vdd.t117 505.781
R174 vdd.t117 vdd.t61 505.781
R175 vdd.t71 vdd.t61 505.781
R176 vdd.n50 vdd.t71 411.851
R177 vdd.n50 vdd.t72 411.851
R178 vdd.t72 vdd.t26 505.781
R179 vdd.t26 vdd.t116 505.781
R180 vdd.t73 vdd.t116 505.781
R181 vdd.n51 vdd.t73 411.851
R182 vdd.n51 vdd.t40 484.104
R183 vdd.t40 vdd.t15 650.289
R184 vdd.t42 vdd.t15 650.289
R185 vdd.n52 vdd.t42 484.104
R186 vdd.n52 vdd.t54 484.104
R187 vdd.t54 vdd.t94 526.013
R188 vdd.t94 vdd.t48 401.735
R189 vdd.t104 vdd.t48 401.735
R190 vdd.t106 vdd.t104 401.735
R191 vdd.n53 vdd.t106 359.827
R192 vdd.n53 vdd.t108 359.827
R193 vdd.t108 vdd.t23 1104.05
R194 vdd.n54 vdd.t23 1062.14
R195 vdd.n54 vdd.t31 375.724
R196 vdd.t31 vdd.t96 433.526
R197 vdd.t96 vdd.t21 433.526
R198 vdd.t21 vdd.t118 433.526
R199 vdd.t78 vdd.t118 433.526
R200 vdd.n55 vdd.t78 375.724
R201 vdd.n55 vdd.t120 375.724
R202 vdd.t120 vdd.t110 417.63
R203 vdd.n49 vdd.t110 383.603
R204 vdd.n47 vdd.n55 23.09
R205 vdd.n43 vdd.n54 23.09
R206 vdd.n40 vdd.n53 23.09
R207 vdd.n34 vdd.n52 23.09
R208 vdd.n30 vdd.n51 23.09
R209 vdd.n29 vdd.n50 23.09
R210 vdd.n49 vdd.t111 18.6345
R211 vdd.n48 vdd.t121 11.2274
R212 vdd.n46 vdd.t79 11.2274
R213 vdd.n45 vdd.t119 11.2274
R214 vdd.n44 vdd.t22 11.2274
R215 vdd.n42 vdd.t24 21.6308
R216 vdd.n41 vdd.t109 13.5844
R217 vdd.n39 vdd.t107 18.6345
R218 vdd.n38 vdd.t105 18.6345
R219 vdd.n37 vdd.t49 13.5844
R220 vdd.n36 vdd.t95 13.5844
R221 vdd.n35 vdd.t55 11.646
R222 vdd.n33 vdd.t43 11.646
R223 vdd.n32 vdd.t16 11.646
R224 vdd.n31 vdd.t41 11.646
R225 vdd.n1 vdd.n0 1.013
R226 vdd.n2 vdd.n1 1.013
R227 vdd.n3 vdd.n2 1.07375
R228 vdd.n4 vdd.n3 0.43475
R229 vdd.n5 vdd.n4 1.013
R230 vdd.n6 vdd.n5 1.013
R231 vdd.n7 vdd.n6 1.07375
R232 vdd.n8 vdd.n7 0.43475
R233 vdd.n9 vdd.n8 1.013
R234 vdd.n10 vdd.n9 1.013
R235 vdd.n11 vdd.n10 1.07375
R236 vdd.n12 vdd.n11 0.43475
R237 vdd.n13 vdd.n12 1.013
R238 vdd.n14 vdd.n13 1.013
R239 vdd.n28 vdd.n14 0.06125
R240 vdd.n28 vdd.n15 1.013
R241 vdd.n15 vdd.n16 0.43475
R242 vdd.n16 vdd.n17 1.013
R243 vdd.n17 vdd.n18 1.013
R244 vdd.n18 vdd.n19 1.07375
R245 vdd.n19 vdd.n20 0.43475
R246 vdd.n20 vdd.n21 1.013
R247 vdd.n21 vdd.n22 1.013
R248 vdd.n0 vdd.t11 152.468
R249 vdd.t11 vdd.t74 167.162
R250 vdd.t102 vdd.t74 167.162
R251 vdd.n23 vdd.t102 124.444
R252 vdd.n23 vdd.t6 124.444
R253 vdd.t6 vdd.t34 167.162
R254 vdd.t100 vdd.t34 167.162
R255 vdd.n24 vdd.t100 124.444
R256 vdd.n24 vdd.t87 124.444
R257 vdd.t87 vdd.t50 167.162
R258 vdd.t66 vdd.t50 167.162
R259 vdd.n25 vdd.t66 124.444
R260 vdd.n25 vdd.t64 124.444
R261 vdd.t64 vdd.t32 167.162
R262 vdd.t68 vdd.t32 167.162
R263 vdd.n26 vdd.t68 124.444
R264 vdd.n26 vdd.t52 124.444
R265 vdd.t52 vdd.t13 167.162
R266 vdd.t13 vdd.t0 167.162
R267 vdd.n27 vdd.t0 124.444
R268 vdd.n27 vdd.t27 124.444
R269 vdd.t27 vdd.t62 167.162
R270 vdd.t62 vdd.t29 167.162
R271 vdd.n22 vdd.t29 153.107
R272 vdd.n19 vdd.n27 27.59
R273 vdd.n15 vdd.n26 27.59
R274 vdd.n11 vdd.n25 27.59
R275 vdd.n7 vdd.n24 27.59
R276 vdd.n3 vdd.n23 27.59
R277 vdd.n22 vdd.t30 16.146
R278 vdd.n21 vdd.t63 16.146
R279 vdd.n20 vdd.t28 16.146
R280 vdd.n18 vdd.t1 16.146
R281 vdd.n17 vdd.t14 16.146
R282 vdd.n16 vdd.t53 16.146
R283 vdd.n14 vdd.t69 16.146
R284 vdd.n13 vdd.t33 16.146
R285 vdd.n12 vdd.t65 16.146
R286 vdd.n10 vdd.t67 16.146
R287 vdd.n9 vdd.t51 16.146
R288 vdd.n8 vdd.t88 16.146
R289 vdd.n6 vdd.t101 16.146
R290 vdd.n5 vdd.t35 16.146
R291 vdd.n4 vdd.t7 12.6482
R292 vdd.n2 vdd.t103 12.6482
R293 vdd.n1 vdd.t75 12.6482
R294 vdd.n0 vdd.t12 12.6482
R295 vss.n72 vss.n71 4.5005
R296 vss.n74 vss.n73 4.5005
R297 vss.n76 vss.n75 4.5005
R298 vss.n178 vss.n177 4.5005
R299 vss vss.n178 17.4357
R300 vss.n178 vss.n76 14.63
R301 vss.n76 vss.n74 4.06625
R302 vss.n74 vss.n72 18.7059
R303 vss.n72 vss.n32 15.6189
R304 vss.n78 vss.n77 0.43025
R305 vss.n79 vss.n78 0.995
R306 vss.n80 vss.n79 0.995
R307 vss.n81 vss.n80 1.06025
R308 vss.n82 vss.n81 0.43025
R309 vss.n83 vss.n82 0.995
R310 vss.n84 vss.n83 0.995
R311 vss.n85 vss.n84 1.06025
R312 vss.n86 vss.n85 0.43025
R313 vss.n87 vss.n86 0.995
R314 vss.n177 vss.n87 0.08375
R315 vss.n177 vss.n88 0.91175
R316 vss.n88 vss.n89 1.06025
R317 vss.n89 vss.n90 0.43025
R318 vss.n90 vss.n91 1.7645
R319 vss.n91 vss.n92 0.77
R320 vss.n92 vss.n93 0.83525
R321 vss.n93 vss.n94 0.43025
R322 vss.n94 vss.n102 1.36175
R323 vss.n102 vss.n95 0.08375
R324 vss.n95 vss.n96 0.608
R325 vss.n96 vss.n97 0.608
R326 vss.n97 vss.n98 0.67325
R327 vss.n98 vss.n99 0.43025
R328 vss.n99 vss.n100 0.6575
R329 vss.n100 vss.n101 2.81975
R330 vss.n104 vss.n103 10.4005
R331 vss.n106 vss.n105 10.4005
R332 vss.n108 vss.n107 10.4005
R333 vss.n163 vss.n162 10.4005
R334 vss.n102 vss.n104 26.0292
R335 vss.n104 vss.n176 0.344
R336 vss.n176 vss.n175 0.3485
R337 vss.n175 vss.n174 0.1655
R338 vss.n174 vss.n106 0.344
R339 vss.n106 vss.n173 0.005
R340 vss.n173 vss.n172 0.1655
R341 vss.n172 vss.n171 0.3485
R342 vss.n171 vss.n170 0.1655
R343 vss.n170 vss.n169 0.3485
R344 vss.n169 vss.n168 0.1655
R345 vss.n168 vss.n108 0.005
R346 vss.n108 vss.n167 0.344
R347 vss.n167 vss.n166 0.6125
R348 vss.n166 vss.n163 0.245
R349 vss.n163 vss.n165 0.038
R350 vss.n165 vss.n164 0.1655
R351 vss.n176 vss.t69 3.85787
R352 vss.n175 vss.t134 3.85787
R353 vss.n174 vss.t132 3.85787
R354 vss.n173 vss.t13 3.85787
R355 vss.n172 vss.t11 3.85787
R356 vss.n171 vss.t25 3.85787
R357 vss.n170 vss.t23 3.85787
R358 vss.n169 vss.t83 3.85787
R359 vss.n168 vss.t97 3.85787
R360 vss.n167 vss.t35 3.85787
R361 vss.n166 vss.t141 4.97103
R362 vss.n165 vss.t143 4.97103
R363 vss.n164 vss.t123 3.59261
R364 vss.n164 vss.t101 3.87461
R365 vss.n103 vss.n156 397.483
R366 vss.n103 vss.t129 661.692
R367 vss.t129 vss.t68 25.7199
R368 vss.t68 vss.t167 161.332
R369 vss.t167 vss.t133 77.1588
R370 vss.t133 vss.t150 535.433
R371 vss.t131 vss.t150 25.7199
R372 vss.t149 vss.t131 161.332
R373 vss.t12 vss.t149 77.1588
R374 vss.n105 vss.t12 144.964
R375 vss.n105 vss.t109 390.469
R376 vss.t109 vss.t10 25.7199
R377 vss.t10 vss.t108 161.332
R378 vss.t108 vss.t24 77.1588
R379 vss.t24 vss.t5 535.433
R380 vss.t22 vss.t5 25.7199
R381 vss.t103 vss.t22 161.332
R382 vss.t82 vss.t103 77.1588
R383 vss.n107 vss.t82 416.188
R384 vss.n107 vss.t29 119.246
R385 vss.t29 vss.t96 25.7199
R386 vss.t96 vss.t28 161.332
R387 vss.t28 vss.t34 77.1588
R388 vss.t34 vss.t102 535.433
R389 vss.t102 vss.t126 187.05
R390 vss.t140 vss.t126 509.712
R391 vss.t142 vss.t140 187.05
R392 vss.n162 vss.t142 67.8063
R393 vss.n162 vss.t122 441.906
R394 vss.t122 vss.t100 187.05
R395 vss.n77 vss.t90 226.969
R396 vss.t90 vss.t60 246.507
R397 vss.t60 vss.t117 246.507
R398 vss.t91 vss.t117 246.507
R399 vss.n157 vss.t91 202.54
R400 vss.n157 vss.t2 238.578
R401 vss.t2 vss.t111 318.586
R402 vss.t113 vss.t111 318.586
R403 vss.n158 vss.t113 238.578
R404 vss.n158 vss.t66 238.578
R405 vss.t66 vss.t153 318.586
R406 vss.t151 vss.t153 318.586
R407 vss.n159 vss.t151 238.578
R408 vss.n159 vss.t115 238.578
R409 vss.t115 vss.t124 318.586
R410 vss.t124 vss.t159 318.586
R411 vss.n160 vss.t159 238.578
R412 vss.n160 vss.t80 238.578
R413 vss.t80 vss.t31 282.546
R414 vss.t31 vss.t146 246.507
R415 vss.t163 vss.t146 246.507
R416 vss.n161 vss.t163 202.54
R417 vss.n161 vss.t157 310.656
R418 vss.t157 vss.n156 215.513
R419 vss.n93 vss.n161 20.8562
R420 vss.n89 vss.n160 20.8562
R421 vss.n85 vss.n159 20.8562
R422 vss.n81 vss.n158 20.8562
R423 vss.n77 vss.n157 20.8562
R424 vss.n156 vss.t74 313.615
R425 vss.t74 vss.t165 539.337
R426 vss.t62 vss.t165 539.337
R427 vss.n109 vss.t62 489.399
R428 vss.n109 vss.t78 511.372
R429 vss.t78 vss.t84 561.309
R430 vss.t84 vss.t92 611.249
R431 vss.t92 vss.t93 683.159
R432 vss.t138 vss.t93 611.249
R433 vss.n110 vss.t138 489.399
R434 vss.n110 vss.n155 415.49
R435 vss.n155 vss.t139 73.9095
R436 vss.t139 vss.n101 511.356
R437 vss.n119 vss.n111 21.9812
R438 vss.n123 vss.n112 21.9812
R439 vss.n124 vss.n113 21.9812
R440 vss.n130 vss.n114 21.9812
R441 vss.n134 vss.t110 3.46717
R442 vss.n135 vss.t107 3.46717
R443 vss.n136 vss.t130 3.46717
R444 vss.n137 vss.t135 3.46717
R445 vss.n138 vss.t4 10.4005
R446 vss.n139 vss.t148 10.4005
R447 vss.n140 vss.t30 10.4005
R448 vss.n141 vss.t32 10.4005
R449 vss.n142 vss.t105 10.4005
R450 vss.n143 vss.t70 10.4005
R451 vss.n144 vss.t144 10.4005
R452 vss.n145 vss.t9 10.4005
R453 vss.n146 vss.t76 10.4005
R454 vss.n147 vss.t145 10.4005
R455 vss.n148 vss.t77 10.4005
R456 vss.n149 vss.t104 10.4005
R457 vss.n150 vss.t27 10.4005
R458 vss.n151 vss.t33 10.4005
R459 vss.n152 vss.t61 10.4005
R460 vss.n153 vss.t8 10.4005
R461 vss.n154 vss.t26 8.87793
R462 vss.n116 vss.t110 126.885
R463 vss.t110 vss.t6 33.8503
R464 vss.t6 vss.t107 133.31
R465 vss.t107 vss.t155 51.4021
R466 vss.t155 vss.t130 115.758
R467 vss.t130 vss.t98 68.9538
R468 vss.t98 vss.t135 98.2068
R469 vss.t135 vss.n111 40.1188
R470 vss.n111 vss.t94 138.326
R471 vss.t4 vss.t94 93.192
R472 vss.t4 vss.t120 91.5204
R473 vss.t148 vss.t120 33.8503
R474 vss.t148 vss.t0 150.863
R475 vss.t30 vss.t0 99.8783
R476 vss.t30 vss.t71 53.4916
R477 vss.t71 vss.t32 71.8791
R478 vss.t32 vss.n112 35.104
R479 vss.n112 vss.t105 90.2667
R480 vss.t105 vss.t106 16.7165
R481 vss.t106 vss.t70 108.654
R482 vss.t70 vss.t127 8.77638
R483 vss.t127 vss.t86 112.834
R484 vss.t144 vss.t86 3.76159
R485 vss.t144 vss.t128 109.073
R486 vss.t9 vss.t128 16.2986
R487 vss.t9 vss.t87 96.5352
R488 vss.n113 vss.t87 102.385
R489 vss.n113 vss.t76 51.82
R490 vss.t76 vss.t118 50.5663
R491 vss.t118 vss.t145 74.8044
R492 vss.t145 vss.t72 38.0293
R493 vss.t72 vss.t77 87.3414
R494 vss.t77 vss.t64 25.4923
R495 vss.t64 vss.t104 99.8783
R496 vss.t104 vss.t136 12.9554
R497 vss.t136 vss.t27 112.415
R498 vss.t27 vss.t20 36.3577
R499 vss.t20 vss.t33 89.013
R500 vss.t33 vss.n114 49.3126
R501 vss.n114 vss.t61 76.0581
R502 vss.t61 vss.t18 62.2674
R503 vss.t18 vss.t8 63.1032
R504 vss.t8 vss.t16 121.609
R505 vss.t26 vss.t16 3.76159
R506 vss.n154 vss.t161 9.4844
R507 vss.t161 vss.t14 55.5811
R508 vss.t14 vss.n115 138.326
R509 vss.n115 vss.n155 3561.15
R510 vss.n134 vss.n135 0.947868
R511 vss.n135 vss.n136 0.947868
R512 vss.n136 vss.n137 0.947868
R513 vss.n137 vss.n138 1.53997
R514 vss.n138 vss.n139 0.711026
R515 vss.n139 vss.n140 1.42155
R516 vss.n140 vss.n141 0.711026
R517 vss.n141 vss.n142 0.711026
R518 vss.n142 vss.n143 0.711026
R519 vss.n143 vss.n144 0.711026
R520 vss.n144 vss.n145 0.711026
R521 vss.n145 vss.n146 1.42155
R522 vss.n146 vss.n147 0.711026
R523 vss.n147 vss.n148 0.711026
R524 vss.n148 vss.n149 0.711026
R525 vss.n149 vss.n150 0.711026
R526 vss.n150 vss.n151 0.711026
R527 vss.n151 vss.n152 0.711026
R528 vss.n152 vss.n153 0.711026
R529 vss.n153 vss.n154 1.49822
R530 vss.n75 vss.n134 30.7502
R531 vss.n75 vss.t162 25.4912
R532 vss.n133 vss.n115 23.041
R533 vss.n117 vss.n116 0.995
R534 vss.n118 vss.n117 0.995
R535 vss.n119 vss.n118 1.06025
R536 vss.n120 vss.n119 0.43025
R537 vss.n121 vss.n120 0.995
R538 vss.n122 vss.n121 0.995
R539 vss.n123 vss.n122 1.71725
R540 vss.n124 vss.n123 3.5825
R541 vss.n125 vss.n124 0.43025
R542 vss.n73 vss.n125 0.41225
R543 vss.n73 vss.n126 0.19625
R544 vss.n126 vss.n127 0.608
R545 vss.n127 vss.n128 0.608
R546 vss.n128 vss.n129 0.608
R547 vss.n129 vss.n130 1.06025
R548 vss.n130 vss.n131 0.43025
R549 vss.n131 vss.n132 0.995
R550 vss.n132 vss.n133 0.995
R551 vss.n133 vss.t15 11.1876
R552 vss.n132 vss.t17 11.1876
R553 vss.n131 vss.t19 11.1876
R554 vss.n129 vss.t21 11.1876
R555 vss.n128 vss.t137 20.4058
R556 vss.n127 vss.t65 20.4058
R557 vss.n126 vss.t73 20.4058
R558 vss.n125 vss.t119 20.4058
R559 vss.n122 vss.t1 11.1876
R560 vss.n121 vss.t121 11.1876
R561 vss.n120 vss.t95 11.1876
R562 vss.n118 vss.t99 11.1876
R563 vss.n117 vss.t156 11.1876
R564 vss.n116 vss.t7 11.1876
R565 vss.n101 vss.n110 20.8562
R566 vss.n98 vss.n109 20.8562
R567 vss.n100 vss.t85 19.2808
R568 vss.n99 vss.t79 11.6644
R569 vss.n97 vss.t63 19.2808
R570 vss.n96 vss.t166 19.2808
R571 vss.n95 vss.t75 19.2808
R572 vss.n94 vss.t158 21.857
R573 vss.n92 vss.t164 11.2319
R574 vss.n91 vss.t147 11.2319
R575 vss.n90 vss.t81 13.7073
R576 vss.n88 vss.t160 13.7073
R577 vss.n87 vss.t125 13.7073
R578 vss.n86 vss.t116 13.7073
R579 vss.n84 vss.t152 13.7073
R580 vss.n83 vss.t154 13.7073
R581 vss.n82 vss.t67 13.7073
R582 vss.n80 vss.t114 13.7073
R583 vss.n79 vss.t112 13.7073
R584 vss.n78 vss.t3 13.7073
R585 vss.n34 vss.n33 3.3485
R586 vss.n35 vss.n34 3.3485
R587 vss.n71 vss.n35 2.13575
R588 vss.n71 vss.n36 1.21325
R589 vss.n36 vss.n37 3.3485
R590 vss.n39 vss.n38 0.0868014
R591 vss.n40 vss.n39 0.0868014
R592 vss.n37 vss.n40 14.3926
R593 vss.n40 vss.n70 4.57882
R594 vss.t58 vss.n70 0.0473
R595 vss.n42 vss.n41 0.0868014
R596 vss.n44 vss.n43 0.0868014
R597 vss.n46 vss.n45 0.0868014
R598 vss.n47 vss.n46 0.0868014
R599 vss.n49 vss.n48 0.0868014
R600 vss.n51 vss.n50 0.0868014
R601 vss.n52 vss.n51 0.0868014
R602 vss.n54 vss.n53 0.0868014
R603 vss.n56 vss.n55 0.0868014
R604 vss.n57 vss.n56 0.0868014
R605 vss.n59 vss.n58 0.0868014
R606 vss.n61 vss.n60 0.0868014
R607 vss.n62 vss.n61 0.0868014
R608 vss.n64 vss.n63 0.0868014
R609 vss.n66 vss.n65 0.0868014
R610 vss.n67 vss.n66 0.0868014
R611 vss.n69 vss.n68 0.0868014
R612 vss.n41 vss.n43 353.161
R613 vss.n43 vss.n45 66.5544
R614 vss.n45 vss.n48 353.075
R615 vss.n48 vss.n50 66.5544
R616 vss.n50 vss.n53 353.075
R617 vss.n53 vss.n55 66.5544
R618 vss.n55 vss.n58 353.075
R619 vss.n58 vss.n60 66.5544
R620 vss.n60 vss.n63 353.075
R621 vss.n63 vss.n65 66.5544
R622 vss.n65 vss.n68 353.075
R623 vss.n68 vss.n38 66.5544
R624 vss.n38 vss.n70 353.161
R625 vss.n69 vss.n67 4.57882
R626 vss.n37 vss.n67 11.0446
R627 vss.t56 vss.n69 0.0473
R628 vss.n66 vss.t56 0.0473
R629 vss.n64 vss.n62 4.57882
R630 vss.n36 vss.n62 11.0446
R631 vss.t54 vss.n64 0.0473
R632 vss.n61 vss.t54 0.0473
R633 vss.n59 vss.n57 4.57882
R634 vss.n35 vss.n57 11.0446
R635 vss.t52 vss.n59 0.0473
R636 vss.n56 vss.t52 0.0473
R637 vss.n54 vss.n52 4.57882
R638 vss.n34 vss.n52 11.0446
R639 vss.t50 vss.n54 0.0473
R640 vss.n51 vss.t50 0.0473
R641 vss.n49 vss.n47 4.57882
R642 vss.n33 vss.n47 11.0446
R643 vss.t48 vss.n49 0.0473
R644 vss.n46 vss.t48 0.0473
R645 vss.n44 vss.n42 4.57882
R646 vss.n33 vss.n42 14.3926
R647 vss.t46 vss.n44 0.0473
R648 vss.n41 vss.t46 0.0473
R649 vss.n39 vss.t58 0.0473
R650 vss.n1 vss.n0 3.3485
R651 vss.n2 vss.n1 3.3485
R652 vss.n32 vss.n2 2.13575
R653 vss.n32 vss.n3 1.21325
R654 vss.n5 vss.n4 0.0697308
R655 vss.n6 vss.n5 0.0697308
R656 vss.n3 vss.n6 14.7418
R657 vss.n6 vss.n31 5.26015
R658 vss.t88 vss.n31 0.038593
R659 vss.n8 vss.n7 0.0868014
R660 vss.n10 vss.n9 0.0868014
R661 vss.n12 vss.n11 0.0868014
R662 vss.n13 vss.n12 0.0868014
R663 vss.n15 vss.n14 0.0868014
R664 vss.n17 vss.n16 0.0868014
R665 vss.n18 vss.n17 0.0868014
R666 vss.n20 vss.n19 0.0868014
R667 vss.n22 vss.n21 0.0868014
R668 vss.n23 vss.n22 0.0868014
R669 vss.n25 vss.n24 0.0868014
R670 vss.n27 vss.n26 0.0868014
R671 vss.n28 vss.n27 0.0868014
R672 vss.n30 vss.n29 0.0868014
R673 vss.n7 vss.n9 288.168
R674 vss.n9 vss.n11 54.3033
R675 vss.n11 vss.n14 288.082
R676 vss.n14 vss.n16 54.3033
R677 vss.n16 vss.n19 288.082
R678 vss.n19 vss.n21 54.3033
R679 vss.n21 vss.n24 288.082
R680 vss.n24 vss.n26 54.3033
R681 vss.n26 vss.n29 288.082
R682 vss.n29 vss.n4 54.3033
R683 vss.n4 vss.n31 288.151
R684 vss.n30 vss.n28 4.57882
R685 vss.n3 vss.n28 12.8446
R686 vss.t44 vss.n30 0.0473
R687 vss.n27 vss.t44 0.0473
R688 vss.n25 vss.n23 4.57882
R689 vss.n2 vss.n23 12.8446
R690 vss.t42 vss.n25 0.0473
R691 vss.n22 vss.t42 0.0473
R692 vss.n20 vss.n18 4.57882
R693 vss.n1 vss.n18 12.8446
R694 vss.t40 vss.n20 0.0473
R695 vss.n17 vss.t40 0.0473
R696 vss.n15 vss.n13 4.57882
R697 vss.n0 vss.n13 12.8446
R698 vss.t38 vss.n15 0.0473
R699 vss.n12 vss.t38 0.0473
R700 vss.n10 vss.n8 4.57882
R701 vss.n0 vss.n8 16.1926
R702 vss.t36 vss.n10 0.0473
R703 vss.n7 vss.t36 0.0473
R704 vss.n5 vss.t88 0.038593
R705 a_21564_n100.t2 a_21564_n100.n0 0.8195
R706 a_21564_n100.n0 a_21564_n100.t3 0.8195
R707 a_21564_n100.n1 a_21564_n100.n0 7.26555
R708 a_21564_n100.n2 a_21564_n100.n1 7.22955
R709 a_21564_n100 a_21564_n100.n2 0.662
R710 a_21564_n100.n2 a_21564_n100.t0 1.2605
R711 a_21564_n100.n1 a_21564_n100.t1 8.06655
R712 a_20880_0.t0 a_20880_0.n2 9.75178
R713 a_20880_0.n2 a_20880_0.n1 7.36905
R714 a_20880_0.n1 a_20880_0.t3 0.8195
R715 a_20880_0.n1 a_20880_0.t2 0.8195
R716 a_20880_0.n0 a_20880_0.n2 8.17078
R717 a_20880_0 a_20880_0.n0 0.8825
R718 a_20880_0.n0 a_20880_0.t1 1.6805
R719 a_20196_0 a_20196_0.n0 0.8825
R720 a_20196_0.n0 a_20196_0.t0 1.6805
R721 a_20196_0.n0 a_20196_0.n2 8.17078
R722 a_20196_0.n2 a_20196_0.n1 7.36905
R723 a_20196_0.n1 a_20196_0.t1 0.8195
R724 a_20196_0.n1 a_20196_0.t2 0.8195
R725 a_20196_0.n2 a_20196_0.t3 9.75178
R726 a_19512_0.t0 a_19512_0.n0 0.8195
R727 a_19512_0.n0 a_19512_0.t1 0.8195
R728 a_19512_0.n2 a_19512_0.n0 7.36905
R729 a_19512_0.n1 a_19512_0.n2 8.17078
R730 a_19512_0 a_19512_0.n1 0.8825
R731 a_19512_0.n1 a_19512_0.t3 1.6805
R732 a_19512_0.n2 a_19512_0.t2 9.75178
R733 a_18828_0.n0 a_18828_0.t1 0.8195
R734 a_18828_0.n0 a_18828_0.t0 0.8195
R735 a_18828_0.n2 a_18828_0.n0 7.36905
R736 a_18828_0.n1 a_18828_0.n2 8.17078
R737 a_18828_0 a_18828_0.n1 0.8825
R738 a_18828_0.n1 a_18828_0.t3 1.6805
R739 a_18828_0.n2 a_18828_0.t2 9.75178
R740 a_18144_0.t0 a_18144_0.n0 0.8195
R741 a_18144_0.n0 a_18144_0.t2 0.8195
R742 a_18144_0.n2 a_18144_0.n0 7.36905
R743 a_18144_0.n1 a_18144_0.n2 8.17078
R744 a_18144_0 a_18144_0.n1 0.8825
R745 a_18144_0.n1 a_18144_0.t1 1.6805
R746 a_18144_0.n2 a_18144_0.t3 9.75178
R747 nb.n0 nb.t4 0.9105
R748 nb.n0 nb.t5 0.9105
R749 nb.n9 nb.n0 11.3929
R750 nb nb.n9 0.2855
R751 nb.n7 nb.n6 4.5005
R752 nb nb.n7 0.2915
R753 nb.n7 nb.n8 10.2408
R754 nb.n8 nb.t8 58.7685
R755 nb.n8 nb.t9 58.5791
R756 nb.n6 nb.n5 5.29503
R757 nb.n5 nb.t6 58.7685
R758 nb.n5 nb.t7 58.5791
R759 nb.n6 nb.n4 4.87676
R760 nb.n4 nb.t10 58.7685
R761 nb.n4 nb.t11 58.5791
R762 nb.n9 nb.n3 5.3705
R763 nb.n3 nb.n2 7.67955
R764 nb.n2 nb.t2 0.8195
R765 nb.n2 nb.t3 0.8195
R766 nb.n3 nb.n1 6.89289
R767 nb.n1 nb.t1 0.9105
R768 nb.n1 nb.t0 0.9105
R769 r4.n0 r4.t1 0.607167
R770 r4.n0 r4.t0 0.607167
R771 r4.n1 r4.n0 6.55734
R772 r4.n1 r4.n5 8.43066
R773 r4.n5 r4.t3 1.0925
R774 r4.n5 r4.t2 1.0925
R775 r4 r4.n1 5.3705
R776 r4 r4.n4 5.3705
R777 r4.n4 r4.n3 5.05503
R778 r4.n3 r4.t4 39.215
R779 r4.n3 r4.t5 39.0255
R780 r4.n4 r4.n2 5.11676
R781 r4.n2 r4.t6 58.7685
R782 r4.n2 r4.t7 58.5791
R783 r5.t0 r5.n0 0.607167
R784 r5.n0 r5.t1 0.607167
R785 r5.n1 r5.n0 6.31734
R786 r5.n8 r5.n1 4.5005
R787 r5.n1 r5.n9 8.67066
R788 r5.n9 r5.t2 1.0925
R789 r5.n9 r5.t3 1.0925
R790 r5.n8 r5.n7 5.2145
R791 r5.n7 r5.n6 5.29503
R792 r5.n6 r5.t4 45.7328
R793 r5.n6 r5.t5 45.5434
R794 r5.n7 r5.n5 4.87676
R795 r5.n5 r5.t8 45.7328
R796 r5.n5 r5.t9 45.5434
R797 r5 r5.n8 0.2675
R798 r5 r5.n4 5.5115
R799 r5.n4 r5.n3 5.29503
R800 r5.n3 r5.t6 39.215
R801 r5.n3 r5.t7 39.0255
R802 r5.n4 r5.n2 4.87676
R803 r5.n2 r5.t11 58.5791
R804 r5.n2 r5.t10 58.7685
R805 r3.t0 r3.n0 0.607167
R806 r3.n0 r3.t2 0.607167
R807 r3.n1 r3.n0 6.31734
R808 r3.n1 r3.n5 8.67066
R809 r3.n5 r3.t1 1.0925
R810 r3.n5 r3.t3 1.0925
R811 r3 r3.n1 5.3705
R812 r3 r3.n4 5.3705
R813 r3.n4 r3.n3 5.29503
R814 r3.n3 r3.t4 39.215
R815 r3.n3 r3.t5 39.0255
R816 r3.n4 r3.n2 4.87676
R817 r3.n2 r3.t6 58.7685
R818 r3.n2 r3.t7 58.5791
R819 r1.n0 r1.t3 0.607167
R820 r1.n0 r1.t2 0.607167
R821 r1.n1 r1.n0 6.79734
R822 r1.n1 r1.n5 8.19066
R823 r1.n5 r1.t0 1.0925
R824 r1.n5 r1.t1 1.0925
R825 r1 r1.n1 5.6495
R826 r1 r1.n4 5.6555
R827 r1.n4 r1.n3 4.81503
R828 r1.n3 r1.t4 39.215
R829 r1.n3 r1.t5 39.0255
R830 r1.n4 r1.n2 5.35676
R831 r1.n2 r1.t7 58.5791
R832 r1.n2 r1.t6 58.7685
R833 r2.t2 r2.n0 0.607167
R834 r2.n0 r2.t3 0.607167
R835 r2.n1 r2.n0 6.55734
R836 r2.n1 r2.n5 8.43066
R837 r2.n5 r2.t0 1.0925
R838 r2.n5 r2.t1 1.0925
R839 r2 r2.n1 5.1365
R840 r2 r2.n4 5.1425
R841 r2.n4 r2.n3 5.05503
R842 r2.n3 r2.t4 39.215
R843 r2.n3 r2.t5 39.0255
R844 r2.n4 r2.n2 5.11676
R845 r2.n2 r2.t7 58.5791
R846 r2.n2 r2.t6 58.7685
R847 a_20876_1144.t2 a_20876_1144.n1 7.12409
R848 a_20876_1144.n2 a_20876_1144.n1 6.24309
R849 a_20876_1144 a_20876_1144.n2 0.537167
R850 a_20876_1144.n2 a_20876_1144.t1 0.9805
R851 a_20876_1144.n1 a_20876_1144.n0 6.20245
R852 a_20876_1144.n0 a_20876_1144.t3 0.3645
R853 a_20876_1144.n0 a_20876_1144.t0 0.3645
R854 a_20192_1144.t1 a_20192_1144.n1 7.12409
R855 a_20192_1144.n2 a_20192_1144.n1 6.24309
R856 a_20192_1144 a_20192_1144.n2 0.537167
R857 a_20192_1144.n2 a_20192_1144.t0 0.9805
R858 a_20192_1144.n1 a_20192_1144.n0 6.20245
R859 a_20192_1144.n0 a_20192_1144.t2 0.3645
R860 a_20192_1144.n0 a_20192_1144.t3 0.3645
R861 a_19508_1144.t1 a_19508_1144.n1 7.12409
R862 a_19508_1144.n2 a_19508_1144.n1 6.24309
R863 a_19508_1144 a_19508_1144.n2 0.537167
R864 a_19508_1144.n2 a_19508_1144.t0 0.9805
R865 a_19508_1144.n1 a_19508_1144.n0 6.20245
R866 a_19508_1144.n0 a_19508_1144.t3 0.3645
R867 a_19508_1144.n0 a_19508_1144.t2 0.3645
R868 a_18824_1144.t1 a_18824_1144.n1 7.12409
R869 a_18824_1144.n2 a_18824_1144.n1 6.24309
R870 a_18824_1144 a_18824_1144.n2 0.537167
R871 a_18824_1144.n2 a_18824_1144.t0 0.9805
R872 a_18824_1144.n1 a_18824_1144.n0 6.20245
R873 a_18824_1144.n0 a_18824_1144.t3 0.3645
R874 a_18824_1144.n0 a_18824_1144.t2 0.3645
R875 a_18140_1144 a_18140_1144.n0 0.537167
R876 a_18140_1144.n0 a_18140_1144.t2 0.9805
R877 a_18140_1144.n0 a_18140_1144.n2 6.24309
R878 a_18140_1144.n2 a_18140_1144.t3 7.12409
R879 a_18140_1144.n2 a_18140_1144.n1 6.20245
R880 a_18140_1144.n1 a_18140_1144.t0 0.3645
R881 a_18140_1144.n1 a_18140_1144.t1 0.3645
R882 vi.n2 vi.t2 11.9519
R883 vi vi.n0 6.16325
R884 vi.n0 vi.n1 0.77
R885 vi.n1 vi.n2 0.365
R886 vi.n2 vi.t3 13.0544
R887 vi.n1 vi.t1 11.9519
R888 vi.n0 vi.t0 11.9519
R889 vi vi.t4 22.8266
R890 vnt.n5 vnt.t0 11.4119
R891 vnt.n0 vnt.n5 0.77
R892 vnt.n1 vnt.n0 0.77
R893 vnt vnt.n1 5.01125
R894 vnt vnt.n2 2.35175
R895 vnt.n2 vnt.n3 1.49
R896 vnt.n3 vnt.n4 1.9895
R897 vnt.n4 vnt.t1 15.3768
R898 vnt.n4 vnt.t7 13.8873
R899 vnt.n3 vnt.t4 13.8873
R900 vnt.n2 vnt.t6 13.8873
R901 vnt.n1 vnt.t2 11.4119
R902 vnt.n0 vnt.t5 11.4119
R903 vnt.n5 vnt.t3 12.1814
R904 vbn_vco.t1 vbn_vco.n12 11.7674
R905 vbn_vco.n11 vbn_vco.n12 12.9043
R906 vbn_vco vbn_vco.n3 17.2479
R907 vbn_vco vbn_vco.n1 0.683375
R908 vbn_vco.n1 vbn_vco.n11 0.00725
R909 vbn_vco.n3 vbn_vco.n5 0.9965
R910 vbn_vco.n5 vbn_vco.n7 0.9965
R911 vbn_vco.n7 vbn_vco.n9 0.9965
R912 vbn_vco.n9 vbn_vco.n10 10.4541
R913 vbn_vco.n10 vbn_vco.t5 29.8501
R914 vbn_vco.n10 vbn_vco.t6 29.6085
R915 vbn_vco.n9 vbn_vco.n8 9.45808
R916 vbn_vco.n8 vbn_vco.t7 29.8501
R917 vbn_vco.n8 vbn_vco.t8 29.6085
R918 vbn_vco.n7 vbn_vco.n6 9.45808
R919 vbn_vco.n6 vbn_vco.t9 29.8501
R920 vbn_vco.n6 vbn_vco.t10 29.6085
R921 vbn_vco.n5 vbn_vco.n4 9.45808
R922 vbn_vco.n4 vbn_vco.t11 29.8501
R923 vbn_vco.n4 vbn_vco.t12 29.6085
R924 vbn_vco.n3 vbn_vco.n2 9.45808
R925 vbn_vco.n2 vbn_vco.t13 29.8501
R926 vbn_vco.n2 vbn_vco.t14 29.6085
R927 vbn_vco.n11 vbn_vco.t0 20.0615
R928 vbn_vco.n1 vbn_vco.n0 9.95675
R929 vbn_vco.n0 vbn_vco.t3 1.88813
R930 vbn_vco.n0 vbn_vco.t2 44.5424
R931 vbn_vco.n12 vbn_vco.t4 12.4424
R932 vst.t2 vst.n0 12.1814
R933 vst vst.n0 0.88925
R934 vst vst.n2 0.0725
R935 vst.n2 vst.n1 1.148
R936 vst.n2 vst.t0 36.7845
R937 vst.n1 vst.t1 19.8995
R938 vst.n1 vst.t4 13.747
R939 vst.n0 vst.t3 11.4119
R940 vbh.t5 vbh.n5 11.5919
R941 vbh vbh.n5 2.03338
R942 vbh vbh.n4 16.6089
R943 vbh.n4 vbh.n1 0.0275
R944 vbh.n1 vbh.n2 1.013
R945 vbh.n2 vbh.n3 11.3292
R946 vbh.n3 vbh.t3 1.83599
R947 vbh.n3 vbh.t2 12.2744
R948 vbh.n2 vbh.t6 22.039
R949 vbh.n1 vbh.t7 22.039
R950 vbh.n4 vbh.n0 11.1447
R951 vbh.n0 vbh.t1 1.83599
R952 vbh.n0 vbh.t0 12.2744
R953 vbh.n5 vbh.t4 13.9004
R954 vbl.t4 vbl.n7 11.5874
R955 vbl.n0 vbl.n7 1.283
R956 vbl.n1 vbl.n0 1.24475
R957 vbl.n6 vbl.n1 11.9075
R958 vbl.n3 vbl.n6 0.059
R959 vbl vbl.n3 0.5765
R960 vbl vbl.n4 0.419
R961 vbl.n4 vbl.n5 12.452
R962 vbl.n5 vbl.t3 3.47655
R963 vbl.n5 vbl.t2 8.58548
R964 vbl.n4 vbl.t8 19.4863
R965 vbl.n3 vbl.t9 19.4863
R966 vbl.n6 vbl.n2 12.236
R967 vbl.n2 vbl.t1 3.47655
R968 vbl.n2 vbl.t0 8.58548
R969 vbl.n1 vbl.t7 12.7057
R970 vbl.n0 vbl.t6 11.5874
R971 vbl.n7 vbl.t5 13.9499
R972 vbp_vco.t1 vbp_vco.n0 13.5944
R973 vbp_vco vbp_vco.n16 17.1511
R974 vbp_vco vbp_vco.n1 0.055625
R975 vbp_vco.n1 vbp_vco.n0 1.66775
R976 vbp_vco.n16 vbp_vco.n10 0.7955
R977 vbp_vco.n10 vbp_vco.n12 0.9965
R978 vbp_vco.n12 vbp_vco.n14 0.9965
R979 vbp_vco.n14 vbp_vco.n15 10.4558
R980 vbp_vco.n15 vbp_vco.t7 51.8961
R981 vbp_vco.n15 vbp_vco.t8 51.6545
R982 vbp_vco.n14 vbp_vco.n13 9.45982
R983 vbp_vco.n13 vbp_vco.t9 51.8961
R984 vbp_vco.n13 vbp_vco.t10 51.6545
R985 vbp_vco.n12 vbp_vco.n11 9.45982
R986 vbp_vco.n11 vbp_vco.t11 51.8961
R987 vbp_vco.n11 vbp_vco.t12 51.6545
R988 vbp_vco.n10 vbp_vco.n9 9.45982
R989 vbp_vco.n9 vbp_vco.t13 51.8961
R990 vbp_vco.n9 vbp_vco.t14 51.6545
R991 vbp_vco.n16 vbp_vco.n8 9.61057
R992 vbp_vco.n8 vbp_vco.t15 51.8961
R993 vbp_vco.n8 vbp_vco.t16 51.6545
R994 vbp_vco.n1 vbp_vco.n7 11.5475
R995 vbp_vco.n4 vbp_vco.n3 0.6755
R996 vbp_vco.n6 vbp_vco.n4 1.00175
R997 vbp_vco.n7 vbp_vco.n6 0.00725
R998 vbp_vco.n7 vbp_vco.t2 19.6132
R999 vbp_vco.n6 vbp_vco.n5 9.94325
R1000 vbp_vco.n5 vbp_vco.t6 1.6447
R1001 vbp_vco.n5 vbp_vco.t5 51.9932
R1002 vbp_vco.n4 vbp_vco.t17 61.7152
R1003 vbp_vco.n3 vbp_vco.t18 61.7152
R1004 vbp_vco.n3 vbp_vco.n2 10.787
R1005 vbp_vco.n2 vbp_vco.t4 1.6447
R1006 vbp_vco.n2 vbp_vco.t3 51.9932
R1007 vbp_vco.n0 vbp_vco.t0 12.4919
R1008 vs.n0 vs.t1 11.4119
R1009 vs.n0 vs.t0 67.3435
R1010 vs vs.n0 0.352625
R1011 vs vs.t2 11.8293
R1012 vcl.t0 vcl.n1 12.7221
R1013 vcl.n2 vcl.n0 0.00275
R1014 vcl.n2 vcl.n1 0.99275
R1015 vcl vcl.n2 18.275
R1016 vcl vcl.t4 30.385
R1017 vcl.n1 vcl.t1 11.7276
R1018 vcl.n0 vcl.t2 11.7276
R1019 vcl.n0 vcl.t3 13.2171
R1020 up_b.t1 up_b.n0 14.3606
R1021 up_b up_b.n0 3.15838
R1022 up_b.n0 up_b.t0 46.0827
R1023 up_b up_b.t2 58.2143
R1024 en_b.t1 en_b.n0 17.4656
R1025 en_b.n5 en_b.n0 6.1385
R1026 en_b.n4 en_b.n5 7.7675
R1027 en_b.n2 en_b.n4 0.563
R1028 en_b.n3 en_b.n2 0.608
R1029 en_b en_b.n3 0.27275
R1030 en_b en_b.t2 45.6133
R1031 en_b.n3 en_b.t3 44.126
R1032 en_b.n2 en_b.t4 44.126
R1033 en_b.n4 en_b.t5 44.1711
R1034 en_b.n5 en_b.n1 25.655
R1035 en_b.n1 en_b.t0 20.7657
R1036 en_b.n1 en_b.t7 44.9698
R1037 en_b.n0 en_b.t6 13.6789
R1038 t1c t1c.t0 16.6346
R1039 t1c t1c.t1 16.6346
R1040 vdump.t9 vdump.n0 1.68292
R1041 vdump.n0 vdump.t8 30.1453
R1042 vdump.n15 vdump.n0 10.2695
R1043 vdump vdump.n15 1.73975
R1044 vdump vdump.n2 1.51475
R1045 vdump.n2 vdump.n3 0.47075
R1046 vdump.n14 vdump.n13 4.5005
R1047 vdump.n3 vdump.n14 7.9475
R1048 vdump.n8 vdump.n6 2.858
R1049 vdump.n10 vdump.n8 0.788
R1050 vdump.n13 vdump.n10 0.02975
R1051 vdump.n13 vdump.n11 3.27875
R1052 vdump.n11 vdump.n12 1.013
R1053 vdump.n12 vdump.t17 22.1535
R1054 vdump.n12 vdump.t3 12.366
R1055 vdump.n11 vdump.t2 12.366
R1056 vdump.n10 vdump.n9 10.3032
R1057 vdump.n9 vdump.t15 1.6447
R1058 vdump.n9 vdump.t14 30.2254
R1059 vdump.n8 vdump.n7 10.3032
R1060 vdump.n7 vdump.t11 1.6447
R1061 vdump.n7 vdump.t10 30.2254
R1062 vdump.n6 vdump.n5 10.3032
R1063 vdump.n5 vdump.t13 1.6447
R1064 vdump.n5 vdump.t12 30.2254
R1065 vdump.n6 vdump.n4 11.0908
R1066 vdump.n4 vdump.t5 1.6447
R1067 vdump.n4 vdump.t4 30.2254
R1068 vdump.n14 vdump.t16 36.8193
R1069 vdump.n3 vdump.t1 14.9516
R1070 vdump.n2 vdump.t0 14.4273
R1071 vdump.n15 vdump.n1 11.039
R1072 vdump.n1 vdump.t7 1.68292
R1073 vdump.n1 vdump.t6 30.1453
R1074 dn_b.t1 dn_b 14.139
R1075 dn_b dn_b.n0 24.9834
R1076 dn_b.n0 dn_b.t0 21.0245
R1077 dn_b.n0 dn_b.t2 45.5055
R1078 dn_s.n1 dn_s.t0 15.3723
R1079 dn_s dn_s.n0 1.0085
R1080 dn_s dn_s.n1 1.346
R1081 dn_s.n1 dn_s.t3 16.5243
R1082 dn_s.n0 dn_s.t1 11.7276
R1083 dn_s.n0 dn_s.t2 13.2171
R1084 vref.n12 vref.t1 12.5644
R1085 vref.n1 vref.n0 1.49
R1086 vref.n2 vref.n1 0.995
R1087 vref.n3 vref.n2 0.995
R1088 vref vref.n3 1.45963
R1089 vref vref.n4 0.030875
R1090 vref.n4 vref.n7 0.041
R1091 vref.n7 vref.n12 0.15575
R1092 vref.n12 vref.n5 1.34375
R1093 vref.n5 vref.n6 0.77
R1094 vref.n7 vref.n11 19.13
R1095 vref.n11 vref.n10 8.56625
R1096 vref.n11 vref.t0 35.3913
R1097 vref.n10 vref.n8 1.067
R1098 vref.n8 vref.n9 0.995
R1099 vref.n9 vref.t11 34.4058
R1100 vref.n9 vref.t12 33.4113
R1101 vref.n8 vref.t13 33.4113
R1102 vref.n10 vref.t14 33.8343
R1103 vref.n6 vref.t2 23.774
R1104 vref.n6 vref.t3 40.3782
R1105 vref.n5 vref.t4 40.3782
R1106 vref.n4 vref.t5 19.4863
R1107 vref.n3 vref.t6 19.4863
R1108 vref.n2 vref.t7 19.4863
R1109 vref.n1 vref.t8 19.4863
R1110 vref.n0 vref.t9 19.4863
R1111 vref.n0 vref.t10 20.4808
R1112 t1b t1b.t1 19.0432
R1113 t1b t1b.t0 37.5581
R1114 va.t1 va.n1 56.25
R1115 va.n0 va.n1 0.0095
R1116 va va.n0 0.55175
R1117 va va.t2 23.6143
R1118 va.n0 va.t3 36.4132
R1119 va.n1 va.t0 17.4806
R1120 t1a t1a.t1 16.6807
R1121 t1a t1a.t0 36.7481
R1122 t2 t2.t1 16.3769
R1123 t2 t2.n0 17.5921
R1124 t2.n0 t2.t0 23.0242
R1125 t2.n0 t2.t2 17.1202
R1126 vcp_n.t4 vcp_n.n0 1.64987
R1127 vcp_n.n0 vcp_n.t3 23.1665
R1128 vcp_n.n13 vcp_n.n0 9.71825
R1129 vcp_n.n3 vcp_n.n2 0.995
R1130 vcp_n.n4 vcp_n.n3 1.49
R1131 vcp_n.n5 vcp_n.n4 0.995
R1132 vcp_n.n13 vcp_n.n5 0.82625
R1133 vcp_n vcp_n.n13 0.545
R1134 vcp_n vcp_n.n6 1.8725
R1135 vcp_n.n6 vcp_n.n9 0.03425
R1136 vcp_n.n9 vcp_n.n7 0.57425
R1137 vcp_n.n7 vcp_n.n8 1.2155
R1138 vcp_n.n9 vcp_n.n12 17.8475
R1139 vcp_n.n12 vcp_n.n10 0.17375
R1140 vcp_n.n10 vcp_n.n11 8.078
R1141 vcp_n.n11 vcp_n.t8 19.386
R1142 vcp_n.n11 vcp_n.t0 16.866
R1143 vcp_n.n10 vcp_n.t5 16.866
R1144 vcp_n.n12 vcp_n.t10 19.2127
R1145 vcp_n.n8 vcp_n.t11 22.9033
R1146 vcp_n.n8 vcp_n.t7 15.0123
R1147 vcp_n.n7 vcp_n.t6 15.0123
R1148 vcp_n.n6 vcp_n.t9 15.0123
R1149 vcp_n.n5 vcp_n.t12 32.6913
R1150 vcp_n.n4 vcp_n.t13 32.6913
R1151 vcp_n.n3 vcp_n.t14 32.6913
R1152 vcp_n.n2 vcp_n.t15 32.6913
R1153 vcp_n.n2 vcp_n.n1 10.8815
R1154 vcp_n.n1 vcp_n.t2 1.64987
R1155 vcp_n.n1 vcp_n.t1 23.1665
R1156 vbt.n9 vbt.t6 11.4074
R1157 vbt.n1 vbt.n0 0.788
R1158 vbt.n2 vbt.n1 0.788
R1159 vbt vbt.n2 0.64175
R1160 vbt vbt.n3 0.64175
R1161 vbt.n3 vbt.n4 0.788
R1162 vbt.n4 vbt.n5 0.69125
R1163 vbt.n5 vbt.n9 0.09725
R1164 vbt.n5 vbt.n6 32.6165
R1165 vbt.n6 vbt.n7 2.5205
R1166 vbt.n7 vbt.n8 10.598
R1167 vbt.n8 vbt.t1 18.351
R1168 vbt.n8 vbt.t0 16.326
R1169 vbt.n7 vbt.t11 16.326
R1170 vbt.n6 vbt.t2 16.326
R1171 vbt.n9 vbt.t10 12.1949
R1172 vbt.n4 vbt.t5 11.4074
R1173 vbt.n3 vbt.t9 11.4074
R1174 vbt.n2 vbt.t8 11.4074
R1175 vbt.n1 vbt.t4 11.4074
R1176 vbt.n0 vbt.t3 11.4074
R1177 vbt.n0 vbt.t7 12.1949
R1178 vbp.t1 vbp.n15 12.7444
R1179 vbp.n15 vbp.n0 9.22775
R1180 vbp vbp.n15 1.00962
R1181 vbp.n0 vbp.n14 27.6957
R1182 vbp.n2 vbp.n1 1.508
R1183 vbp.n3 vbp.n2 1.013
R1184 vbp.n4 vbp.n3 1.013
R1185 vbp.n5 vbp.n4 1.508
R1186 vbp.n7 vbp.n5 0.84425
R1187 vbp.n8 vbp.n7 1.18175
R1188 vbp.n14 vbp.n8 0.5135
R1189 vbp.n14 vbp.n9 0.995
R1190 vbp.n9 vbp.n10 1.013
R1191 vbp.n10 vbp.n11 1.013
R1192 vbp.n11 vbp.n12 1.508
R1193 vbp.n12 vbp.n13 1.013
R1194 vbp.n13 vbp.t5 27.9115
R1195 vbp.n13 vbp.t6 26.899
R1196 vbp.n12 vbp.t7 26.899
R1197 vbp.n11 vbp.t8 26.899
R1198 vbp.n10 vbp.t9 26.899
R1199 vbp.n9 vbp.t10 26.899
R1200 vbp.n8 vbp.t11 26.899
R1201 vbp.n7 vbp.n6 14.8505
R1202 vbp.n6 vbp.t3 1.83599
R1203 vbp.n6 vbp.t2 12.2744
R1204 vbp.n5 vbp.t12 26.899
R1205 vbp.n4 vbp.t13 26.899
R1206 vbp.n3 vbp.t14 26.899
R1207 vbp.n2 vbp.t15 26.899
R1208 vbp.n1 vbp.t16 26.899
R1209 vbp.n1 vbp.t17 27.9115
R1210 vbp.n0 vbp.t4 24.0548
R1211 vbp vbp.t0 25.4064
R1212 up_s.t0 up_s.n0 14.0207
R1213 up_s.n1 up_s.n0 47.615
R1214 up_s up_s.n1 0.29975
R1215 up_s up_s.t1 13.4235
R1216 up_s.n1 up_s.t2 13.1242
R1217 up_s.n0 up_s.t3 13.0082
R1218 vcp_p.t3 vcp_p.n0 3.11042
R1219 vcp_p.n0 vcp_p.t2 50.5496
R1220 vcp_p.n3 vcp_p.n0 11.057
R1221 vcp_p.n4 vcp_p.n2 0.9635
R1222 vcp_p.n4 vcp_p.n3 0.05
R1223 vcp_p.n6 vcp_p.n5 4.5005
R1224 vcp_p.n6 vcp_p.n4 12.6275
R1225 vcp_p vcp_p.n6 24.4861
R1226 vcp_p vcp_p.t6 24.8119
R1227 vcp_p.n5 vcp_p.t5 13.8629
R1228 vcp_p.n5 vcp_p.t4 12.7109
R1229 vcp_p.n3 vcp_p.t7 60.139
R1230 vcp_p.n2 vcp_p.t8 60.139
R1231 vcp_p.n2 vcp_p.n1 10.8995
R1232 vcp_p.n1 vcp_p.t1 3.11042
R1233 vcp_p.n1 vcp_p.t0 50.5496
C0 a_19512_0 r1 0.01603f
C1 vcp_p up_b 0.08716f
C2 t1b dn_b 0.03197f
C3 t1c vbp 0
C4 vref dn_s 0.01204f
C5 vdump en_b 1.03093f
C6 t1c bias_ref 0.00215f
C7 t2 vcl 0.00114f
C8 pfd_dn a_10200_10658 0
C9 vdump vnt 0.94926f
C10 vcp_n cp_trim1 1.05619f
C11 vbp vctrl 0.43056f
C12 vbp pfd_up 0.0647f
C13 vref vst 0.67534f
C14 a_4200_10658 a_2000_10658 0.00234f
C15 bias_ref vctrl 0.11158f
C16 bias_ref pfd_up 0.00295f
C17 vdd vcl 0.04377f
C18 vref t1a 0.00602f
C19 vcp_p va 0
C20 t1b vcp_n 0.1734f
C21 vfilt up_s 0.06736f
C22 r2 r1 0.40043f
C23 vref pll_en 0.39181f
C24 up_b vbp 0.10331f
C25 dn_s dn_b 0.04766f
C26 vco_out a_21564_n100 0.0037f
C27 vfilt vs 0.71378f
C28 bias_ref up_b 0.00175f
C29 vdump vdd 3.08533f
C30 vctrl a_7800_16790 0
C31 up_s cp_trim0 0.06681f
C32 vbl a_6000_10658 0
C33 cp_trim0 vs 0.00101f
C34 a_7200_10658 a_6000_10658 0.00585f
C35 r1 vbn_vco 0.10187f
C36 vbp_vco vbp 0
C37 vco_out a_20880_0 0
C38 up_s vbt 2.54586f
C39 va vbp 1.96492f
C40 t1a dn_b 0.96541f
C41 vcp_n dn_s 1.36315f
C42 va bias_ref 0
C43 dn_b pll_en 0.0102f
C44 vco_out a_20876_1144 0
C45 vcp_p a_2000_10658 0.02136f
C46 vbt vs 0.0788f
C47 r1 r5 0.35907f
C48 vdd en_b 3.71478f
C49 t1a vcp_n 1.07252f
C50 up_s pfd_dn 0.08862f
C51 nb r1 0
C52 vdd vnt 0.0871f
C53 vcp_n pll_en 0.00414f
C54 r4 a_19508_1144 0.25082f
C55 pfd_dn vs 0.09896f
C56 t2 vdd 2.60432f
C57 vcp_p vbh 0.00561f
C58 vbt a_6000_10658 0
C59 vcp_p vi 0
C60 r1 pll_en 0.00709f
C61 t1c pfd_up 0
C62 r4 a_18824_1144 0.00202f
C63 a_18824_1144 a_19508_1144 0.08564f
C64 vdump vbl 2.09627f
C65 vctrl pfd_up 0.04727f
C66 vdump a_7200_10658 0
C67 vbp vi 0.0906f
C68 vfilt vcl 0.09853f
C69 bias_ref vbh 0.15726f
C70 bias_ref vi 0.05055f
C71 up_b vctrl 1.59596f
C72 up_s cp_trim1 0.07199f
C73 r4 a_18828_0 0.00191f
C74 up_b pfd_up 3.52859f
C75 r4 a_21564_n100 0.0018f
C76 r4 vbp_vco 0.03255f
C77 vref vcp_p 0.00453f
C78 vdump vfilt 0.1481f
C79 t1b up_s 0.08686f
C80 cp_trim1 vs 0.00101f
C81 cp_trim0 vcl 0.63963f
C82 a_19508_1144 vbp_vco 0.38347f
C83 up_s vbn_vco 0
C84 t1b vs 0
C85 vdump cp_trim0 0
C86 vbp_vco vctrl 0.05707f
C87 vbp_vco pfd_up 0.02518f
C88 r4 a_20880_0 0.07334f
C89 vbn_vco vs 0.21976f
C90 va vctrl 1.51824f
C91 va pfd_up 0.06231f
C92 vbt vcl 0.18891f
C93 a_18824_1144 a_18828_0 0.0053f
C94 r4 a_20876_1144 0.09637f
C95 vbl vnt 0.17196f
C96 a_18824_1144 vbp_vco 0.38813f
C97 vbp_vco up_b 0.00308f
C98 vdump vbt 2.89209f
C99 vref vbp 2.21172f
C100 up_s dn_s 0
C101 va up_b 0.05244f
C102 vcp_p dn_b 0.05729f
C103 vref bias_ref 0.13459f
C104 dn_s vs 0
C105 r4 r3 0.27551f
C106 r4 a_20192_1144 0.00302f
C107 vdd vbl 1.0394f
C108 pfd_dn vcl 0.03078f
C109 en_b cp_trim0 0.31865f
C110 a_19508_1144 r3 0.10179f
C111 a_19508_1144 a_20192_1144 0.08564f
C112 up_s vst 0.04114f
C113 va vbp_vco 0.10155f
C114 vctrl a_2000_10658 0
C115 vfilt t2 0.06928f
C116 vcp_p vcp_n 1.87181f
C117 up_s t1a 0.08486f
C118 vdump pfd_dn 0.24647f
C119 up_s pll_en 0.14569f
C120 dn_b vbp 0.00407f
C121 t1a vs 0
C122 bias_ref dn_b 0.00244f
C123 pll_en vs 0.63821f
C124 vfilt vdd 0.64136f
C125 a_20880_0 a_21564_n100 0.0416f
C126 a_18144_0 a_18828_0 0.05369f
C127 a_18824_1144 r3 0.01879f
C128 t2 cp_trim0 0.46407f
C129 vcp_p a_11400_10658 0
C130 vbp_vco a_20876_1144 0.28051f
C131 vbt vnt 0.00163f
C132 vcp_p a_8400_10658 0.00353f
C133 vdd cp_trim0 0.06566f
C134 en_b a_18140_1144 0
C135 vbp a_12000_18110 0.00764f
C136 vcp_p a_1200_18290 0.00697f
C137 vbp a_13200_18110 0.00418f
C138 vcp_n vbp 7.47115f
C139 t2 vbt 0.12594f
C140 vctrl vbh 2.67039f
C141 en_b pfd_dn 0.90128f
C142 vcp_n bias_ref 0
C143 vbh pfd_up 0.00826f
C144 vctrl vi 3.66219f
C145 pfd_up vi 0
C146 a_20876_1144 a_20880_0 0.0053f
C147 a_18828_0 r3 0.00275f
C148 cp_trim1 vcl 0.00301f
C149 vdd vbt 9.68036f
C150 vbp_vco r3 0.06543f
C151 vbp_vco a_20192_1144 0.37969f
C152 vcp_p a_10200_10658 0.00353f
C153 up_b vbh 0.01113f
C154 t1b vcl 0
C155 up_b vi 0
C156 pfd_dn vnt 0
C157 vbp a_11400_10658 0.00244f
C158 vbp a_12600_10658 0.01436f
C159 vcp_p a_400_10658 0.00113f
C160 t2 pfd_dn 0.2255f
C161 vdd a_20196_0 0.00326f
C162 bias_ref a_8400_10658 0.0018f
C163 bias_ref a_10800_18110 0.00953f
C164 t1c vref 0.01204f
C165 vctrl a_15000_10658 0
C166 a_13800_10658 pfd_up 0.00557f
C167 vdd a_18140_1144 0.60244f
C168 a_18144_0 r3 0.11466f
C169 vctrl a_13800_10658 0
C170 pfd_up a_15000_10658 0.00557f
C171 a_20192_1144 a_20876_1144 0.08564f
C172 vdump vbn_vco 0
C173 vdd pfd_dn 0.66474f
C174 vbp_vco vi 0.96748f
C175 va vi 0.05837f
C176 up_b a_13800_10658 0
C177 up_b a_15000_10658 0
C178 va a_14400_18110 0.00764f
C179 vref vctrl 0.67454f
C180 vref pfd_up 0.11219f
C181 dn_s vcl 0
C182 vdd a_19512_0 0.00326f
C183 bias_ref a_10200_10658 0.01361f
C184 en_b cp_trim1 0
C185 a_20192_1144 r3 0
C186 vref up_b 0.10003f
C187 vdump dn_s 0.75951f
C188 t1b en_b 0
C189 t1c dn_b 0.06526f
C190 va a_13800_10658 0.01425f
C191 en_b vbn_vco 0.53869f
C192 va a_15000_10658 0.004f
C193 t1a vcl 0
C194 pll_en vcl 0.20715f
C195 vdd r2 0.38363f
C196 t2 cp_trim1 0.2775f
C197 vdump vst 0.09201f
C198 dn_b vctrl 0.06244f
C199 dn_b pfd_up 0.14217f
C200 a_6000_10658 a_4200_10658 0.00234f
C201 vref vbp_vco 0.06742f
C202 vcp_p up_s 2.4573f
C203 vref va 1.93199f
C204 t1c vcp_n 0.41366f
C205 t1b t2 0.19143f
C206 vdump t1a 0.04835f
C207 vdump pll_en 0.0748f
C208 vdd cp_trim1 0.20013f
C209 up_b dn_b 0.42265f
C210 vbl vbt 2.07556f
C211 vcp_p vs 0.01841f
C212 t1b vdd 1.71242f
C213 vfilt cp_trim0 0.01233f
C214 vdd vbn_vco 1.52332f
C215 vcp_n vctrl 0.34295f
C216 r4 r1 0.25847f
C217 vcp_n pfd_up 0.06644f
C218 a_19508_1144 r1 0.00429f
C219 en_b vst 1.0325f
C220 vbh vi 0.09626f
C221 up_b a_12000_18110 0
C222 up_s vbp 3.11845f
C223 vfilt vbt 0.28746f
C224 va dn_b 0
C225 vcp_n up_b 0.31252f
C226 en_b pll_en 2.1641f
C227 vdd r5 0.84038f
C228 vctrl a_11400_10658 0
C229 vctrl a_12600_10658 0
C230 a_11400_10658 pfd_up 0.01173f
C231 pfd_up a_12600_10658 0.00557f
C232 vbp vs 0.05935f
C233 vcp_p a_6000_10658 0.00353f
C234 bias_ref vs 0.13938f
C235 vdd dn_s 0.02751f
C236 vst vnt 0.00255f
C237 vctrl a_8400_10658 0
C238 pfd_up a_10800_18110 0.01304f
C239 vbt cp_trim0 0
C240 a_18824_1144 r1 0.09681f
C241 vctrl a_1200_18290 0.01597f
C242 vdd nb 1.32772f
C243 vnt pll_en 0
C244 up_b a_11400_10658 0.0096f
C245 up_b a_12600_10658 0
C246 va a_13200_18110 0.00323f
C247 up_b a_10800_18110 0.00344f
C248 va vcp_n 0.11948f
C249 t1a t2 0.36991f
C250 vfilt pfd_dn 0.08905f
C251 vdd vst 0.6805f
C252 vctrl a_10200_10658 0
C253 pfd_up a_10200_10658 0
C254 t1a vdd 1.37505f
C255 vdd pll_en 5.11338f
C256 vctrl a_400_10658 0.00176f
C257 r1 a_21564_n100 0
C258 a_18828_0 r1 0.0845f
C259 vref vi 2.95099f
C260 vref vbh 0.1463f
C261 pfd_dn cp_trim0 0.73576f
C262 vbp_vco r1 0.02988f
C263 vdump a_4200_10658 0
C264 a_13800_10658 a_15000_10658 0.00585f
C265 vbt pfd_dn 0.0023f
C266 a_18144_0 r1 0
C267 r1 a_20880_0 0.00191f
C268 a_20876_1144 r1 0.00202f
C269 vref a_13800_10658 0.00511f
C270 dn_b vbh 0.00796f
C271 vcp_p vcl 0.00659f
C272 dn_b vi 0
C273 vfilt cp_trim1 0.00597f
C274 vdump vcp_p 1.9844f
C275 t1b vfilt 0.02246f
C276 a_19512_0 a_20196_0 0.05369f
C277 a_20192_1144 r1 0.24409f
C278 r1 r3 0.20322f
C279 cp_trim0 cp_trim1 0.79081f
C280 t1c vs 0
C281 a_14400_18110 a_13200_18110 0.00585f
C282 t1b cp_trim0 0.05587f
C283 up_s vctrl 0.40821f
C284 up_s pfd_up 0.30919f
C285 vbp vcl 0.10943f
C286 bias_ref vcl 0.00215f
C287 vbt cp_trim1 0.00826f
C288 vctrl vs 0.58452f
C289 pfd_up vs 0.1003f
C290 a_400_10658 a_2000_10658 0.00585f
C291 vdump vbp 0.11635f
C292 vref dn_b 0.0617f
C293 vfilt dn_s 0.14028f
C294 r2 a_18140_1144 0.10479f
C295 t1b vbt 0.08686f
C296 up_s up_b 0.24478f
C297 vdump bias_ref 0.06049f
C298 up_b vs 0.037f
C299 vcp_p vnt 0
C300 a_19512_0 r2 0.00191f
C301 pfd_dn cp_trim1 0.24514f
C302 vref a_13200_18110 0.01727f
C303 vref a_12000_18110 0.00106f
C304 up_s vbp_vco 0.0011f
C305 a_20196_0 vbn_vco 0.28019f
C306 vfilt t1a 0.03168f
C307 vref vcp_n 0.02372f
C308 up_s va 0.08757f
C309 t1b pfd_dn 0.03281f
C310 vbn_vco a_18140_1144 0.04706f
C311 a_13800_10658 a_12600_10658 0.00585f
C312 vctrl a_6000_10658 0.01456f
C313 vbp_vco vs 0.61127f
C314 dn_s vbt 0.08611f
C315 en_b vbp 0.19711f
C316 va vs 0.05927f
C317 pfd_dn vbn_vco 0.05603f
C318 vcp_p vdd 10.4695f
C319 t1a cp_trim0 0.14684f
C320 a_20196_0 r5 0.07329f
C321 cp_trim0 pll_en 0.2501f
C322 vref a_12600_10658 0.00454f
C323 a_19512_0 vbn_vco 0.28224f
C324 vco_out vdd 0.60116f
C325 vbp vnt 0.0027f
C326 vref a_10800_18110 0.00106f
C327 bias_ref vnt 0.10244f
C328 vcp_n dn_b 0.19577f
C329 t2 vbp 2.72289f
C330 t1a vbt 0.08486f
C331 dn_s pfd_dn 0.16656f
C332 a_19512_0 r5 0
C333 vdd vbp 26.9639f
C334 bias_ref vdd 0.19297f
C335 t1c vcl 0
C336 r2 vbn_vco 0.13825f
C337 a_12000_18110 a_13200_18110 0.00585f
C338 dn_b a_11400_10658 0
C339 vbl a_4200_10658 0
C340 pfd_dn vst 0.10061f
C341 t1b cp_trim1 1.52676f
C342 dn_b a_10800_18110 0.01243f
C343 t1a pfd_dn 0.05385f
C344 pfd_dn pll_en 0.09345f
C345 vctrl vcl 0.10093f
C346 pfd_up vcl 0.03006f
C347 up_s vi 0
C348 a_12000_18110 a_10800_18110 0.00585f
C349 vdump vctrl 5.69684f
C350 vdump pfd_up 0.40291f
C351 dn_b a_10200_10658 0.0025f
C352 up_b vcl 0.02975f
C353 vi vs 0.47784f
C354 vcp_n a_1200_18290 0.00174f
C355 a_14400_18110 vs 0.00168f
C356 vbn_vco r5 0.02169f
C357 vdump up_b 0.05754f
C358 vcp_p vbl 0.00934f
C359 a_11400_10658 a_12600_10658 0.00585f
C360 up_s a_15000_10658 0.00107f
C361 vcp_p a_7200_10658 0.00353f
C362 va vcl 0.79499f
C363 vbt a_4200_10658 0.00785f
C364 t1a cp_trim1 0.13592f
C365 en_b vctrl 0.31338f
C366 en_b pfd_up 0.12051f
C367 cp_trim1 pll_en 0
C368 vdump vbp_vco 0.00761f
C369 vcp_p vfilt 0.07239f
C370 t1b t1a 0.09526f
C371 t1c t2 0.10629f
C372 vref up_s 0.04778f
C373 vdump va 0.05193f
C374 vst vbn_vco 0.0292f
C375 a_18824_1144 en_b 0
C376 t1b pll_en 0
C377 a_11400_10658 a_10200_10658 0.00585f
C378 up_b en_b 0.12068f
C379 nb r5 0.29278f
C380 vref vs 0.14233f
C381 vctrl vnt 0.71424f
C382 vnt pfd_up 0
C383 vbn_vco pll_en 0.13229f
C384 a_8400_10658 a_10200_10658 0.00234f
C385 vdd r4 0.39172f
C386 t1c vdd 0.02974f
C387 vdd a_19508_1144 0.54024f
C388 t2 pfd_up 0.00175f
C389 up_b vnt 0
C390 pll_en r5 0.18174f
C391 vdd vctrl 3.34956f
C392 vdd pfd_up 1.13584f
C393 vbp_vco en_b 0.65273f
C394 vfilt vbp 0.21533f
C395 va en_b 0.58166f
C396 vcp_p vbt 0.33363f
C397 vdump a_2000_10658 0.00395f
C398 vdd a_18824_1144 0.54021f
C399 dn_b vs 0.04385f
C400 nb pll_en 0.4914f
C401 vdd up_b 3.52599f
C402 vbp cp_trim0 0.06665f
C403 va vnt 0.49737f
C404 bias_ref cp_trim0 0
C405 vst pll_en 0.09186f
C406 up_s vcp_n 0.26351f
C407 va t2 0.6614f
C408 vcp_p pfd_dn 0.32379f
C409 a_12000_18110 vs 0.00168f
C410 vdd a_21564_n100 0.01068f
C411 vdd a_18828_0 0.00326f
C412 a_13200_18110 vs 0.00168f
C413 vbp vbt 5.28987f
C414 vcp_n vs 0.01665f
C415 a_14400_18110 vcl 0.00137f
C416 vdd vbp_vco 7.0561f
C417 va vdd 2.03881f
C418 vdump vbh 0.97499f
C419 vdump vi 0
C420 vdd a_20880_0 0.00326f
C421 vdd a_18144_0 0.00326f
C422 vbp pfd_dn 0.1009f
C423 vdd a_20876_1144 0.6635f
C424 a_10800_18110 vs 0.00168f
C425 bias_ref pfd_dn 0.00199f
C426 vdump a_13800_10658 0
C427 vdump a_15000_10658 0
C428 en_b vi 0.39942f
C429 vref vcl 4.10761f
C430 vbl vctrl 2.93597f
C431 vdd r3 0.42478f
C432 vdd a_20192_1144 0.54226f
C433 vdump vref 0.10618f
C434 a_7200_10658 vctrl 0.00329f
C435 vnt vi 0.03911f
C436 vbh vnt 1.98329f
C437 en_b a_13800_10658 0
C438 en_b a_15000_10658 0
C439 t1c cp_trim0 1.07447f
C440 vfilt vctrl 5.96211f
C441 dn_b vcl 0.03675f
C442 vdd vbh 4.90163f
C443 vdd vi 0.14496f
C444 vbp cp_trim1 0.14868f
C445 bias_ref cp_trim1 0
C446 vref en_b 1.0862f
C447 t1b vbp 1.92188f
C448 vcp_p dn_s 0.68209f
C449 vdump dn_b 0.57805f
C450 cp_trim0 pfd_up 0.10106f
C451 vco_out r5 0
C452 vbp vbn_vco 0
C453 a_13200_18110 vcl 0.00132f
C454 a_12000_18110 vcl 0.00132f
C455 a_6600_16790 a_7800_16790 0.00585f
C456 vcp_n vcl 0.04253f
C457 up_b cp_trim0 0.04536f
C458 r4 a_20196_0 0.00733f
C459 vref vnt 1.62789f
C460 vbt vctrl 1.11807f
C461 vco_out nb 0.59878f
C462 vfilt va 0.06118f
C463 vref t2 0.00612f
C464 vdump vcp_n 0.64496f
C465 t1c pfd_dn 0.08129f
C466 vcp_p pll_en 0.33323f
C467 en_b dn_b 0
C468 dn_s vbp 0.00596f
C469 up_s vs 0.07346f
C470 vref vdd 0.70097f
C471 a_10800_18110 vcl 0.00132f
C472 r4 a_19512_0 0.1149f
C473 vco_out pll_en 0.28455f
C474 vbl a_2000_10658 0
C475 va cp_trim0 0.05193f
C476 a_19508_1144 a_19512_0 0.0053f
C477 vdump a_11400_10658 0
C478 vdump a_12600_10658 0
C479 vctrl pfd_dn 0.69821f
C480 pfd_dn pfd_up 5.5399f
C481 a_18824_1144 a_18140_1144 0.08564f
C482 dn_b vnt 0
C483 vdump a_8400_10658 0
C484 vbp vst 0.4954f
C485 vcp_n en_b 0.52234f
C486 t1a vbp 1.40087f
C487 t2 dn_b 0.03559f
C488 va vbt 0.08741f
C489 up_b pfd_dn 0.18418f
C490 vbp pll_en 0.55872f
C491 r4 r2 0.01867f
C492 a_20196_0 a_21564_n100 0
C493 vdd dn_b 0.63241f
C494 a_19508_1144 r2 0.00202f
C495 vdump a_10200_10658 0
C496 vbp_vco a_18140_1144 0.41357f
C497 vbl vbh 0.20055f
C498 vbl vi 0.01838f
C499 va a_18140_1144 0
C500 vdump a_400_10658 0
C501 t1c cp_trim1 0.17179f
C502 vbp_vco pfd_dn 0.11709f
C503 t2 vcp_n 1.94515f
C504 va pfd_dn 0.05188f
C505 t1c t1b 0.64688f
C506 vdd a_12000_18110 0.00672f
C507 a_20196_0 a_20880_0 0.05369f
C508 a_19512_0 a_21564_n100 0
C509 a_18828_0 a_19512_0 0.05369f
C510 a_18144_0 a_18140_1144 0.0053f
C511 vcp_n vdd 4.43137f
C512 a_18824_1144 r2 0.24429f
C513 r4 vbn_vco 0.03827f
C514 a_6600_16790 vctrl 0.00648f
C515 cp_trim1 pfd_up 0.1647f
C516 a_19508_1144 vbn_vco 0.0038f
C517 vcp_p a_4200_10658 0.0049f
C518 t1b pfd_up 0.00277f
C519 r4 r5 0.56361f
C520 up_b cp_trim1 0.01011f
C521 vdd r1 0.37029f
C522 vdd a_11400_10658 0.01151f
C523 vdd a_12600_10658 0.00153f
C524 vctrl vbn_vco 0.28884f
C525 vbn_vco pfd_up 0.00502f
C526 a_19508_1144 r5 0
C527 a_18828_0 r2 0.11455f
C528 t1b up_b 0
C529 a_20196_0 r3 0
C530 a_20192_1144 a_20196_0 0.0053f
C531 vdd a_10800_18110 0
C532 vref vbl 0.02239f
C533 a_18824_1144 vbn_vco 0.01237f
C534 r3 a_18140_1144 0.25282f
C535 vbp_vco r2 0.03534f
C536 r4 nb 0.0025f
C537 vbt vbh 0
C538 up_s vcl 0.0197f
C539 va cp_trim1 0.06981f
C540 dn_s vctrl 0.5338f
C541 vs vcl 2.16356f
C542 a_18144_0 r2 0.08224f
C543 a_19512_0 r3 0.0705f
C544 vdump up_s 0.33478f
C545 t1b va 0.70437f
C546 t1c t1a 0.06958f
C547 vref vfilt 0.111f
C548 r4 pll_en 0.01395f
C549 a_18828_0 vbn_vco 0.28797f
C550 vbp_vco vbn_vco 1.84138f
C551 a_19508_1144 pll_en 0.00199f
C552 va vbn_vco 0.09483f
C553 vdump vs 0.04935f
C554 vst pfd_up 0.11767f
C555 pfd_dn vi 0
C556 pfd_dn vbh 0
C557 vctrl vst 0.15885f
C558 vref cp_trim0 0.8825f
C559 a_21564_n100 r5 0.08315f
C560 t1a pfd_up 0.0048f
C561 vctrl pll_en 0.30811f
C562 pfd_up pll_en 0.11039f
C563 vbp_vco r5 0.0448f
C564 a_18144_0 vbn_vco 0.31038f
C565 r2 r3 0.5427f
C566 vbn_vco a_20880_0 0.18888f
C567 up_b vst 0.1f
C568 vfilt dn_b 0.03905f
C569 t1a up_b 0.02861f
C570 vref vbt 0.00547f
C571 vcp_p vbp 0.07181f
C572 up_s en_b 0.8211f
C573 vcp_p bias_ref 0.06097f
C574 up_b pll_en 1.05529f
C575 nb a_21564_n100 0.1727f
C576 en_b vs 0.30967f
C577 vdump a_6000_10658 0.00304f
C578 pfd_dn a_13800_10658 0
C579 pfd_dn a_15000_10658 0
C580 a_20880_0 r5 0.12234f
C581 a_20876_1144 r5 0.26179f
C582 dn_b cp_trim0 0.69419f
C583 vbp_vco vst 0
C584 va vst 0.67027f
C585 a_20192_1144 vbn_vco 0
C586 vbn_vco r3 0.06267f
C587 pll_en a_21564_n100 0.08392f
C588 up_s t2 0.12594f
C589 vfilt vcp_n 0.59388f
C590 vbp_vco pll_en 2.03794f
C591 nb a_20880_0 0.0032f
C592 vref pfd_dn 0.11125f
C593 va pll_en 0.11186f
C594 nb a_20876_1144 0.00237f
C595 a_7200_10658 a_8400_10658 0.00585f
C596 t2 vs 0
C597 up_s vdd 4.099f
C598 r3 r5 0.02161f
C599 a_20192_1144 r5 0.11486f
C600 vcp_n cp_trim0 0.5852f
C601 pll_en a_20880_0 0
C602 vdd vs 0.22165f
C603 vbn_vco vi 0.06288f
C604 a_20876_1144 pll_en 0.04939f
C605 vbl a_400_10658 0
C606 bias_ref a_7800_16790 0.00948f
C607 nb a_20192_1144 0
C608 vfilt a_1200_18290 0.00928f
C609 vcp_n vbt 0.43414f
C610 dn_b pfd_dn 3.58679f
C611 vctrl a_4200_10658 0
C612 a_20192_1144 pll_en 0.01591f
C613 vdump vcl 0.0829f
C614 vref a_6600_16790 0.00948f
C615 vref cp_trim1 0.34969f
C616 vcp_n pfd_dn 0.19733f
C617 t1b vref 0.00924f
C618 a_20196_0 r1 0.1209f
C619 vst vi 0.05628f
C620 vref vbn_vco 0.04386f
C621 r1 a_18140_1144 0
C622 vbh pll_en 0
C623 pll_en vi 0.5017f
C624 pfd_dn a_12600_10658 0
C625 pfd_dn a_11400_10658 0
C626 vcp_p vctrl 0.17472f
C627 vcp_p pfd_up 0.04833f
C628 en_b vcl 0.8183f
C629 pfd_dn a_10800_18110 0.01033f
C630 dn_b cp_trim1 0.07889f
C631 vco_out vss 0.157774f
C632 bias_ref vss 6.43985f
C633 pll_en vss 4.69426f
C634 pfd_up vss 1.57211f
C635 cp_trim1 vss 2.18406f
C636 cp_trim0 vss 1.1861f
C637 pfd_dn vss 1.31954f
C638 vctrl vss 20.5438f
C639 vdd vss 371.437f
C640 a_21564_n100 vss 0.306224f
C641 a_20880_0 vss 0.168829f
C642 a_20196_0 vss 0.116081f
C643 a_19512_0 vss 0.115282f
C644 a_18828_0 vss 0.115374f
C645 a_18144_0 vss 0.175644f
C646 nb vss 0.280773f
C647 r4 vss 0.214574f
C648 r5 vss 0.41999f
C649 r3 vss 0.217883f
C650 r1 vss 0.240187f
C651 r2 vss 0.251416f
C652 a_20876_1144 vss 0.00323158f
C653 a_20192_1144 vss 0.00079178f
C654 a_19508_1144 vss 0.000788704f
C655 a_18824_1144 vss 0.000786184f
C656 a_18140_1144 vss 0.00637007f
C657 vi vss 0.923382f
C658 vnt vss 2.60617f
C659 vbn_vco vss 3.94254f
C660 vst vss 2.28014f
C661 vbh vss 0.911508f
C662 vbl vss 3.13608f
C663 vbp_vco vss 1.08571f
C664 a_15000_10658 vss 0.66425f
C665 a_14400_18110 vss 0.68276f
C666 a_13800_10658 vss 0.65668f
C667 a_13200_18110 vss 0.67329f
C668 a_12600_10658 vss 0.65668f
C669 a_12000_18110 vss 0.67329f
C670 a_11400_10658 vss 0.65668f
C671 a_10800_18110 vss 0.67854f
C672 a_10200_10658 vss 0.67606f
C673 a_8400_10658 vss 0.6626f
C674 a_7800_16790 vss 0.66004f
C675 a_7200_10658 vss 0.65668f
C676 a_6600_16790 vss 0.66004f
C677 a_6000_10658 vss 0.6626f
C678 a_4200_10658 vss 0.66852f
C679 vs vss 3.86794f
C680 a_2000_10658 vss 1.06033f
C681 a_1200_18290 vss 1.08054f
C682 a_400_10658 vss 1.07671f
C683 vcl vss 2.54362f
C684 up_b vss 0.473911f
C685 en_b vss 4.02066f
C686 t1c vss 0.518228f
C687 vdump vss 1.71189f
C688 dn_b vss 1.90431f
C689 dn_s vss 1.16877f
C690 vref vss 13.4397f
C691 t1b vss 0.886448f
C692 va vss 2.09199f
C693 t1a vss 0.993619f
C694 t2 vss 0.467963f
C695 vcp_n vss 6.12561f
C696 vbt vss 0.668031f
C697 vbp vss 1.55858f
C698 up_s vss 1.38532f
C699 vcp_p vss 4.43449f
C700 vcp_p.t3 vss 0.874752f
C701 vcp_p.n0 vss 0.376336f
C702 vcp_p.t1 vss 0.874752f
C703 vcp_p.n1 vss 0.375496f
C704 vcp_p.n2 vss 0.334894f
C705 vcp_p.n3 vss 0.323001f
C706 vcp_p.n4 vss 0.116367f
C707 vcp_p.t4 vss 0.510003f
C708 vcp_p.t5 vss 0.517437f
C709 vcp_p.n5 vss 0.171519f
C710 vcp_p.n6 vss 0.606284f
C711 vcp_p.t6 vss 0.101343f
C712 up_s.t0 vss 0.907675f
C713 up_s.t3 vss 0.902414f
C714 up_s.n0 vss 1.08341f
C715 up_s.t2 vss 0.201354f
C716 up_s.t1 vss 0.188826f
C717 up_s.n1 vss 0.88509f
C718 vbp.t1 vss 0.178234f
C719 vbp.t0 vss 0.12161f
C720 vbp.t4 vss 0.0761546f
C721 vbp.n0 vss 0.797697f
C722 vbp.n1 vss 0.517604f
C723 vbp.n2 vss 0.279077f
C724 vbp.n3 vss 0.268052f
C725 vbp.n4 vss 0.279077f
C726 vbp.n5 vss 0.275318f
C727 vbp.t3 vss 0.150666f
C728 vbp.n6 vss 0.265463f
C729 vbp.n7 vss 0.1774f
C730 vbp.n8 vss 0.260685f
C731 vbp.n9 vss 0.26765f
C732 vbp.n10 vss 0.268052f
C733 vbp.n11 vss 0.279077f
C734 vbp.n12 vss 0.279077f
C735 vbp.n13 vss 0.506579f
C736 vbp.n14 vss 0.467928f
C737 vbp.n15 vss 0.166555f
C738 vbt.t6 vss 0.133833f
C739 vbt.t7 vss 0.110424f
C740 vbt.t3 vss 0.133833f
C741 vbt.n0 vss 0.0812814f
C742 vbt.t4 vss 0.133833f
C743 vbt.n1 vss 0.0475287f
C744 vbt.t8 vss 0.107571f
C745 vbt.n2 vss 0.0451299f
C746 vbt.t9 vss 0.107571f
C747 vbt.n3 vss 0.0451299f
C748 vbt.t5 vss 0.133833f
C749 vbt.n4 vss 0.0459413f
C750 vbt.t10 vss 0.109901f
C751 vbt.n5 vss 0.401682f
C752 vbt.t2 vss 0.2699f
C753 vbt.n6 vss 0.537809f
C754 vbt.t11 vss 0.266528f
C755 vbt.n7 vss 0.320945f
C756 vbt.t0 vss 0.266528f
C757 vbt.n8 vss 0.437717f
C758 vbt.t1 vss 0.285393f
C759 vbt.n9 vss 0.0699462f
C760 vcp_n.t4 vss 0.504045f
C761 vcp_n.n0 vss 0.308596f
C762 vcp_n.t2 vss 0.504045f
C763 vcp_n.n1 vss 0.314891f
C764 vcp_n.n2 vss 0.284881f
C765 vcp_n.n3 vss 0.241616f
C766 vcp_n.n4 vss 0.241616f
C767 vcp_n.n5 vss 0.222653f
C768 vcp_n.t9 vss 0.155176f
C769 vcp_n.n6 vss 0.152973f
C770 vcp_n.t6 vss 0.146361f
C771 vcp_n.n7 vss 0.14963f
C772 vcp_n.t7 vss 0.14279f
C773 vcp_n.n8 vss 0.369352f
C774 vcp_n.t11 vss 0.122174f
C775 vcp_n.n9 vss 0.272676f
C776 vcp_n.t10 vss 0.66333f
C777 vcp_n.t5 vss 0.63036f
C778 vcp_n.n10 vss 0.436011f
C779 vcp_n.t0 vss 0.63036f
C780 vcp_n.n11 vss 0.742185f
C781 vcp_n.t8 vss 0.666091f
C782 vcp_n.n12 vss 0.564256f
C783 vcp_n.n13 vss 0.0622235f
C784 t2.t1 vss 0.092369f
C785 t2.t2 vss 0.279271f
C786 t2.t0 vss 0.338048f
C787 t2.n0 vss 0.545128f
C788 t1a.t1 vss 0.131012f
C789 t1a.t0 vss 0.647269f
C790 va.t1 vss 1.49758f
C791 va.t0 vss 0.213908f
C792 va.n0 vss 0.126611f
C793 va.t2 vss 0.122847f
C794 va.n1 vss 1.67426f
C795 t1b.t1 vss 0.141894f
C796 t1b.t0 vss 0.552448f
C797 vref.t1 vss 0.412307f
C798 vref.n0 vss 0.452704f
C799 vref.n1 vss 0.259211f
C800 vref.n2 vss 0.239458f
C801 vref.n3 vss 0.257995f
C802 vref.n4 vss 0.162926f
C803 vref.n5 vss 0.243111f
C804 vref.n6 vss 0.58141f
C805 vref.t2 vss 0.178054f
C806 vref.n7 vss 0.456958f
C807 vref.n8 vss 0.364598f
C808 vref.n9 vss 0.677959f
C809 vref.n10 vss 0.437186f
C810 vref.t0 vss 0.333919f
C811 vref.n11 vss 1.60468f
C812 vref.n12 vss 0.152211f
C813 dn_s.t0 vss 0.210563f
C814 dn_s.t2 vss 0.563398f
C815 dn_s.t1 vss 0.55386f
C816 dn_s.n0 vss 0.183176f
C817 dn_s.t3 vss 0.185207f
C818 dn_s.n1 vss 0.28457f
C819 dn_b.t1 vss 0.156793f
C820 dn_b.t0 vss 0.146658f
C821 dn_b.n0 vss 1.35024f
C822 vdump.t9 vss 0.134096f
C823 vdump.n0 vss 0.139119f
C824 vdump.t7 vss 0.134096f
C825 vdump.n1 vss 0.142689f
C826 vdump.t0 vss 0.149144f
C827 vdump.n2 vss 0.109357f
C828 vdump.t1 vss 0.151869f
C829 vdump.n3 vss 0.133354f
C830 vdump.t16 vss 0.387337f
C831 vdump.t5 vss 0.135126f
C832 vdump.n4 vss 0.148482f
C833 vdump.t13 vss 0.135126f
C834 vdump.n5 vss 0.144761f
C835 vdump.n6 vss 0.164863f
C836 vdump.t11 vss 0.135126f
C837 vdump.n7 vss 0.144761f
C838 vdump.n8 vss 0.116211f
C839 vdump.t15 vss 0.135126f
C840 vdump.n9 vss 0.144761f
C841 vdump.n10 vss 0.0509695f
C842 vdump.t2 vss 0.251027f
C843 vdump.n11 vss 0.148971f
C844 vdump.t3 vss 0.251027f
C845 vdump.n12 vss 0.454219f
C846 vdump.t17 vss 0.29738f
C847 vdump.n13 vss 0.0762981f
C848 vdump.n14 vss 0.757402f
C849 vdump.n15 vss 0.13683f
C850 t1c.t0 vss 0.166424f
C851 t1c.t1 vss 0.170918f
C852 en_b.t1 vss 0.239456f
C853 en_b.n0 vss 0.670776f
C854 en_b.t0 vss 0.420298f
C855 en_b.n1 vss 1.4278f
C856 en_b.n2 vss 0.280546f
C857 en_b.n3 vss 0.267066f
C858 en_b.n4 vss 0.326046f
C859 en_b.n5 vss 1.31635f
C860 up_b.t1 vss 0.0808144f
C861 up_b.n0 vss 0.68396f
C862 up_b.t0 vss 0.391044f
C863 vcl.t0 vss 0.547404f
C864 vcl.t3 vss 0.550524f
C865 vcl.t2 vss 0.53879f
C866 vcl.n0 vss 0.179055f
C867 vcl.t1 vss 0.53879f
C868 vcl.n1 vss 0.183502f
C869 vcl.n2 vss 0.225681f
C870 vcl.t4 vss 0.189874f
C871 vs.t1 vss 0.248727f
C872 vs.t2 vss 0.251524f
C873 vs.t0 vss 1.21285f
C874 vs.n0 vss 1.78858f
C875 vbp_vco.t1 vss 0.202129f
C876 vbp_vco.t0 vss 0.193911f
C877 vbp_vco.n0 vss 0.222089f
C878 vbp_vco.n1 vss 0.112944f
C879 vbp_vco.t4 vss 0.115556f
C880 vbp_vco.n2 vss 0.139736f
C881 vbp_vco.n3 vss 0.159698f
C882 vbp_vco.n4 vss 0.116816f
C883 vbp_vco.t6 vss 0.115556f
C884 vbp_vco.n5 vss 0.135752f
C885 vbp_vco.n6 vss 0.0528721f
C886 vbp_vco.t2 vss 0.0650416f
C887 vbp_vco.n7 vss 0.175771f
C888 vbp_vco.n8 vss 0.0724056f
C889 vbp_vco.n9 vss 0.0721818f
C890 vbp_vco.n10 vss 0.0361394f
C891 vbp_vco.n11 vss 0.0721818f
C892 vbp_vco.n12 vss 0.0390693f
C893 vbp_vco.n13 vss 0.0721818f
C894 vbp_vco.n14 vss 0.0624693f
C895 vbp_vco.n15 vss 0.0746457f
C896 vbp_vco.n16 vss 0.206385f
C897 vbl.t4 vss 0.262921f
C898 vbl.t5 vss 0.289879f
C899 vbl.t6 vss 0.262921f
C900 vbl.n0 vss 0.151152f
C901 vbl.t7 vss 0.27189f
C902 vbl.n1 vss 0.293141f
C903 vbl.t1 vss 0.140377f
C904 vbl.n2 vss 0.233899f
C905 vbl.n3 vss 0.173593f
C906 vbl.n4 vss 0.336129f
C907 vbl.t3 vss 0.140377f
C908 vbl.n5 vss 0.236767f
C909 vbl.n6 vss 0.271481f
C910 vbl.n7 vss 0.316176f
C911 vbh.t5 vss 0.155892f
C912 vbh.t4 vss 0.171906f
C913 vbh.t1 vss 0.159514f
C914 vbh.n0 vss 0.172128f
C915 vbh.n1 vss 0.104466f
C916 vbh.n2 vss 0.187565f
C917 vbh.t3 vss 0.159514f
C918 vbh.n3 vss 0.173443f
C919 vbh.n4 vss 0.204149f
C920 vbh.n5 vss 0.212894f
C921 vst.t2 vss 0.312815f
C922 vst.t3 vss 0.307686f
C923 vst.n0 vss 0.187899f
C924 vst.n1 vss 0.281549f
C925 vst.t1 vss 0.102108f
C926 vst.n2 vss 0.4625f
C927 vst.t0 vss 0.824019f
C928 vbn_vco.t1 vss 0.335878f
C929 vbn_vco.t4 vss 0.341205f
C930 vbn_vco.t3 vss 0.134537f
C931 vbn_vco.n0 vss 0.181684f
C932 vbn_vco.n1 vss 0.0686388f
C933 vbn_vco.t0 vss 0.116119f
C934 vbn_vco.n2 vss 0.0764146f
C935 vbn_vco.n3 vss 0.343707f
C936 vbn_vco.n4 vss 0.0764146f
C937 vbn_vco.n5 vss 0.0596834f
C938 vbn_vco.n6 vss 0.0764146f
C939 vbn_vco.n7 vss 0.0596834f
C940 vbn_vco.n8 vss 0.0764146f
C941 vbn_vco.n9 vss 0.0954468f
C942 vbn_vco.n10 vss 0.0801808f
C943 vbn_vco.n11 vss 0.307578f
C944 vbn_vco.n12 vss 0.351514f
C945 vnt.t0 vss 0.30243f
C946 vnt.t3 vss 0.227632f
C947 vnt.t5 vss 0.30243f
C948 vnt.n0 vss 0.0938871f
C949 vnt.t2 vss 0.221593f
C950 vnt.n1 vss 0.235849f
C951 vnt.t6 vss 0.196841f
C952 vnt.n2 vss 0.199141f
C953 vnt.t4 vss 0.196841f
C954 vnt.n3 vss 0.187016f
C955 vnt.t7 vss 0.196841f
C956 vnt.n4 vss 0.29851f
C957 vnt.t1 vss 0.208798f
C958 vnt.n5 vss 0.160535f
C959 vi.t2 vss 0.164835f
C960 vi.t4 vss 0.22326f
C961 vi.t0 vss 0.161773f
C962 vi.n0 vss 0.210907f
C963 vi.t1 vss 0.161943f
C964 vi.n1 vss 0.0718482f
C965 vi.t3 vss 0.171456f
C966 vi.n2 vss 0.146897f
C967 a_18140_1144.t2 vss 0.00647934f
C968 a_18140_1144.n0 vss 0.00967615f
C969 a_18140_1144.t0 vss 0.0103148f
C970 a_18140_1144.t1 vss 0.0103284f
C971 a_18140_1144.n1 vss 0.015653f
C972 a_18140_1144.n2 vss 0.0201967f
C973 a_18140_1144.t3 vss 0.0163726f
C974 a_18824_1144.t1 vss 0.00428646f
C975 a_18824_1144.t3 vss 0.00271197f
C976 a_18824_1144.t2 vss 0.00271547f
C977 a_18824_1144.n0 vss 0.00405617f
C978 a_18824_1144.n1 vss 0.00523357f
C979 a_18824_1144.t0 vss 0.00172269f
C980 a_18824_1144.n2 vss 0.00250738f
C981 a_19508_1144.t1 vss 0.00427222f
C982 a_19508_1144.t3 vss 0.00272779f
C983 a_19508_1144.t2 vss 0.00273132f
C984 a_19508_1144.n0 vss 0.00405367f
C985 a_19508_1144.n1 vss 0.00523037f
C986 a_19508_1144.t0 vss 0.00170997f
C987 a_19508_1144.n2 vss 0.00250585f
C988 a_20192_1144.t1 vss 0.00424872f
C989 a_20192_1144.t2 vss 0.00273089f
C990 a_20192_1144.t3 vss 0.00273453f
C991 a_20192_1144.n0 vss 0.00408119f
C992 a_20192_1144.n1 vss 0.00526584f
C993 a_20192_1144.t0 vss 0.00166927f
C994 a_20192_1144.n2 vss 0.00252289f
C995 a_20876_1144.t2 vss 0.0108177f
C996 a_20876_1144.t3 vss 0.0069547f
C997 a_20876_1144.t0 vss 0.00696404f
C998 a_20876_1144.n0 vss 0.0102495f
C999 a_20876_1144.n1 vss 0.0132248f
C1000 a_20876_1144.t1 vss 0.00433939f
C1001 a_20876_1144.n2 vss 0.00633584f
C1002 r2.t2 vss 0.0349202f
C1003 r2.n0 vss 0.0687999f
C1004 r2.n1 vss 0.0873565f
C1005 r2.n2 vss 0.0576277f
C1006 r2.n3 vss 0.046685f
C1007 r2.n4 vss 0.0519802f
C1008 r2.t0 vss 0.0196735f
C1009 r2.t1 vss 0.0197199f
C1010 r2.n5 vss 0.0276396f
C1011 r2.t3 vss 0.0349584f
C1012 r1.t2 vss 0.0296826f
C1013 r1.n0 vss 0.0633684f
C1014 r1.n1 vss 0.081296f
C1015 r1.n2 vss 0.0530072f
C1016 r1.n3 vss 0.0412117f
C1017 r1.n4 vss 0.0496581f
C1018 r1.t0 vss 0.016605f
C1019 r1.t1 vss 0.0166407f
C1020 r1.n5 vss 0.0239407f
C1021 r1.t3 vss 0.0296517f
C1022 r3.t0 vss 0.0305069f
C1023 r3.n0 vss 0.0600981f
C1024 r3.n1 vss 0.0793924f
C1025 r3.n2 vss 0.0505477f
C1026 r3.n3 vss 0.042744f
C1027 r3.n4 vss 0.0474214f
C1028 r3.t1 vss 0.0171512f
C1029 r3.t3 vss 0.0171899f
C1030 r3.n5 vss 0.025757f
C1031 r3.t2 vss 0.0305407f
C1032 r5.t0 vss 0.0393989f
C1033 r5.n0 vss 0.0752282f
C1034 r5.n1 vss 0.0951373f
C1035 r5.n2 vss 0.0632744f
C1036 r5.n3 vss 0.0535039f
C1037 r5.n4 vss 0.0605405f
C1038 r5.n5 vss 0.0563275f
C1039 r5.n6 vss 0.0569998f
C1040 r5.n7 vss 0.0582003f
C1041 r5.n8 vss 0.046016f
C1042 r5.t2 vss 0.0222205f
C1043 r5.t3 vss 0.0222717f
C1044 r5.n9 vss 0.0322407f
C1045 r5.t1 vss 0.0394405f
C1046 r4.t0 vss 0.0304129f
C1047 r4.n0 vss 0.0606937f
C1048 r4.n1 vss 0.0783751f
C1049 r4.n2 vss 0.0508371f
C1050 r4.n3 vss 0.0411846f
C1051 r4.n4 vss 0.0471624f
C1052 r4.t3 vss 0.0170906f
C1053 r4.t2 vss 0.0171314f
C1054 r4.n5 vss 0.0243822f
C1055 r4.t1 vss 0.0303793f
C1056 nb.t5 vss 0.0211348f
C1057 nb.n0 vss 0.0512604f
C1058 nb.t1 vss 0.0232379f
C1059 nb.t0 vss 0.02328f
C1060 nb.n1 vss 0.0375299f
C1061 nb.t2 vss 0.0231761f
C1062 nb.t3 vss 0.0232182f
C1063 nb.n2 vss 0.0388244f
C1064 nb.n3 vss 0.0819953f
C1065 nb.n4 vss 0.0523246f
C1066 nb.n5 vss 0.05283f
C1067 nb.n6 vss 0.0455801f
C1068 nb.n7 vss 0.0539925f
C1069 nb.n8 vss 0.0638368f
C1070 nb.n9 vss 0.0646343f
C1071 nb.t4 vss 0.0211011f
C1072 a_18144_0.t0 vss 0.0259952f
C1073 a_18144_0.n0 vss 0.0289695f
C1074 a_18144_0.t3 vss 0.0453585f
C1075 a_18144_0.t1 vss 0.0242249f
C1076 a_18144_0.n1 vss 0.0210845f
C1077 a_18144_0.n2 vss 0.105423f
C1078 a_18144_0.t2 vss 0.0260707f
C1079 a_18828_0.t0 vss 0.0219643f
C1080 a_18828_0.n0 vss 0.0255216f
C1081 a_18828_0.t2 vss 0.0395295f
C1082 a_18828_0.t3 vss 0.0209136f
C1083 a_18828_0.n1 vss 0.0185753f
C1084 a_18828_0.n2 vss 0.0928767f
C1085 a_18828_0.t1 vss 0.0219019f
C1086 a_19512_0.t0 vss 0.0219178f
C1087 a_19512_0.n0 vss 0.0253699f
C1088 a_19512_0.t2 vss 0.0391158f
C1089 a_19512_0.t3 vss 0.0206095f
C1090 a_19512_0.n1 vss 0.0184656f
C1091 a_19512_0.n2 vss 0.092325f
C1092 a_19512_0.t1 vss 0.0219835f
C1093 a_20196_0.t0 vss 0.020005f
C1094 a_20196_0.n0 vss 0.0184955f
C1095 a_20196_0.t3 vss 0.0385383f
C1096 a_20196_0.t1 vss 0.0220345f
C1097 a_20196_0.t2 vss 0.0220975f
C1098 a_20196_0.n1 vss 0.0254128f
C1099 a_20196_0.n2 vss 0.0924773f
C1100 a_20880_0.t0 vss 0.0425105f
C1101 a_20880_0.t1 vss 0.0236889f
C1102 a_20880_0.n0 vss 0.0187713f
C1103 a_20880_0.t3 vss 0.0256187f
C1104 a_20880_0.t2 vss 0.0256962f
C1105 a_20880_0.n1 vss 0.0257931f
C1106 a_20880_0.n2 vss 0.0938603f
C1107 a_21564_n100.t2 vss 0.0265841f
C1108 a_21564_n100.n0 vss 0.0255344f
C1109 a_21564_n100.t1 vss 0.0613569f
C1110 a_21564_n100.n1 vss 0.0815154f
C1111 a_21564_n100.t0 vss 0.0342123f
C1112 a_21564_n100.n2 vss 0.0277918f
C1113 a_21564_n100.t3 vss 0.0266452f
C1114 vss.t38 vss 0.11221p
C1115 vss.t88 vss 25.2875f
C1116 vss.t3 vss 0.21258f
C1117 vss.t112 vss 0.31269f
C1118 vss.t114 vss 0.31269f
C1119 vss.t67 vss 0.21258f
C1120 vss.t154 vss 0.24788f
C1121 vss.t152 vss 0.24041f
C1122 vss.t116 vss 0.24041f
C1123 vss.t125 vss 0.24041f
C1124 vss.t160 vss 0.24041f
C1125 vss.t81 vss 0.24041f
C1126 vss.t147 vss 0.18893f
C1127 vss.t164 vss 0.18893f
C1128 vss.t158 vss 0.37762f
C1129 vss.t75 vss 0.07553f
C1130 vss.t166 vss 0.07524f
C1131 vss.t63 vss 0.07524f
C1132 vss.t79 vss 0.08018f
C1133 vss.t85 vss 0.08724f
C1134 vss.t7 vss 0.65689f
C1135 vss.t156 vss 0.73305f
C1136 vss.t99 vss 0.73305f
C1137 vss.t95 vss 0.73305f
C1138 vss.t121 vss 0.73305f
C1139 vss.t1 vss 0.65689f
C1140 vss.t119 vss 0.7265f
C1141 vss.t73 vss 0.13023f
C1142 vss.t65 vss 0.08599f
C1143 vss.t137 vss 0.75007f
C1144 vss.t21 vss 0.65355f
C1145 vss.t19 vss 0.65068f
C1146 vss.t17 vss 0.65068f
C1147 vss.t15 vss 0.6578f
C1148 vss.t101 vss 0.05812f
C1149 vss.t123 vss 0.058f
C1150 vss.t143 vss 0.03857f
C1151 vss.t141 vss 0.03845f
C1152 vss.t35 vss 0.04832f
C1153 vss.t97 vss 0.04812f
C1154 vss.t83 vss 0.04832f
C1155 vss.t23 vss 0.04812f
C1156 vss.t25 vss 0.04832f
C1157 vss.t11 vss 0.04812f
C1158 vss.t13 vss 0.04832f
C1159 vss.t132 vss 0.04812f
C1160 vss.t134 vss 0.04832f
C1161 vss.t69 vss 0.04812f
C1162 vdd.t12 vss 1.26134f
C1163 vdd.n0 vss 1.58779f
C1164 vdd.t75 vss 1.30736f
C1165 vdd.n1 vss 0.0606575f
C1166 vdd.t103 vss 1.30736f
C1167 vdd.n2 vss 0.0616439f
C1168 vdd.n3 vss 0.176007f
C1169 vdd.t7 vss 1.26134f
C1170 vdd.n4 vss 0.0512394f
C1171 vdd.t35 vss 0.837994f
C1172 vdd.n5 vss 0.134773f
C1173 vdd.t101 vss 0.818571f
C1174 vdd.n6 vss 0.135759f
C1175 vdd.n7 vss 0.176007f
C1176 vdd.t88 vss 0.818571f
C1177 vdd.n8 vss 0.125355f
C1178 vdd.t51 vss 0.818571f
C1179 vdd.n9 vss 0.134773f
C1180 vdd.t67 vss 0.818571f
C1181 vdd.n10 vss 0.135759f
C1182 vdd.n11 vss 0.176007f
C1183 vdd.t65 vss 0.818571f
C1184 vdd.n12 vss 0.125355f
C1185 vdd.t33 vss 0.572465f
C1186 vdd.n13 vss 0.134773f
C1187 vdd.t69 vss 0.818571f
C1188 vdd.n14 vss 0.119272f
C1189 vdd.n15 vss 0.17502f
C1190 vdd.t53 vss 0.818571f
C1191 vdd.n16 vss 0.125355f
C1192 vdd.t14 vss 0.818571f
C1193 vdd.n17 vss 0.134773f
C1194 vdd.t1 vss 0.818571f
C1195 vdd.n18 vss 0.135759f
C1196 vdd.n19 vss 0.176007f
C1197 vdd.t28 vss 0.818571f
C1198 vdd.n20 vss 0.125355f
C1199 vdd.t63 vss 0.818571f
C1200 vdd.n21 vss 0.134773f
C1201 vdd.t30 vss 0.837994f
C1202 vdd.n22 vss 1.67623f
C1203 vdd.n23 vss 1.72411f
C1204 vdd.n24 vss 1.72411f
C1205 vdd.n25 vss 1.72411f
C1206 vdd.n26 vss 1.72411f
C1207 vdd.n27 vss 1.72411f
C1208 vdd.t0 vss 1.93623f
C1209 vdd.t6 vss 1.93623f
C1210 vdd.t11 vss 2.24678f
C1211 vdd.t13 vss 2.21989f
C1212 vdd.t27 vss 1.93623f
C1213 vdd.t29 vss 2.25327f
C1214 vdd.t32 vss 2.21989f
C1215 vdd.t34 vss 2.21989f
C1216 vdd.t50 vss 2.21989f
C1217 vdd.t52 vss 1.93623f
C1218 vdd.t62 vss 2.21989f
C1219 vdd.t64 vss 1.93623f
C1220 vdd.t66 vss 1.93623f
C1221 vdd.t68 vss 1.93623f
C1222 vdd.t74 vss 2.21989f
C1223 vdd.t87 vss 1.93623f
C1224 vdd.t100 vss 1.93623f
C1225 vdd.t102 vss 1.93623f
C1226 vdd.n28 vss 0.340858f
C1227 vdd.n29 vss 0.661932f
C1228 vdd.n30 vss 0.114817f
C1229 vdd.t41 vss 0.420109f
C1230 vdd.n31 vss 0.0458376f
C1231 vdd.t16 vss 0.497473f
C1232 vdd.n32 vss 0.0552634f
C1233 vdd.t43 vss 0.497473f
C1234 vdd.n33 vss 0.0562499f
C1235 vdd.n34 vss 0.0729252f
C1236 vdd.t55 vss 0.420109f
C1237 vdd.n35 vss 0.0458376f
C1238 vdd.t95 vss 0.126106f
C1239 vdd.n36 vss 0.0582462f
C1240 vdd.t49 vss 0.129292f
C1241 vdd.n37 vss 0.0453757f
C1242 vdd.t105 vss 0.0756026f
C1243 vdd.n38 vss 0.0563282f
C1244 vdd.t107 vss 0.0730583f
C1245 vdd.n39 vss 0.0609393f
C1246 vdd.n40 vss 0.066623f
C1247 vdd.t109 vss 0.0950728f
C1248 vdd.n41 vss 0.0488203f
C1249 vdd.t24 vss 1.03159f
C1250 vdd.n42 vss 0.0999424f
C1251 vdd.n43 vss 0.111662f
C1252 vdd.t22 vss 0.207455f
C1253 vdd.n44 vss 0.0418449f
C1254 vdd.t119 vss 0.223966f
C1255 vdd.n45 vss 0.0402713f
C1256 vdd.t79 vss 0.223966f
C1257 vdd.n46 vss 0.0412656f
C1258 vdd.n47 vss 0.0674294f
C1259 vdd.t121 vss 0.207455f
C1260 vdd.n48 vss 0.0363491f
C1261 vdd.t111 vss 0.073301f
C1262 vdd.n49 vss 0.487334f
C1263 vdd.n50 vss 0.389412f
C1264 vdd.n51 vss 0.421119f
C1265 vdd.n52 vss 0.452817f
C1266 vdd.n53 vss 0.343762f
C1267 vdd.n54 vss 0.658887f
C1268 vdd.n55 vss 0.357713f
C1269 vdd.t15 vss 0.570641f
C1270 vdd.t21 vss 0.380424f
C1271 vdd.t23 vss 0.950431f
C1272 vdd.t26 vss 0.44383f
C1273 vdd.t31 vss 0.355067f
C1274 vdd.t40 vss 0.497723f
C1275 vdd.t42 vss 0.497723f
C1276 vdd.t48 vss 0.35253f
C1277 vdd.t54 vss 0.443196f
C1278 vdd.t61 vss 0.44383f
C1279 vdd.t70 vss 0.428619f
C1280 vdd.t71 vss 0.402619f
C1281 vdd.t72 vss 0.402619f
C1282 vdd.t73 vss 0.402619f
C1283 vdd.t78 vss 0.355067f
C1284 vdd.t94 vss 0.407058f
C1285 vdd.t96 vss 0.380424f
C1286 vdd.t104 vss 0.35253f
C1287 vdd.t106 vss 0.334141f
C1288 vdd.t108 vss 0.64229f
C1289 vdd.t110 vss 0.365323f
C1290 vdd.t116 vss 0.44383f
C1291 vdd.t117 vss 0.44383f
C1292 vdd.t118 vss 0.380424f
C1293 vdd.t120 vss 0.348092f
C1294 vdd.n56 vss 0.161234f
C1295 vdd.n57 vss 0.907803f
C1296 vdd.n58 vss 0.322217f
C1297 vdd.n59 vss 0.0254357f
C1298 vdd.n60 vss 0.322217f
C1299 vdd.n61 vss 0.0254357f
C1300 vdd.n62 vss 0.307178f
C1301 vdd.n63 vss 0.0230166f
C1302 vdd.t2 vss 0.139439f
C1303 vdd.t3 vss 0.0874867f
C1304 vdd.t4 vss 0.407379f
C1305 vdd.t8 vss 0.422418f
C1306 vdd.t10 vss 0.139439f
C1307 vdd.t17 vss 0.139439f
C1308 vdd.t18 vss 0.246067f
C1309 vdd.t19 vss 0.358167f
C1310 vdd.t25 vss 0.458086f
C1311 vdd.t36 vss 0.407379f
C1312 vdd.t38 vss 0.407379f
C1313 vdd.t44 vss 0.10936f
C1314 vdd.t46 vss 0.358167f
C1315 vdd.t56 vss 0.139439f
C1316 vdd.t57 vss 0.10936f
C1317 vdd.t59 vss 0.127132f
C1318 vdd.t76 vss 0.10936f
C1319 vdd.t80 vss 0.328089f
C1320 vdd.t81 vss 0.10936f
C1321 vdd.t83 vss 0.358167f
C1322 vdd.t85 vss 0.370466f
C1323 vdd.t89 vss 0.328089f
C1324 vdd.t90 vss 0.10936f
C1325 vdd.t92 vss 0.285712f
C1326 vdd.t97 vss 0.81749f
C1327 vdd.t99 vss 0.139439f
C1328 vdd.t114 vss 0.407379f
C1329 vdd.t112 vss 0.146273f
C1330 vdd.t77 vss 0.17232f
C1331 vdd.n64 vss 0.0660515f
C1332 vdd.t84 vss 0.172547f
C1333 vdd.n65 vss 0.0592874f
C1334 vdd.t82 vss 0.17232f
C1335 vdd.n66 vss 0.0589038f
C1336 vdd.t60 vss 0.172547f
C1337 vdd.n67 vss 0.0466987f
C1338 vdd.t58 vss 0.17232f
C1339 vdd.n68 vss 0.0592874f
C1340 vdd.t47 vss 0.172547f
C1341 vdd.n69 vss 0.0592874f
C1342 vdd.t45 vss 0.17232f
C1343 vdd.n70 vss 0.0592874f
C1344 vdd.t93 vss 0.172547f
C1345 vdd.n71 vss 0.0592874f
C1346 vdd.t91 vss 0.17232f
C1347 vdd.n72 vss 0.0464795f
C1348 vdd.t20 vss 0.172547f
C1349 vdd.n73 vss 0.059123f
C1350 vdd.t9 vss 0.0761193f
C1351 vdd.n74 vss 0.0838464f
C1352 vdd.t5 vss 0.0762368f
C1353 vdd.n75 vss 0.0838464f
C1354 vdd.t115 vss 0.0701616f
C1355 vdd.n76 vss 0.0822571f
C1356 vdd.t113 vss 0.0702556f
C1357 vdd.n77 vss 0.0748902f
C1358 vdd.t86 vss 0.101806f
C1359 vdd.n78 vss 0.0794779f
C1360 vdd.t39 vss 0.1019f
C1361 vdd.n79 vss 0.0794779f
C1362 vdd.t37 vss 0.101806f
C1363 vdd.n80 vss 0.161484f
C1364 vdd.t98 vss 0.107059f
C1365 vdd.n81 vss 0.0101853f
C1366 vdd.n82 vss 0.723693f
C1367 vctrl.n0 vss 0.224717f
C1368 vctrl.n1 vss 0.125375f
C1369 vctrl.n2 vss 0.410606f
C1370 vctrl.t0 vss 0.427874f
C1371 vctrl.n3 vss 0.041938f
C1372 vctrl.n4 vss 0.253324f
C1373 vctrl.t1 vss 0.322476f
C1374 vctrl.n5 vss 2.73369f
C1375 vctrl.t2 vss 0.12246f
C1376 vctrl.n6 vss 0.44287f
C1377 vctrl.n7 vss 0.263165f
C1378 vctrl.n8 vss 0.446208f
C1379 vctrl.n9 vss 0.364369f
C1380 vctrl.n10 vss 0.301908f
C1381 pfd_dn.n0 vss 1.38893f
C1382 pfd_dn.n1 vss 1.3738f
C1383 cp_trim0.n0 vss 1.30515f
C1384 cp_trim1.n0 vss 1.57641f
C1385 pfd_up.n0 vss 0.976869f
C1386 pfd_up.n1 vss 1.96164f
C1387 pll_en.n0 vss 0.068783f
C1388 pll_en.n1 vss 0.0638706f
C1389 pll_en.n2 vss 0.0641661f
C1390 pll_en.n3 vss 0.357389f
C1391 pll_en.n4 vss 0.456565f
C1392 pll_en.n5 vss 0.631299f
C1393 pll_en.n6 vss 0.596245f
C1394 pll_en.n7 vss 2.357f
C1395 pll_en.n8 vss 0.472081f
C1396 pll_en.n9 vss 0.626337f
C1397 bias_ref.t0 vss 0.0360324f
C1398 bias_ref.t1 vss 0.0185116f
C1399 bias_ref.n0 vss 0.535984f
C1400 vco_out.t0 vss 0.026092f
C1401 vco_out.t5 vss 0.0261218f
C1402 vco_out.n0 vss 0.061557f
C1403 vco_out.n1 vss 0.0729067f
C1404 vco_out.t3 vss 0.026092f
C1405 vco_out.t1 vss 0.0261218f
C1406 vco_out.n2 vss 0.0481012f
C1407 vco_out.t4 vss 0.0260523f
C1408 vco_out.t2 vss 0.0260821f
C1409 vco_out.n3 vss 0.0470308f
C1410 vco_out.n4 vss 0.063288f
.ends
