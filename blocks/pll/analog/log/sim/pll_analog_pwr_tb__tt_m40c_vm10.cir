* pll_analog_pwr_tb.cir - power-down bench (spec.yaml: standby_current_ua,
* vco_out_off_toggles). Written from spec/ only, before any netlist exists.
*
* pll_en = 0 throughout (DC operating point with the cell disabled, no uic).
*  - standby_current_ua: |I(vdd)| in uA, max over vctrl swept 0.3 .. vdd-0.3 V
*    (vctrl is still held by the filter in standby, so it is swept, not fixed)
*    and over all four cp_trim codes: the trims are user pins and stay set
*    through standby (a trim-leg hold gated by pll_en once drew 70..210 uA
*    with a trim bit high, unseen at trim 00). Pump inputs low, bias_ref
*    floating.
*  - vco_out_off_toggles: vdd/2 crossings of vco_out (either direction) in a
*    500 ns transient with vctrl = vdd-0.3 V (the strongest drive the ring
*    would see) and pll_en = 0. Must be 0.
* sim_timeout_s: 300

.include '/home/hive2/.cc/toolchains/iic-osic-tools-2026.09/foss/pdks/gf180mcuD/libs.tech/ngspice/design.spice'
.lib '/home/hive2/.cc/toolchains/iic-osic-tools-2026.09/foss/pdks/gf180mcuD/libs.tech/ngspice/sm141064.spice' typical
.lib '/home/hive2/.cc/toolchains/iic-osic-tools-2026.09/foss/pdks/gf180mcuD/libs.tech/ngspice/sm141064.spice' res_typical
.lib '/home/hive2/.cc/toolchains/iic-osic-tools-2026.09/foss/pdks/gf180mcuD/libs.tech/ngspice/sm141064.spice' mimcap_typical
* the loop filter's MOS caps: the PDK's cap_nmos_03v3_b (sm141064.spice, .lib
* moscap), written in charge form. The PDK's C(v) = A*(cvar1 + cvar2*tanh(cvar3*v
* + cvar4)) as a voltage-dependent C makes the transient step collapse ("timestep
* too small" on its current probe) at most corners on the extracted netlist;
* Q(v), its integral, is the same device and holds (pex tt_27c: Icp 18.52 vs
* 18.52 uA, Kvco 72.67 vs 72.66 MHz/V, fmax 203.31 vs 203.29 MHz against the
* PDK form under Gear). Its corner factor follows the MIM corner's
* (mim_corner_2p0ff: 1 / 1.1 ss / 0.9 ff, as moscap_<corner> sets it).
.param cap_nmos_03v3_b_corner=mim_corner_2p0ff
.subckt cap_nmos_03v3_b 1 2 c_length=1e-6 c_width=1e-6 dtemp=0
.param cvar1=0.002458 cvar2=0.001533 cvar3=1.515152 cvar4=0.560606
* ln(cosh(x)) written |x| + ln(1+exp(-2|x|)) - ln 2, the same function, as in
* spec/moscap.spice and layout_ref/: cosh overflowed on a wild Newton iterate
* ('Error: 1710.01 out of range for cosh', startup_tb tt_125c_vp10 with MP_HDM).
C1 1 2 q='cap_nmos_03v3_b_corner*c_length*c_width*(cvar1*v(1,2)+cvar2/cvar3*(abs(cvar3*v(1,2)+cvar4)+ln(1+exp(-2*abs(cvar3*v(1,2)+cvar4)))-ln(2)))'
.ends cap_nmos_03v3_b
.include '/home/hive2/wt/pll-pump/blocks/pll/analog/netlist/pll_analog.cir'
.param w_bp='4e-06' l_bp='2e-06' w_b1='2e-06' l_b1='2e-06' w_b2='4e-06' l_b2='1e-06' rb_l=0.000366 rbt_l=0.00018 w_cpn='4e-05' l_cpn='4e-06' w_cpp='1e-04' l_cpp='4e-06' w_swn='2e-06' w_swp='4e-06' l_sw='5e-07' r1_l=0.00015 c1_w=3.5e-05 c1_l=1.2e-05 c2_w=4.3e-05 c2_l=1.2e-05 w_v2i='1e-05' l_v2i='1e-06' rv2i_l=4.3e-05 w_flr='2e-06' l_flr='2e-06' w_v2ip='1e-05' w_v2in='4e-06' l_v2i2='5e-07' w_sp='1e-05' w_sn='4e-06' l_s='5e-07' w_rp='6e-06' w_rn='3e-06' l_r=2.8e-07 w_gp='4e-06' w_gn='4e-06' w_op=1.2e-05 w_on='6e-06' m_buft=4 w_bufp='2e-05' l_bufp='1e-06' w_bufn='1e-05' l_bufn='1e-06' w_bufln='4e-06' w_buflp='8e-06' l_bufl='2e-06' w_cl='5e-05' l_cl='1e-06'

.temp -40
.param vddp=2.97
.csparam vddp={vddp}
.csparam vmid={vddp/2}
.csparam vhi={vddp-0.3}
.csparam vstp={(vddp-0.6)/24}

vdd_src  vdd      0 {vddp}
vss_src  vss      0 0
ven      pll_en   0 0
vup      pfd_up   0 0
vdn      pfd_dn   0 0
vt0      cp_trim0 0 0
vt1      cp_trim1 0 0
vvc      vctrl    0 {vddp/2}
cload2   vco_div2 0 30f
xdut vco_div2 pfd_up pfd_dn pll_en cp_trim0 cp_trim1 vctrl bias_ref vdd vss pll_analog

.control
set noaskquit
* one sweep per trim code (00, 01, 11, 10); each plot's max kept as a string
dc vvc 0.3 $&vhi $&vstp
let x = vecmax(abs(i(vdd_src)))*1e6
set i00 = "$&x"
alter vt0 dc = $&vddp
dc vvc 0.3 $&vhi $&vstp
let x = vecmax(abs(i(vdd_src)))*1e6
set i01 = "$&x"
alter vt1 dc = $&vddp
dc vvc 0.3 $&vhi $&vstp
let x = vecmax(abs(i(vdd_src)))*1e6
set i11 = "$&x"
alter vt0 dc = 0
dc vvc 0.3 $&vhi $&vstp
let x = vecmax(abs(i(vdd_src)))*1e6
set i10 = "$&x"
alter vt1 dc = 0
compose isbs values $i00 $i01 $i11 $i10
let x = vecmax(isbs)
set isb = "$&x"
echo "standby_current_by_trim_ua 00 $i00 01 $i01 10 $i10 11 $i11"
alter vvc dc = $&vhi
tran 50p 500n 0 50p
let nx = length(time)
let nx1 = nx - 1
let nx2 = nx - 2
let hi = (v(xdut.vco_out) gt vmid)
let x = mean(abs(hi[1,$&nx1] - hi[0,$&nx2]))*(nx - 1)
set tog = "$&x"
echo
echo "  Measurements for Transient Analysis (pll_analog_pwr_tb, computed in .control)"
echo "standby_current_ua = $isb"
echo "vco_out_off_toggles = $tog"
echo
.endc

.end
