* pll_analog_cp_tb.cir - charge-pump DC bench (spec.yaml: icp_up_code00_ua,
* icp_dn_code00_ua, icp_up_code00_tt_ua, icp_up_code01_ua, icp_up_code10_ua,
* icp_up_code11_ua, icp_code11_over_code00_ratio, cp_updn_mismatch_pct,
* vctrl_leak_off_na). Written from spec/ only, before any netlist exists.
*
* vctrl is forced by the 0 V-referenced source vvc; i(vvc) is the current the
* pump pushes INTO vctrl (ngspice: positive into the + node of the source),
* so UP current = +i(vvc), DN current = -i(vvc). Every point is a DC
* operating point (no uic). pll_en = 1, bias_ref floating (internal default),
* vco_out loaded with 15 fF, as spec.md's default conditions.
*
* Spec reading (resolved here, spec.md "Measures"):
*  - icp_*_code*: vctrl = vdd/2, the addressed input held high.
*  - cp_updn_mismatch_pct: vctrl swept 0.3 V .. vdd-0.3 V (49 points) at code
*    00; max over the sweep of 100*|Iup-Idn| / Icp, Icp = the code-00 mid-range
*    pump current (Iup+Idn)/2 at vdd/2.
*  - vctrl_leak_off_na: both inputs low, same sweep, max |i(vctrl)| in nA.
*  - icp_up_code00_tt_ua is the same UP code-00 current, bound only at tt_27c.
* sim_timeout_s: 300

.include '/home/hive2/.cc/toolchains/iic-osic-tools-2026.09/foss/pdks/gf180mcuD/libs.tech/ngspice/design.spice'
.lib '/home/hive2/.cc/toolchains/iic-osic-tools-2026.09/foss/pdks/gf180mcuD/libs.tech/ngspice/sm141064.spice' typical
.lib '/home/hive2/.cc/toolchains/iic-osic-tools-2026.09/foss/pdks/gf180mcuD/libs.tech/ngspice/sm141064.spice' res_typical
.lib '/home/hive2/.cc/toolchains/iic-osic-tools-2026.09/foss/pdks/gf180mcuD/libs.tech/ngspice/sm141064.spice' mimcap_typical
* the loop filter's MOS caps: the PDK's cap_nmos_03v3_b (sm141064.spice, .lib
* moscap), written in charge form. The PDK's C(v) = A*(cvar1 + cvar2*tanh(cvar3*v
* + cvar4)) as a voltage-dependent C makes the transient step collapse ("timestep
* too small" on its current probe) at most corners on the extracted netlist;
* Q(v), its integral, is the same device and holds (pex tt_27c: Icp 18.52 vs
* 18.52 uA, Kvco 72.67 vs 72.66 MHz/V, fmax 203.31 vs 203.29 MHz against the
* PDK form under Gear). Its corner factor follows the MIM corner's
* (mim_corner_2p0ff: 1 / 1.1 ss / 0.9 ff, as moscap_<corner> sets it).
.param cap_nmos_03v3_b_corner=mim_corner_2p0ff
.subckt cap_nmos_03v3_b 1 2 c_length=1e-6 c_width=1e-6 dtemp=0
.param cvar1=0.002458 cvar2=0.001533 cvar3=1.515152 cvar4=0.560606
* ln(cosh(x)) written |x| + ln(1+exp(-2|x|)) - ln 2, the same function, as in
* spec/moscap.spice and layout_ref/: cosh overflowed on a wild Newton iterate
* ('Error: 1710.01 out of range for cosh', startup_tb tt_125c_vp10 with MP_HDM).
C1 1 2 q='cap_nmos_03v3_b_corner*c_length*c_width*(cvar1*v(1,2)+cvar2/cvar3*(abs(cvar3*v(1,2)+cvar4)+ln(1+exp(-2*abs(cvar3*v(1,2)+cvar4)))-ln(2)))'
.ends cap_nmos_03v3_b
.include '/home/hive2/wt/pll-pump/blocks/pll/analog/netlist/pll_analog.cir'
.param w_bp='4e-06' l_bp='2e-06' w_b1='2e-06' l_b1='2e-06' w_b2='4e-06' l_b2='1e-06' rb_l=0.000366 rbt_l=0.00018 w_cpn='4e-05' l_cpn='4e-06' w_cpp='1e-04' l_cpp='4e-06' w_swn='2e-06' w_swp='4e-06' l_sw='5e-07' r1_l=0.00015 c1_w=3.5e-05 c1_l=1.2e-05 c2_w=4.3e-05 c2_l=1.2e-05 w_v2i='1e-05' l_v2i='1e-06' rv2i_l=4.3e-05 w_flr='2e-06' l_flr='2e-06' w_v2ip='1e-05' w_v2in='4e-06' l_v2i2='5e-07' w_sp='1e-05' w_sn='4e-06' l_s='5e-07' w_rp='6e-06' w_rn='3e-06' l_r=2.8e-07 w_gp='4e-06' w_gn='4e-06' w_op=1.2e-05 w_on='6e-06' m_buft=4 w_bufp='2e-05' l_bufp='1e-06' w_bufn='1e-05' l_bufn='1e-06' w_bufln='4e-06' w_buflp='8e-06' l_bufl='2e-06' w_cl='5e-05' l_cl='1e-06'

.temp 125
.param vddp=3.63
.csparam vddp={vddp}
.csparam vhi={vddp-0.3}
.csparam vstp={(vddp-0.6)/48}

vdd_src  vdd      0 {vddp}
vss_src  vss      0 0
ven      pll_en   0 {vddp}
vup      pfd_up   0 0
vdn      pfd_dn   0 0
vt0      cp_trim0 0 0
vt1      cp_trim1 0 0
vvc      vctrl    0 {vddp/2}
cload2   vco_div2 0 30f
xdut vco_div2 pfd_up pfd_dn pll_en cp_trim0 cp_trim1 vctrl bias_ref vdd vss pll_analog

.control
set noaskquit
* --- UP current per trim code, vctrl = vdd/2
alter vup dc = $&vddp
op
let x = i(vvc)*1e6
set iu00 = "$&x"
alter vt0 dc = $&vddp
op
let x = i(vvc)*1e6
set iu01 = "$&x"
alter vt0 dc = 0
alter vt1 dc = $&vddp
op
let x = i(vvc)*1e6
set iu10 = "$&x"
alter vt0 dc = $&vddp
op
let x = i(vvc)*1e6
set iu11 = "$&x"
let x = $iu11 / $iu00
set rat = "$&x"
* --- DN current, code 00, vctrl = vdd/2
alter vt0 dc = 0
alter vt1 dc = 0
alter vup dc = 0
alter vdn dc = $&vddp
op
let x = -i(vvc)*1e6
set id00 = "$&x"
* --- UP/DN mismatch over the tuning range, code 00
alter vdn dc = 0
alter vup dc = $&vddp
dc vvc 0.3 $&vhi $&vstp
set pu = $curplot
let iupv = i(vvc)
alter vup dc = 0
alter vdn dc = $&vddp
dc vvc 0.3 $&vhi $&vstp
let idnv = -i(vvc)
let icpm = ($iu00 + $id00)/2
let x = vecmax(abs({$pu}.iupv - idnv))*1e6/icpm*100
set mm = "$&x"
* --- off leakage into vctrl, both inputs low, over the tuning range
alter vdn dc = 0
dc vvc 0.3 $&vhi $&vstp
let x = vecmax(abs(i(vvc)))*1e9
set lk = "$&x"
echo
echo "  Measurements for DC Analysis (pll_analog_cp_tb, computed in .control)"
echo "icp_up_code00_ua = $iu00"
echo "icp_dn_code00_ua = $id00"
echo "icp_up_code00_tt_ua = $iu00"
echo "icp_up_code01_ua = $iu01"
echo "icp_up_code10_ua = $iu10"
echo "icp_up_code11_ua = $iu11"
echo "icp_code11_over_code00_ratio = $rat"
echo "cp_updn_mismatch_pct = $mm"
echo "vctrl_leak_off_na = $lk"
echo
.endc

.end
