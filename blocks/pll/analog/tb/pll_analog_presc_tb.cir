* pll_analog_presc_tb.cir - prescaler-drive bench (spec.yaml:
* presc_div2_ratio, scored at ff_m40c_vp10 and tt_27c, so computed and printed
* only there: at ff_m40c_vp10 (process ff, -40 C, vdd above nominal) and at tt). Written from spec/.
*
* Since 2026-10-31 (issue #48) the first /2 is the macro's own /2 (TSPC until 2026-11-10,
* now a static master-slave flop):
* vco_div2 = vco_out / 2 is the clock the digital half takes. This bench
* checks that divider keeps up at the VCO's fastest corner: vctrl = vdd, the
* maximum VCO frequency, vco_div2 loaded by one inv_1 (the digital side's
* first gate) plus 30 fF of route, vco_out by 15 fF.
* presc_div2_ratio = f(vco_div2) / (f(vco_out)/2) = 2*T_vco/T_q, with T_vco the mean
* of 20 vco_out periods and T_q the mean of the 10 vco_div2 periods spanning them,
* both from rising vdd/2 crossings after 25 ns. The ring starts from its DC
* point within a few ns but can leave a runt pulse on vco_out near 22 ns
* (ff_m40c_vp10, 2026-10-31), which a 10 ns start counted as a VCO period and
* read the ratio 0.969 with the divider exact (7.52 ns = 2 x 3.76 ns). Two runs, the second only when the first is too
* short for 20 VCO periods: 40 ns at a 5 ps max step (fast VCO, >~ 730 MHz),
* then 130 ns at a 10 ps max step (down to ~190 MHz, under the 200 MHz
* fmax_ff floor). Fewer vco_div2 edges than 11 (a divider that cannot follow), or
* fewer VCO edges after both runs: the count ratio 2*nq/nv (as before).
* tt_27c (2026-11-02): bench_strength runs at tt only, so with the divider
* unscored there none of its devices could be seen (22 survivors). At tt
* the ratio is scored too, plus what moves when a divider device moves, all on
* vco_div2 at vctrl = vdd after 25 ns: presc_ckq_r_ns / presc_ckq_f_ns, vdd/2
* on the clocking vco_out rise to vdd/2 on vco_div2 (the vco_out edge just
* before it, so either start phase of the divider reads the same);
* presc_tr_ns / presc_tf_ns, 20-80 %; presc_duty_pct. One 130 ns run at 5 ps.
* At every other corner the bench runs a DC op only and prints nothing: these
* are not scored there, and a deck with no analysis at all reads to the gate
* as "no simulations run".
*
* Load cell netlist: the PDK's own libs.ref/.../spice/gf180mcu_fd_sc_mcu7t5v0.spice.
* Its nfet_05v0/pfet_05v0 devices resolve through sm141064.spice's own fets_mm
* section, which the {{CORNER}} section already pulls in.
* sim_timeout_s: 1800

.include '{{PDK}}/libs.tech/ngspice/design.spice'
.lib '{{PDK}}/libs.tech/ngspice/sm141064.spice' {{CORNER}}
.lib '{{PDK}}/libs.tech/ngspice/sm141064.spice' {{RES_CORNER}}
.lib '{{PDK}}/libs.tech/ngspice/sm141064.spice' {{MIM_CORNER}}
* the loop filter's MOS caps: the PDK's cap_nmos_03v3_b (sm141064.spice, .lib
* moscap), written in charge form. The PDK's C(v) = A*(cvar1 + cvar2*tanh(cvar3*v
* + cvar4)) as a voltage-dependent C makes the transient step collapse ("timestep
* too small" on its current probe) at most corners on the extracted netlist;
* Q(v), its integral, is the same device and holds (pex tt_27c: Icp 18.52 vs
* 18.52 uA, Kvco 72.67 vs 72.66 MHz/V, fmax 203.31 vs 203.29 MHz against the
* PDK form under Gear). Its corner factor follows the MIM corner's
* (mim_corner_2p0ff: 1 / 1.1 ss / 0.9 ff, as moscap_<corner> sets it).
.param cap_nmos_03v3_b_corner=mim_corner_2p0ff
.subckt cap_nmos_03v3_b 1 2 c_length=1e-6 c_width=1e-6 dtemp=0
.param cvar1=0.002458 cvar2=0.001533 cvar3=1.515152 cvar4=0.560606
* ln(cosh(x)) written |x| + ln(1+exp(-2|x|)) - ln 2, the same function, as in
* spec/moscap.spice and layout_ref/: cosh overflowed on a wild Newton iterate
* ('Error: 1710.01 out of range for cosh', startup_tb tt_125c_vp10 with MP_HDM).
C1 1 2 q='cap_nmos_03v3_b_corner*c_length*c_width*(cvar1*v(1,2)+cvar2/cvar3*(abs(cvar3*v(1,2)+cvar4)+ln(1+exp(-2*abs(cvar3*v(1,2)+cvar4)))-ln(2)))'
.ends cap_nmos_03v3_b
.include '{{NETLIST}}'
.include '{{PDK}}/libs.ref/gf180mcu_fd_sc_mcu7t5v0/spice/gf180mcu_fd_sc_mcu7t5v0.spice'
{{SIZING}}

.temp {{TEMP_C}}
.param vddp={{VDD}}
.param tempp={{TEMP_C}}
.param p_typical=1 p_ss=2 p_ff=3
.csparam procn={p_{{CORNER}}}
.csparam tempc={tempp}
.csparam vddp={vddp}
.csparam vmid={vddp/2}

vdd_src  vdd      0 {vddp}
vss_src  vss      0 0
ven      pll_en   0 {vddp}
vup      pfd_up   0 0
vdn      pfd_dn   0 0
vt0      cp_trim0 0 0
vt1      cp_trim1 0 0
vvc      vctrl    0 {vddp}
xdut q pfd_up pfd_dn pll_en cp_trim0 cp_trim1 vctrl bias_ref vdd vss pll_analog
xbuf  q nbuf   vdd vdd vss vss gf180mcu_fd_sc_mcu7t5v0__inv_1
cload2   q 0 30f

.control
set noaskquit
set okp = "0"
set okt = "0"
if (procn eq 3) and (tempc eq -40) and (vddp gt 3.4)
  foreach st 0 1
    if $okp eq 0
      if $st eq 0
        set tsx = "5p"
        set tex = "40n"
      end
      if $st eq 1
        set tsx = "10p"
        set tex = "130n"
      end
      tran $tsx $tex 0 $tsx
      let nx = length(time)
      let nx1 = nx - 1
      let nx2 = nx - 2
      let late = time[0,$&nx2] gt 25n
      let hv = (v(xdut.vco_out) gt vmid)
      let hq = (v(q) gt vmid)
      let nv = mean(((hv[1,$&nx1] - hv[0,$&nx2]) gt 0.5) and late)*length(late)
      let nq = mean(((hq[1,$&nx1] - hq[0,$&nx2]) gt 0.5) and late)*length(late)
      if (nv ge 22) and (nq ge 11)
        meas tran va when v(xdut.vco_out)=$&vmid rise=1 td=25n
        meas tran vb when v(xdut.vco_out)=$&vmid rise=21 td=25n
        meas tran qa when v(q)=$&vmid rise=1 td=$&va
        meas tran qb when v(q)=$&vmid rise=11 td=$&va
        let x = 2*((vb - va)/20)/((qb - qa)/10)
        set rat = "$&x"
        set okp = "1"
      else
        if (($st eq 1) or (nv ge 22)) and (nv ge 1)
          let x = 2*nq/nv
          set rat = "$&x"
          set okp = "1"
        end
      end
      destroy $curplot
    end
  end
else
  if (procn eq 1) and (tempc eq 27) and (vddp gt 3.2) and (vddp lt 3.4)
    tran 5p 130n 0 5p
    let nx = length(time)
    let nx1 = nx - 1
    let nx2 = nx - 2
    let late = time[0,$&nx2] gt 25n
    let hv = (v(xdut.vco_out) gt vmid)
    let hq = (v(q) gt vmid)
    let nv = mean(((hv[1,$&nx1] - hv[0,$&nx2]) gt 0.5) and late)*length(late)
    let nq = mean(((hq[1,$&nx1] - hq[0,$&nx2]) gt 0.5) and late)*length(late)
    if (nv ge 22) and (nq ge 11)
      meas tran va when v(xdut.vco_out)=$&vmid rise=1 td=25n
      meas tran vb when v(xdut.vco_out)=$&vmid rise=21 td=25n
      meas tran qa when v(q)=$&vmid rise=1 td=$&va
      meas tran qb when v(q)=$&vmid rise=11 td=$&va
      let tvco = (vb - va)/20
      let tq = (qb - qa)/10
      let x = 2*tvco/tq
      set rat = "$&x"
      set okp = "1"
      meas tran qf when v(q)=$&vmid fall=1 td=$&qa
      let tc = qa - tvco
      meas tran cr when v(xdut.vco_out)=$&vmid rise=1 td=$&tc
      let tc = qf - tvco
      meas tran cf when v(xdut.vco_out)=$&vmid rise=1 td=$&tc
      let vlo = 0.2*vddp
      let vhi = 0.8*vddp
      meas tran r20 when v(q)=$&vlo rise=1 td=$&qf
      meas tran r80 when v(q)=$&vhi rise=1 td=$&qf
      meas tran f80 when v(q)=$&vhi fall=1 td=$&qa
      meas tran f20 when v(q)=$&vlo fall=1 td=$&qa
      let xr = (qa - cr)*1e9
      let xf = (qf - cf)*1e9
      let xtr = (r80 - r20)*1e9
      let xtf = (f20 - f80)*1e9
      let xd = 100*(qf - qa)/tq
      set ckr = "$&xr"
      set ckf = "$&xf"
      set qtr = "$&xtr"
      set qtf = "$&xtf"
      set qd = "$&xd"
      set okt = "1"
    else
      if nv ge 1
        let x = 2*nq/nv
        set rat = "$&x"
        set okp = "1"
      end
    end
    destroy $curplot
  else
    op
  end
end
echo
echo "  Measurements for Transient Analysis (pll_analog_presc_tb, computed in .control)"
if $okp eq 1
  echo "presc_div2_ratio = $rat"
end
if $okt eq 1
  echo "presc_ckq_r_ns = $ckr"
  echo "presc_ckq_f_ns = $ckf"
  echo "presc_tr_ns = $qtr"
  echo "presc_tf_ns = $qtf"
  echo "presc_duty_pct = $qd"
end
echo
.endc

.end
