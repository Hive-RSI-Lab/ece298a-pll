* bias probe
.include '/opt/eda-toolchain/iic-osic-tools-2026.09/foss/pdks/gf180mcuD/libs.tech/ngspice/design.spice'
.lib '/opt/eda-toolchain/iic-osic-tools-2026.09/foss/pdks/gf180mcuD/libs.tech/ngspice/sm141064.spice' typical
.lib '/opt/eda-toolchain/iic-osic-tools-2026.09/foss/pdks/gf180mcuD/libs.tech/ngspice/sm141064.spice' res_typical
.lib '/opt/eda-toolchain/iic-osic-tools-2026.09/foss/pdks/gf180mcuD/libs.tech/ngspice/sm141064.spice' mimcap_typical
.include '/work/blocks/pll/analog/netlist/pll_analog.cir'
.param w_bp=4e-06 l_bp=2e-06 w_b1=2e-06 l_b1=2e-06 w_b2=4e-06 l_b2=1e-06 rb_l=0.000366 rbt_l=0.00018 w_cpn=2e-05 l_cpn=2e-06 w_cpp=5e-05 l_cpp=2e-06 w_swn=2e-06 w_swp=4e-06 l_sw=5e-07 r1_l=0.00015 c1_w=0.0001 c2_w=3.2e-05 w_v2i=1e-05 l_v2i=1e-06 rv2i_l=3.5e-05 w_flr=2e-06 l_flr=2e-06 w_v2ip=1e-05 w_v2in=4e-06 l_v2i2=5e-07 w_sp=1e-05 w_sn=4e-06 l_s=5e-07 w_rp=6e-06 w_rn=3e-06 l_r=2.8e-07 w_gp=4e-06 w_gn=4e-06 w_op=1.2e-05 w_on=6e-06 m_buft=4 w_bufp=2e-05 l_bufp=1e-06 w_bufn=1e-05 l_bufn=1e-06 w_bufln=4e-06 w_buflp=8e-06 l_bufl=2e-06 w_cl=4e-05 l_cl=2e-06
.temp 27
vdd_src vdd 0 3.3
vss_src vss 0 0
ven pll_en 0 pwl(0 0 300n 0 301n 3.3)
vup pfd_up 0 0
vdn pfd_dn 0 0
vt0 cp_trim0 0 0
vt1 cp_trim1 0 0
vvc vctrl 0 1.7
cload vco_out 0 15f
xdut vco_out pfd_up pfd_dn pll_en cp_trim0 cp_trim1 vctrl bias_ref vdd vss pll_analog
.control
set noaskquit
tran 50p 3u 0 50p
meas tran vmin min v(xdut.vref) from=2u to=3u
meas tran vmax max v(xdut.vref) from=2u to=3u
meas tran ta when v(vco_out)=1.65 rise=2 td=2u
meas tran tb when v(vco_out)=1.65 rise=42 td=2u
let f=40/(tb-ta)
echo "RES $&vmin $&vmax $&f"
.endc
.end
