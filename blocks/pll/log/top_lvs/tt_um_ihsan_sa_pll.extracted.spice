* NGSPICE file created from tt_um_ihsan_sa_pll.ext - technology: gf180mcuD

.subckt gf180mcu_fd_sc_mcu7t5v0__fillcap_32 VDD VNW VPW VSS
X0 VDD a_572_375# a_484_472# VNW pfet_05v0 ad=0.5368p pd=3.32u as=0.5368p ps=3.32u w=1.22u l=1u
X1 VDD a_2364_375# a_2276_472# VNW pfet_05v0 ad=0.5368p pd=3.32u as=0.5368p ps=3.32u w=1.22u l=1u
X2 a_572_375# a_484_472# VSS VPW nfet_05v0 ad=0.3608p pd=2.52u as=0.3608p ps=2.52u w=0.82u l=1u
X3 VDD a_1916_375# a_1828_472# VNW pfet_05v0 ad=0.5368p pd=3.32u as=0.5368p ps=3.32u w=1.22u l=1u
X4 a_124_375# a_36_472# VSS VPW nfet_05v0 ad=0.3608p pd=2.52u as=0.3608p ps=2.52u w=0.82u l=1u
X5 a_1916_375# a_1828_472# VSS VPW nfet_05v0 ad=0.3608p pd=2.52u as=0.3608p ps=2.52u w=0.82u l=1u
X6 a_1468_375# a_1380_472# VSS VPW nfet_05v0 ad=0.3608p pd=2.52u as=0.3608p ps=2.52u w=0.82u l=1u
X7 a_2812_375# a_2724_472# VSS VPW nfet_05v0 ad=0.3608p pd=2.52u as=0.3608p ps=2.52u w=0.82u l=1u
X8 VDD a_3260_375# a_3172_472# VNW pfet_05v0 ad=0.5368p pd=3.32u as=0.5368p ps=3.32u w=1.22u l=1u
X9 a_2364_375# a_2276_472# VSS VPW nfet_05v0 ad=0.3608p pd=2.52u as=0.3608p ps=2.52u w=0.82u l=1u
X10 VDD a_2812_375# a_2724_472# VNW pfet_05v0 ad=0.5368p pd=3.32u as=0.5368p ps=3.32u w=1.22u l=1u
X11 a_3260_375# a_3172_472# VSS VPW nfet_05v0 ad=0.3608p pd=2.52u as=0.3608p ps=2.52u w=0.82u l=1u
X12 VDD a_1020_375# a_932_472# VNW pfet_05v0 ad=0.5368p pd=3.32u as=0.5368p ps=3.32u w=1.22u l=1u
X13 VDD a_1468_375# a_1380_472# VNW pfet_05v0 ad=0.5368p pd=3.32u as=0.5368p ps=3.32u w=1.22u l=1u
X14 VDD a_124_375# a_36_472# VNW pfet_05v0 ad=0.5368p pd=3.32u as=0.5368p ps=3.32u w=1.22u l=1u
X15 a_1020_375# a_932_472# VSS VPW nfet_05v0 ad=0.3608p pd=2.52u as=0.3608p ps=2.52u w=0.82u l=1u
.ends

.subckt gf180mcu_fd_sc_mcu7t5v0__fillcap_64 VDD VNW VPW VSS
X0 a_4604_375# a_4516_472# VSS VPW nfet_05v0 ad=0.3608p pd=2.52u as=0.3608p ps=2.52u w=0.82u l=1u
X1 VDD a_572_375# a_484_472# VNW pfet_05v0 ad=0.5368p pd=3.32u as=0.5368p ps=3.32u w=1.22u l=1u
X2 VDD a_2364_375# a_2276_472# VNW pfet_05v0 ad=0.5368p pd=3.32u as=0.5368p ps=3.32u w=1.22u l=1u
X3 a_4156_375# a_4068_472# VSS VPW nfet_05v0 ad=0.3608p pd=2.52u as=0.3608p ps=2.52u w=0.82u l=1u
X4 a_5500_375# a_5412_472# VSS VPW nfet_05v0 ad=0.3608p pd=2.52u as=0.3608p ps=2.52u w=0.82u l=1u
X5 a_572_375# a_484_472# VSS VPW nfet_05v0 ad=0.3608p pd=2.52u as=0.3608p ps=2.52u w=0.82u l=1u
X6 VDD a_5052_375# a_4964_472# VNW pfet_05v0 ad=0.5368p pd=3.32u as=0.5368p ps=3.32u w=1.22u l=1u
X7 VDD a_6844_375# a_6756_472# VNW pfet_05v0 ad=0.5368p pd=3.32u as=0.5368p ps=3.32u w=1.22u l=1u
X8 VDD a_1916_375# a_1828_472# VNW pfet_05v0 ad=0.5368p pd=3.32u as=0.5368p ps=3.32u w=1.22u l=1u
X9 a_124_375# a_36_472# VSS VPW nfet_05v0 ad=0.3608p pd=2.52u as=0.3608p ps=2.52u w=0.82u l=1u
X10 a_5052_375# a_4964_472# VSS VPW nfet_05v0 ad=0.3608p pd=2.52u as=0.3608p ps=2.52u w=0.82u l=1u
X11 a_1916_375# a_1828_472# VSS VPW nfet_05v0 ad=0.3608p pd=2.52u as=0.3608p ps=2.52u w=0.82u l=1u
X12 VDD a_4604_375# a_4516_472# VNW pfet_05v0 ad=0.5368p pd=3.32u as=0.5368p ps=3.32u w=1.22u l=1u
X13 a_1468_375# a_1380_472# VSS VPW nfet_05v0 ad=0.3608p pd=2.52u as=0.3608p ps=2.52u w=0.82u l=1u
X14 a_2812_375# a_2724_472# VSS VPW nfet_05v0 ad=0.3608p pd=2.52u as=0.3608p ps=2.52u w=0.82u l=1u
X15 VDD a_3260_375# a_3172_472# VNW pfet_05v0 ad=0.5368p pd=3.32u as=0.5368p ps=3.32u w=1.22u l=1u
X16 a_2364_375# a_2276_472# VSS VPW nfet_05v0 ad=0.3608p pd=2.52u as=0.3608p ps=2.52u w=0.82u l=1u
X17 a_5948_375# a_5860_472# VSS VPW nfet_05v0 ad=0.3608p pd=2.52u as=0.3608p ps=2.52u w=0.82u l=1u
X18 VDD a_2812_375# a_2724_472# VNW pfet_05v0 ad=0.5368p pd=3.32u as=0.5368p ps=3.32u w=1.22u l=1u
X19 a_3260_375# a_3172_472# VSS VPW nfet_05v0 ad=0.3608p pd=2.52u as=0.3608p ps=2.52u w=0.82u l=1u
X20 VDD a_1020_375# a_932_472# VNW pfet_05v0 ad=0.5368p pd=3.32u as=0.5368p ps=3.32u w=1.22u l=1u
X21 VDD a_5500_375# a_5412_472# VNW pfet_05v0 ad=0.5368p pd=3.32u as=0.5368p ps=3.32u w=1.22u l=1u
X22 a_6844_375# a_6756_472# VSS VPW nfet_05v0 ad=0.3608p pd=2.52u as=0.3608p ps=2.52u w=0.82u l=1u
X23 a_6396_375# a_6308_472# VSS VPW nfet_05v0 ad=0.3608p pd=2.52u as=0.3608p ps=2.52u w=0.82u l=1u
X24 VDD a_6396_375# a_6308_472# VNW pfet_05v0 ad=0.5368p pd=3.32u as=0.5368p ps=3.32u w=1.22u l=1u
X25 VDD a_1468_375# a_1380_472# VNW pfet_05v0 ad=0.5368p pd=3.32u as=0.5368p ps=3.32u w=1.22u l=1u
X26 VDD a_4156_375# a_4068_472# VNW pfet_05v0 ad=0.5368p pd=3.32u as=0.5368p ps=3.32u w=1.22u l=1u
X27 VDD a_5948_375# a_5860_472# VNW pfet_05v0 ad=0.5368p pd=3.32u as=0.5368p ps=3.32u w=1.22u l=1u
X28 VDD a_124_375# a_36_472# VNW pfet_05v0 ad=0.5368p pd=3.32u as=0.5368p ps=3.32u w=1.22u l=1u
X29 a_3708_375# a_3620_472# VSS VPW nfet_05v0 ad=0.3608p pd=2.52u as=0.3608p ps=2.52u w=0.82u l=1u
X30 VDD a_3708_375# a_3620_472# VNW pfet_05v0 ad=0.5368p pd=3.32u as=0.5368p ps=3.32u w=1.22u l=1u
X31 a_1020_375# a_932_472# VSS VPW nfet_05v0 ad=0.3608p pd=2.52u as=0.3608p ps=2.52u w=0.82u l=1u
.ends

.subckt gf180mcu_fd_sc_mcu7t5v0__fillcap_4 VDD VNW VPW VSS
X0 a_124_375# a_36_472# VSS VPW nfet_05v0 ad=0.3608p pd=2.52u as=0.3608p ps=2.52u w=0.82u l=1u
X1 VDD a_124_375# a_36_472# VNW pfet_05v0 ad=0.5368p pd=3.32u as=0.5368p ps=3.32u w=1.22u l=1u
.ends

.subckt gf180mcu_fd_sc_mcu7t5v0__fillcap_8 VDD VNW VPW VSS
X0 VDD a_572_375# a_484_472# VNW pfet_05v0 ad=0.5368p pd=3.32u as=0.5368p ps=3.32u w=1.22u l=1u
X1 a_572_375# a_484_472# VSS VPW nfet_05v0 ad=0.3608p pd=2.52u as=0.3608p ps=2.52u w=0.82u l=1u
X2 a_124_375# a_36_472# VSS VPW nfet_05v0 ad=0.3608p pd=2.52u as=0.3608p ps=2.52u w=0.82u l=1u
X3 VDD a_124_375# a_36_472# VNW pfet_05v0 ad=0.5368p pd=3.32u as=0.5368p ps=3.32u w=1.22u l=1u
.ends

.subckt gf180mcu_fd_sc_mcu7t5v0__aoi21_1 A1 A2 B ZN VDD VNW VPW VSS
X0 a_244_68# A2 VSS VPW nfet_05v0 ad=0.1312p pd=1.14u as=0.3608p ps=2.52u w=0.82u l=0.6u
X1 ZN A1 a_244_68# VPW nfet_05v0 ad=0.2569p pd=1.56u as=0.1312p ps=1.14u w=0.82u l=0.6u
X2 VDD B a_36_472# VNW pfet_05v0 ad=0.5346p pd=3.31u as=0.44955p ps=1.955u w=1.215u l=0.5u
X3 ZN A2 a_36_472# VNW pfet_05v0 ad=0.3159p pd=1.735u as=0.5346p ps=3.31u w=1.215u l=0.5u
X4 a_36_472# A1 ZN VNW pfet_05v0 ad=0.44955p pd=1.955u as=0.3159p ps=1.735u w=1.215u l=0.5u
X5 VSS B ZN VPW nfet_05v0 ad=0.2244p pd=1.9u as=0.2569p ps=1.56u w=0.51u l=0.6u
.ends

.subckt gf180mcu_fd_sc_mcu7t5v0__fillcap_16 VDD VNW VPW VSS
X0 VDD a_572_375# a_484_472# VNW pfet_05v0 ad=0.5368p pd=3.32u as=0.5368p ps=3.32u w=1.22u l=1u
X1 a_572_375# a_484_472# VSS VPW nfet_05v0 ad=0.3608p pd=2.52u as=0.3608p ps=2.52u w=0.82u l=1u
X2 a_124_375# a_36_472# VSS VPW nfet_05v0 ad=0.3608p pd=2.52u as=0.3608p ps=2.52u w=0.82u l=1u
X3 a_1468_375# a_1380_472# VSS VPW nfet_05v0 ad=0.3608p pd=2.52u as=0.3608p ps=2.52u w=0.82u l=1u
X4 VDD a_1020_375# a_932_472# VNW pfet_05v0 ad=0.5368p pd=3.32u as=0.5368p ps=3.32u w=1.22u l=1u
X5 VDD a_1468_375# a_1380_472# VNW pfet_05v0 ad=0.5368p pd=3.32u as=0.5368p ps=3.32u w=1.22u l=1u
X6 VDD a_124_375# a_36_472# VNW pfet_05v0 ad=0.5368p pd=3.32u as=0.5368p ps=3.32u w=1.22u l=1u
X7 a_1020_375# a_932_472# VSS VPW nfet_05v0 ad=0.3608p pd=2.52u as=0.3608p ps=2.52u w=0.82u l=1u
.ends

.subckt gf180mcu_fd_sc_mcu7t5v0__tiel ZN VDD VNW VPW VSS
X0 ZN a_124_24# VSS VPW nfet_05v0 ad=0.3608p pd=2.52u as=0.3608p ps=2.52u w=0.82u l=0.6u
X1 a_124_24# a_124_24# VDD VNW pfet_05v0 ad=0.5368p pd=3.32u as=0.5368p ps=3.32u w=1.22u l=0.5u
.ends

.subckt gf180mcu_fd_sc_mcu7t5v0__oai21_1 A1 A2 B ZN VDD VNW VPW VSS
X0 VSS B a_36_68# VPW nfet_05v0 ad=0.3608p pd=2.52u as=0.2132p ps=1.34u w=0.82u l=0.6u
X1 ZN A2 a_36_68# VPW nfet_05v0 ad=0.2132p pd=1.34u as=0.3608p ps=2.52u w=0.82u l=0.6u
X2 VDD B ZN VNW pfet_05v0 ad=0.4972p pd=3.14u as=0.4248p ps=1.94u w=1.13u l=0.5u
X3 a_244_472# A2 VDD VNW pfet_05v0 ad=0.3172p pd=1.74u as=0.5978p ps=3.42u w=1.22u l=0.5u
X4 ZN A1 a_244_472# VNW pfet_05v0 ad=0.4248p pd=1.94u as=0.3172p ps=1.74u w=1.22u l=0.5u
X5 a_36_68# A1 ZN VPW nfet_05v0 ad=0.2132p pd=1.34u as=0.2132p ps=1.34u w=0.82u l=0.6u
.ends

.subckt gf180mcu_fd_sc_mcu7t5v0__clkbuf_8 I Z VDD VNW VPW VSS
X0 Z a_224_552# VSS VPW nfet_05v0 ad=0.1118p pd=0.95u as=0.1892p ps=1.74u w=0.43u l=0.6u
X1 VSS a_224_552# Z VPW nfet_05v0 ad=0.1118p pd=0.95u as=0.1118p ps=0.95u w=0.43u l=0.6u
X2 VDD a_224_552# Z VNW pfet_05v0 ad=0.3172p pd=1.74u as=0.4392p ps=1.94u w=1.22u l=0.5u
X3 a_224_552# I VDD VNW pfet_05v0 ad=0.2952p pd=1.54u as=0.3608p ps=2.52u w=0.82u l=0.5u
X4 VDD I a_224_552# VNW pfet_05v0 ad=0.2132p pd=1.34u as=0.2952p ps=1.54u w=0.82u l=0.5u
X5 Z a_224_552# VDD VNW pfet_05v0 ad=0.4392p pd=1.94u as=0.3172p ps=1.74u w=1.22u l=0.5u
X6 VDD a_224_552# Z VNW pfet_05v0 ad=0.3172p pd=1.74u as=0.4392p ps=1.94u w=1.22u l=0.5u
X7 VSS I a_224_552# VPW nfet_05v0 ad=0.1053p pd=0.925u as=0.1053p ps=0.925u w=0.405u l=0.6u
X8 a_224_552# I VDD VNW pfet_05v0 ad=0.2952p pd=1.54u as=0.2132p ps=1.34u w=0.82u l=0.5u
X9 VDD a_224_552# Z VNW pfet_05v0 ad=0.3172p pd=1.74u as=0.4392p ps=1.94u w=1.22u l=0.5u
X10 VSS a_224_552# Z VPW nfet_05v0 ad=0.1892p pd=1.74u as=0.1118p ps=0.95u w=0.43u l=0.6u
X11 Z a_224_552# VDD VNW pfet_05v0 ad=0.4392p pd=1.94u as=0.3172p ps=1.74u w=1.22u l=0.5u
X12 Z a_224_552# VSS VPW nfet_05v0 ad=0.1118p pd=0.95u as=0.1118p ps=0.95u w=0.43u l=0.6u
X13 VSS a_224_552# Z VPW nfet_05v0 ad=0.1118p pd=0.95u as=0.1118p ps=0.95u w=0.43u l=0.6u
X14 Z a_224_552# VSS VPW nfet_05v0 ad=0.1118p pd=0.95u as=0.1118p ps=0.95u w=0.43u l=0.6u
X15 Z a_224_552# VDD VNW pfet_05v0 ad=0.4392p pd=1.94u as=0.3172p ps=1.74u w=1.22u l=0.5u
X16 VDD I a_224_552# VNW pfet_05v0 ad=0.367p pd=1.92u as=0.2952p ps=1.54u w=0.82u l=0.5u
X17 VDD a_224_552# Z VNW pfet_05v0 ad=0.5368p pd=3.32u as=0.4392p ps=1.94u w=1.22u l=0.5u
X18 a_224_552# I VSS VPW nfet_05v0 ad=0.1053p pd=0.925u as=0.1782p ps=1.69u w=0.405u l=0.6u
X19 Z a_224_552# VSS VPW nfet_05v0 ad=0.1118p pd=0.95u as=0.1118p ps=0.95u w=0.43u l=0.6u
X20 Z a_224_552# VDD VNW pfet_05v0 ad=0.4392p pd=1.94u as=0.367p ps=1.92u w=1.22u l=0.5u
X21 a_224_552# I VSS VPW nfet_05v0 ad=0.1782p pd=1.69u as=0.1053p ps=0.925u w=0.405u l=0.6u
X22 VSS a_224_552# Z VPW nfet_05v0 ad=0.1118p pd=0.95u as=0.1118p ps=0.95u w=0.43u l=0.6u
.ends

.subckt gf180mcu_fd_sc_mcu7t5v0__clkinv_1 I ZN VDD VNW VPW VSS
X0 ZN I VSS VPW nfet_05v0 ad=0.2112p pd=1.84u as=0.2112p ps=1.84u w=0.48u l=0.6u
X1 ZN I VDD VNW pfet_05v0 ad=0.5368p pd=3.32u as=0.5368p ps=3.32u w=1.22u l=0.5u
.ends

.subckt gf180mcu_fd_sc_mcu7t5v0__buf_1 I Z VDD VNW VPW VSS
X0 Z a_36_160# VSS VPW nfet_05v0 ad=0.3608p pd=2.52u as=0.2344p ps=1.56u w=0.82u l=0.6u
X1 Z a_36_160# VDD VNW pfet_05v0 ad=0.5368p pd=3.32u as=0.35315p ps=1.96u w=1.22u l=0.5u
X2 VDD I a_36_160# VNW pfet_05v0 ad=0.35315p pd=1.96u as=0.2486p ps=2.01u w=0.565u l=0.5u
X3 VSS I a_36_160# VPW nfet_05v0 ad=0.2344p pd=1.56u as=0.1584p ps=1.6u w=0.36u l=0.6u
.ends

.subckt gf180mcu_fd_sc_mcu7t5v0__clkbuf_1 I Z VDD VNW VPW VSS
X0 VDD I a_36_113# VNW pfet_05v0 ad=0.4015p pd=1.92u as=0.462p ps=2.98u w=1.05u l=0.5u
X1 Z a_36_113# VDD VNW pfet_05v0 ad=0.5368p pd=3.32u as=0.4015p ps=1.92u w=1.22u l=0.5u
X2 Z a_36_113# VSS VPW nfet_05v0 ad=0.2178p pd=1.87u as=0.153p ps=1.195u w=0.495u l=0.6u
X3 VSS I a_36_113# VPW nfet_05v0 ad=0.153p pd=1.195u as=0.1584p ps=1.6u w=0.36u l=0.6u
.ends

.subckt gf180mcu_fd_sc_mcu7t5v0__clkbuf_2 I Z VDD VNW VPW VSS
X0 VDD I a_36_160# VNW pfet_05v0 ad=0.458p pd=2.02u as=0.4488p ps=2.92u w=1.02u l=0.5u
X1 VSS I a_36_160# VPW nfet_05v0 ad=0.151p pd=1.185u as=0.1584p ps=1.6u w=0.36u l=0.6u
X2 VDD a_36_160# Z VNW pfet_05v0 ad=0.5368p pd=3.32u as=0.3782p ps=1.84u w=1.22u l=0.5u
X3 Z a_36_160# VDD VNW pfet_05v0 ad=0.3782p pd=1.84u as=0.458p ps=2.02u w=1.22u l=0.5u
X4 VSS a_36_160# Z VPW nfet_05v0 ad=0.2134p pd=1.85u as=0.1261p ps=1.005u w=0.485u l=0.6u
X5 Z a_36_160# VSS VPW nfet_05v0 ad=0.1261p pd=1.005u as=0.151p ps=1.185u w=0.485u l=0.6u
.ends

.subckt gf180mcu_fd_sc_mcu7t5v0__dlyb_1 I Z VDD VNW VPW VSS
X0 a_523_68# a_47_68# VSS VPW nfet_05v0 ad=43.2f pd=0.6u as=93.59999f ps=0.88u w=0.36u l=0.6u
X1 a_671_644# a_47_68# a_523_68# VPW nfet_05v0 ad=0.369p pd=2.77u as=43.2f ps=0.6u w=0.36u l=0.6u
X2 a_503_644# a_47_68# VDD VNW pfet_05v0 ad=61.19999f pd=0.7u as=0.1116p ps=0.98u w=0.36u l=0.5u
X3 VDD a_671_644# a_1127_622# VNW pfet_05v0 ad=0.379p pd=2.37u as=61.19999f ps=0.7u w=0.36u l=0.5u
X4 VDD I a_47_68# VNW pfet_05v0 ad=0.1116p pd=0.98u as=0.3852p ps=2.86u w=0.36u l=0.5u
X5 Z a_895_68# VSS VPW nfet_05v0 ad=0.3608p pd=2.52u as=0.28262p ps=1.87u w=0.82u l=0.6u
X6 a_1147_68# a_671_644# a_895_68# VPW nfet_05v0 ad=43.8f pd=0.605u as=0.3705p ps=2.77u w=0.365u l=0.6u
X7 a_1127_622# a_671_644# a_895_68# VNW pfet_05v0 ad=61.19999f pd=0.7u as=0.3456p ps=2.64u w=0.36u l=0.5u
X8 VSS a_671_644# a_1147_68# VPW nfet_05v0 ad=0.28262p pd=1.87u as=43.8f ps=0.605u w=0.365u l=0.6u
X9 a_671_644# a_47_68# a_503_644# VNW pfet_05v0 ad=0.3852p pd=2.86u as=61.19999f ps=0.7u w=0.36u l=0.5u
X10 VSS I a_47_68# VPW nfet_05v0 ad=93.59999f pd=0.88u as=0.333p ps=2.57u w=0.36u l=0.6u
X11 Z a_895_68# VDD VNW pfet_05v0 ad=0.5368p pd=3.32u as=0.379p ps=2.37u w=1.22u l=0.5u
.ends

.subckt gf180mcu_fd_sc_mcu7t5v0__nor2_1 A1 A2 ZN VDD VNW VPW VSS
X0 ZN A1 a_224_472# VNW pfet_05v0 ad=0.5368p pd=3.32u as=0.4087p ps=1.89u w=1.22u l=0.5u
X1 VSS A1 ZN VPW nfet_05v0 ad=0.2486p pd=2.01u as=0.1469p ps=1.085u w=0.565u l=0.6u
X2 a_224_472# A2 VDD VNW pfet_05v0 ad=0.4087p pd=1.89u as=0.5368p ps=3.32u w=1.22u l=0.5u
X3 ZN A2 VSS VPW nfet_05v0 ad=0.1469p pd=1.085u as=0.2486p ps=2.01u w=0.565u l=0.6u
.ends

.subckt gf180mcu_fd_sc_mcu7t5v0__tieh Z VDD VNW VPW VSS
X0 Z a_125_24# VDD VNW pfet_05v0 ad=0.5368p pd=3.32u as=0.5368p ps=3.32u w=1.22u l=0.5u
X1 a_125_24# a_125_24# VSS VPW nfet_05v0 ad=0.3608p pd=2.52u as=0.3608p ps=2.52u w=0.82u l=0.6u
.ends

.subckt gf180mcu_fd_sc_mcu7t5v0__dffnrnq_1 D RN CLKN Q VDD VNW VPW VSS
X0 a_1228_476# a_448_472# a_1024_476# VNW pfet_05v0 ad=0.2432p pd=1.4u as=0.1976p ps=1.28u w=0.76u l=0.5u
X1 a_1228_476# RN VDD VNW pfet_05v0 ad=0.3344p pd=2.4u as=0.3936p ps=1.88u w=0.76u l=0.5u
X2 a_1356_112# a_1024_476# VDD VNW pfet_05v0 ad=0.17927p pd=1.215u as=0.2222p ps=1.89u w=0.505u l=0.5u
X3 a_1024_476# a_448_472# a_820_476# VPW nfet_05v0 ad=0.1209p pd=1.01u as=0.1014p ps=0.91u w=0.39u l=0.6u
X4 VDD a_2682_301# a_2563_527# VNW pfet_05v0 ad=0.28255p pd=1.68u as=0.15022p ps=1.1u w=0.505u l=0.5u
X5 a_2682_301# RN VDD VNW pfet_05v0 ad=0.376p pd=1.74u as=0.28255p ps=1.68u w=0.94u l=0.5u
X6 a_1304_156# a_36_124# a_1024_476# VPW nfet_05v0 ad=50.7f pd=0.65u as=0.1209p ps=1.01u w=0.39u l=0.6u
X7 Q a_2682_301# VSS VPW nfet_05v0 ad=0.3498p pd=2.47u as=0.3498p ps=2.47u w=0.795u l=0.6u
X8 VDD a_1356_112# a_1228_476# VNW pfet_05v0 ad=0.3936p pd=1.88u as=0.2432p ps=1.4u w=0.76u l=0.5u
X9 a_2563_527# a_448_472# a_2268_156# VPW nfet_05v0 ad=0.1014p pd=0.91u as=0.20985p ps=1.475u w=0.39u l=0.6u
X10 VDD CLKN a_36_124# VNW pfet_05v0 ad=0.2249p pd=1.385u as=0.3806p ps=2.61u w=0.865u l=0.5u
X11 a_448_472# a_36_124# VDD VNW pfet_05v0 ad=0.3806p pd=2.61u as=0.2249p ps=1.385u w=0.865u l=0.5u
X12 a_2563_527# a_36_124# a_2268_156# VNW pfet_05v0 ad=0.15022p pd=1.1u as=0.1578p ps=1.13u w=0.505u l=0.5u
X13 a_820_476# D VSS VPW nfet_05v0 ad=0.1014p pd=0.91u as=0.1716p ps=1.66u w=0.39u l=0.6u
X14 a_448_472# a_36_124# VSS VPW nfet_05v0 ad=0.1782p pd=1.69u as=0.1053p ps=0.925u w=0.405u l=0.6u
X15 Q a_2682_301# VDD VNW pfet_05v0 ad=0.517p pd=3.23u as=0.517p ps=3.23u w=1.175u l=0.5u
X16 VSS RN a_1476_156# VPW nfet_05v0 ad=0.216p pd=1.51u as=46.8f ps=0.63u w=0.39u l=0.6u
X17 a_2682_301# a_2268_156# a_3030_156# VPW nfet_05v0 ad=0.176p pd=1.68u as=0.1385p ps=1.1u w=0.4u l=0.6u
X18 a_820_476# D VDD VNW pfet_05v0 ad=0.1976p pd=1.28u as=0.3344p ps=2.4u w=0.76u l=0.5u
X19 a_3030_156# RN VSS VPW nfet_05v0 ad=0.1385p pd=1.1u as=0.1014p ps=0.91u w=0.39u l=0.6u
X20 a_2268_156# a_36_124# a_1356_112# VPW nfet_05v0 ad=0.20985p pd=1.475u as=0.2079p ps=1.465u w=0.39u l=0.6u
X21 a_2268_156# a_448_472# a_1356_112# VNW pfet_05v0 ad=0.1578p pd=1.13u as=0.17927p ps=1.215u w=0.505u l=0.5u
X22 a_1476_156# a_1356_112# a_1304_156# VPW nfet_05v0 ad=46.8f pd=0.63u as=50.7f ps=0.65u w=0.39u l=0.6u
X23 a_1024_476# a_36_124# a_820_476# VNW pfet_05v0 ad=0.1976p pd=1.28u as=0.1976p ps=1.28u w=0.76u l=0.5u
X24 a_1356_112# a_1024_476# VSS VPW nfet_05v0 ad=0.2079p pd=1.465u as=0.216p ps=1.51u w=0.39u l=0.6u
X25 VDD a_2268_156# a_2682_301# VNW pfet_05v0 ad=0.4136p pd=2.76u as=0.376p ps=1.74u w=0.94u l=0.5u
X26 VSS a_2682_301# a_2563_527# VPW nfet_05v0 ad=0.1014p pd=0.91u as=0.1014p ps=0.91u w=0.39u l=0.6u
X27 VSS CLKN a_36_124# VPW nfet_05v0 ad=0.1053p pd=0.925u as=0.1782p ps=1.69u w=0.405u l=0.6u
.ends

.subckt gf180mcu_fd_sc_mcu7t5v0__dffrnq_1 D RN CLK Q VDD VNW VPW VSS
X0 VSS CLK a_36_151# VPW nfet_05v0 ad=0.1053p pd=0.925u as=0.1782p ps=1.69u w=0.405u l=0.6u
X1 VSS RN a_1456_156# VPW nfet_05v0 ad=0.2016p pd=1.48u as=43.2f ps=0.6u w=0.36u l=0.6u
X2 Q a_2665_112# VDD VNW pfet_05v0 ad=0.5346p pd=3.31u as=0.5346p ps=3.31u w=1.215u l=0.5u
X3 a_796_472# D VSS VPW nfet_05v0 ad=93.59999f pd=0.88u as=0.1584p ps=1.6u w=0.36u l=0.6u
X4 VSS a_2665_112# a_2560_156# VPW nfet_05v0 ad=0.1224p pd=1.04u as=94.5f ps=0.885u w=0.36u l=0.6u
X5 a_2665_112# a_2248_156# a_3041_156# VPW nfet_05v0 ad=0.176p pd=1.68u as=0.134p ps=1.1u w=0.4u l=0.6u
X6 a_1000_472# a_448_472# a_796_472# VNW pfet_05v0 ad=0.2028p pd=1.3u as=0.2028p ps=1.3u w=0.78u l=0.5u
X7 a_2248_156# a_36_151# a_1308_423# VNW pfet_05v0 ad=0.25375p pd=1.51u as=0.2424p ps=1.465u w=0.505u l=0.5u
X8 a_2248_156# a_448_472# a_1308_423# VPW nfet_05v0 ad=0.2007p pd=1.475u as=0.2007p ps=1.475u w=0.36u l=0.6u
X9 VDD CLK a_36_151# VNW pfet_05v0 ad=0.2249p pd=1.385u as=0.3806p ps=2.61u w=0.865u l=0.5u
X10 a_1456_156# a_1308_423# a_1288_156# VPW nfet_05v0 ad=43.2f pd=0.6u as=43.2f ps=0.6u w=0.36u l=0.6u
X11 a_1308_423# a_1000_472# VSS VPW nfet_05v0 ad=0.2007p pd=1.475u as=0.2016p ps=1.48u w=0.36u l=0.6u
X12 Q a_2665_112# VSS VPW nfet_05v0 ad=0.3586p pd=2.51u as=0.3586p ps=2.51u w=0.815u l=0.6u
X13 a_448_472# a_36_151# VDD VNW pfet_05v0 ad=0.3806p pd=2.61u as=0.2249p ps=1.385u w=0.865u l=0.5u
X14 a_1204_472# a_36_151# a_1000_472# VNW pfet_05v0 ad=0.2028p pd=1.3u as=0.2028p ps=1.3u w=0.78u l=0.5u
X15 a_1204_472# RN VDD VNW pfet_05v0 ad=0.3432p pd=2.44u as=0.45p ps=2.02u w=0.78u l=0.5u
X16 a_2665_112# RN VDD VNW pfet_05v0 ad=0.26p pd=1.52u as=0.29465p ps=1.74u w=1u l=0.5u
X17 a_2560_156# a_36_151# a_2248_156# VPW nfet_05v0 ad=94.5f pd=0.885u as=0.2007p ps=1.475u w=0.36u l=0.6u
X18 VDD a_2248_156# a_2665_112# VNW pfet_05v0 ad=0.44p pd=2.88u as=0.26p ps=1.52u w=1u l=0.5u
X19 a_1288_156# a_448_472# a_1000_472# VPW nfet_05v0 ad=43.2f pd=0.6u as=93.59999f ps=0.88u w=0.36u l=0.6u
X20 VDD a_1308_423# a_1204_472# VNW pfet_05v0 ad=0.45p pd=2.02u as=0.2028p ps=1.3u w=0.78u l=0.5u
X21 a_2560_156# a_448_472# a_2248_156# VNW pfet_05v0 ad=0.1313p pd=1.025u as=0.25375p ps=1.51u w=0.505u l=0.5u
X22 a_448_472# a_36_151# VSS VPW nfet_05v0 ad=0.1782p pd=1.69u as=0.1053p ps=0.925u w=0.405u l=0.6u
X23 a_3041_156# RN VSS VPW nfet_05v0 ad=0.134p pd=1.1u as=0.1224p ps=1.04u w=0.36u l=0.6u
X24 VDD a_2665_112# a_2560_156# VNW pfet_05v0 ad=0.29465p pd=1.74u as=0.1313p ps=1.025u w=0.505u l=0.5u
X25 a_1308_423# a_1000_472# VDD VNW pfet_05v0 ad=0.2424p pd=1.465u as=0.2222p ps=1.89u w=0.505u l=0.5u
X26 a_1000_472# a_36_151# a_796_472# VPW nfet_05v0 ad=93.59999f pd=0.88u as=93.59999f ps=0.88u w=0.36u l=0.6u
X27 a_796_472# D VDD VNW pfet_05v0 ad=0.2028p pd=1.3u as=0.3432p ps=2.44u w=0.78u l=0.5u
.ends

.subckt gf180mcu_fd_sc_mcu7t5v0__dlya_1 I Z VDD VNW VPW VSS
X0 VSS a_448_495# a_608_472# VPW nfet_05v0 ad=0.23275p pd=1.56u as=0.1584p ps=1.6u w=0.36u l=0.6u
X1 Z a_608_472# VSS VPW nfet_05v0 ad=0.3608p pd=2.52u as=0.23275p ps=1.56u w=0.82u l=0.6u
X2 a_448_495# a_36_126# VSS VPW nfet_05v0 ad=0.1584p pd=1.6u as=93.59999f ps=0.88u w=0.36u l=0.6u
X3 VDD I a_36_126# VNW pfet_05v0 ad=0.1116p pd=0.98u as=0.1584p ps=1.6u w=0.36u l=0.5u
X4 VSS I a_36_126# VPW nfet_05v0 ad=93.59999f pd=0.88u as=0.1584p ps=1.6u w=0.36u l=0.6u
X5 VDD a_448_495# a_608_472# VNW pfet_05v0 ad=0.3971p pd=2.16u as=0.1944p ps=1.8u w=0.36u l=0.5u
X6 Z a_608_472# VDD VNW pfet_05v0 ad=0.5368p pd=3.32u as=0.3971p ps=2.16u w=1.22u l=0.5u
X7 a_448_495# a_36_126# VDD VNW pfet_05v0 ad=0.1584p pd=1.6u as=0.1116p ps=0.98u w=0.36u l=0.5u
.ends

.subckt gf180mcu_fd_sc_mcu7t5v0__xor2_1 A1 A2 Z VDD VNW VPW VSS
X0 a_728_472# a_56_604# VDD VNW pfet_05v0 ad=0.3172p pd=1.74u as=0.4005p ps=2.12u w=1.22u l=0.5u
X1 Z A1 a_728_472# VNW pfet_05v0 ad=0.3172p pd=1.74u as=0.3172p ps=1.74u w=1.22u l=0.5u
X2 VSS A1 a_56_604# VPW nfet_05v0 ad=0.218p pd=1.52u as=93.59999f ps=0.88u w=0.36u l=0.6u
X3 a_728_472# A2 Z VNW pfet_05v0 ad=0.5368p pd=3.32u as=0.3172p ps=1.74u w=1.22u l=0.5u
X4 Z a_56_604# VSS VPW nfet_05v0 ad=0.2132p pd=1.34u as=0.218p ps=1.52u w=0.82u l=0.6u
X5 VSS A2 a_952_68# VPW nfet_05v0 ad=0.3608p pd=2.52u as=0.1312p ps=1.14u w=0.82u l=0.6u
X6 a_244_604# A2 a_56_604# VNW pfet_05v0 ad=0.1456p pd=1.08u as=0.2464p ps=2u w=0.56u l=0.5u
X7 a_56_604# A2 VSS VPW nfet_05v0 ad=93.59999f pd=0.88u as=0.1584p ps=1.6u w=0.36u l=0.6u
X8 a_952_68# A1 Z VPW nfet_05v0 ad=0.1312p pd=1.14u as=0.2132p ps=1.34u w=0.82u l=0.6u
X9 VDD A1 a_244_604# VNW pfet_05v0 ad=0.4005p pd=2.12u as=0.1456p ps=1.08u w=0.56u l=0.5u
.ends

.subckt gf180mcu_fd_sc_mcu7t5v0__clkbuf_4 I Z VDD VNW VPW VSS
X0 Z a_224_552# VSS VPW nfet_05v0 ad=0.1183p pd=0.975u as=0.1183p ps=0.975u w=0.455u l=0.6u
X1 VDD a_224_552# Z VNW pfet_05v0 ad=0.3782p pd=1.84u as=0.3782p ps=1.84u w=1.22u l=0.5u
X2 a_224_552# I VDD VNW pfet_05v0 ad=0.2542p pd=1.44u as=0.3608p ps=2.52u w=0.82u l=0.5u
X3 a_224_552# I VSS VPW nfet_05v0 ad=0.2662p pd=2.09u as=0.2662p ps=2.09u w=0.605u l=0.6u
X4 VSS a_224_552# Z VPW nfet_05v0 ad=0.1183p pd=0.975u as=0.1183p ps=0.975u w=0.455u l=0.6u
X5 VDD a_224_552# Z VNW pfet_05v0 ad=0.5368p pd=3.32u as=0.3782p ps=1.84u w=1.22u l=0.5u
X6 VSS a_224_552# Z VPW nfet_05v0 ad=0.2002p pd=1.79u as=0.1183p ps=0.975u w=0.455u l=0.6u
X7 Z a_224_552# VDD VNW pfet_05v0 ad=0.3782p pd=1.84u as=0.428p ps=2.02u w=1.22u l=0.5u
X8 Z a_224_552# VSS VPW nfet_05v0 ad=0.1183p pd=0.975u as=0.2002p ps=1.79u w=0.455u l=0.6u
X9 VDD I a_224_552# VNW pfet_05v0 ad=0.428p pd=2.02u as=0.2542p ps=1.44u w=0.82u l=0.5u
X10 Z a_224_552# VDD VNW pfet_05v0 ad=0.3782p pd=1.84u as=0.3782p ps=1.84u w=1.22u l=0.5u
.ends

.subckt gf180mcu_fd_sc_mcu7t5v0__and4_1 A1 A2 A3 A4 Z VDD VNW VPW VSS
X0 a_48_148# A1 VDD VNW pfet_05v0 ad=0.156p pd=1.12u as=0.264p ps=2.08u w=0.6u l=0.5u
X1 a_440_148# A2 a_256_148# VPW nfet_05v0 ad=88.2f pd=0.84u as=67.2f ps=0.74u w=0.42u l=0.6u
X2 Z a_48_148# VSS VPW nfet_05v0 ad=0.3586p pd=2.51u as=0.226p ps=1.515u w=0.815u l=0.6u
X3 VDD A2 a_48_148# VNW pfet_05v0 ad=0.156p pd=1.12u as=0.156p ps=1.12u w=0.6u l=0.5u
X4 Z a_48_148# VDD VNW pfet_05v0 ad=0.5368p pd=3.32u as=0.395p ps=2.02u w=1.22u l=0.5u
X5 a_644_148# A3 a_440_148# VPW nfet_05v0 ad=88.2f pd=0.84u as=88.2f ps=0.84u w=0.42u l=0.6u
X6 a_48_148# A3 VDD VNW pfet_05v0 ad=0.156p pd=1.12u as=0.156p ps=1.12u w=0.6u l=0.5u
X7 VSS A4 a_644_148# VPW nfet_05v0 ad=0.226p pd=1.515u as=88.2f ps=0.84u w=0.42u l=0.6u
X8 VDD A4 a_48_148# VNW pfet_05v0 ad=0.395p pd=2.02u as=0.156p ps=1.12u w=0.6u l=0.5u
X9 a_256_148# A1 a_48_148# VPW nfet_05v0 ad=67.2f pd=0.74u as=0.1848p ps=1.72u w=0.42u l=0.6u
.ends

.subckt gf180mcu_fd_sc_mcu7t5v0__and3_1 A1 A2 A3 Z VDD VNW VPW VSS
X0 Z a_36_148# VDD VNW pfet_05v0 ad=0.5346p pd=3.31u as=0.4268p ps=2.175u w=1.215u l=0.5u
X1 a_428_148# A2 a_244_148# VPW nfet_05v0 ad=79.8f pd=0.8u as=60.8f ps=0.7u w=0.38u l=0.6u
X2 Z a_36_148# VSS VPW nfet_05v0 ad=0.341p pd=2.43u as=0.2424p ps=1.635u w=0.775u l=0.6u
X3 VSS A3 a_428_148# VPW nfet_05v0 ad=0.2424p pd=1.635u as=79.8f ps=0.8u w=0.38u l=0.6u
X4 a_244_148# A1 a_36_148# VPW nfet_05v0 ad=60.8f pd=0.7u as=0.1672p ps=1.64u w=0.38u l=0.6u
X5 VDD A1 a_36_148# VNW pfet_05v0 ad=0.1391p pd=1.055u as=0.2354p ps=1.95u w=0.535u l=0.5u
X6 a_36_148# A2 VDD VNW pfet_05v0 ad=0.1391p pd=1.055u as=0.1391p ps=1.055u w=0.535u l=0.5u
X7 VDD A3 a_36_148# VNW pfet_05v0 ad=0.4268p pd=2.175u as=0.1391p ps=1.055u w=0.535u l=0.5u
.ends

.subckt gf180mcu_fd_sc_mcu7t5v0__nor3_1 A1 A2 A3 ZN VDD VNW VPW VSS
X0 ZN A1 a_448_472# VNW pfet_05v0 ad=0.5368p pd=3.32u as=0.3782p ps=1.84u w=1.22u l=0.5u
X1 ZN A1 VSS VPW nfet_05v0 ad=0.2046p pd=1.81u as=0.1209p ps=0.985u w=0.465u l=0.6u
X2 a_244_472# A3 VDD VNW pfet_05v0 ad=0.3172p pd=1.74u as=0.5368p ps=3.32u w=1.22u l=0.5u
X3 a_448_472# A2 a_244_472# VNW pfet_05v0 ad=0.3782p pd=1.84u as=0.3172p ps=1.74u w=1.22u l=0.5u
X4 VSS A2 ZN VPW nfet_05v0 ad=0.1209p pd=0.985u as=0.1209p ps=0.985u w=0.465u l=0.6u
X5 ZN A3 VSS VPW nfet_05v0 ad=0.1209p pd=0.985u as=0.2046p ps=1.81u w=0.465u l=0.6u
.ends

.subckt gf180mcu_fd_sc_mcu7t5v0__nand2_1 A1 A2 ZN VDD VNW VPW VSS
X0 ZN A2 VDD VNW pfet_05v0 ad=0.2938p pd=1.65u as=0.4972p ps=3.14u w=1.13u l=0.5u
X1 ZN A1 a_245_68# VPW nfet_05v0 ad=0.3608p pd=2.52u as=0.1312p ps=1.14u w=0.82u l=0.6u
X2 VDD A1 ZN VNW pfet_05v0 ad=0.4972p pd=3.14u as=0.2938p ps=1.65u w=1.13u l=0.5u
X3 a_245_68# A2 VSS VPW nfet_05v0 ad=0.1312p pd=1.14u as=0.3608p ps=2.52u w=0.82u l=0.6u
.ends

.subckt gf180mcu_fd_sc_mcu7t5v0__dffnsnq_1 D SETN CLKN Q VDD VNW VPW VSS
X0 a_1308_156# a_36_124# a_1044_472# VPW nfet_05v0 ad=45.6f pd=0.62u as=98.8f ps=0.9u w=0.38u l=0.6u
X1 a_2384_156# a_36_124# a_2160_156# VNW pfet_05v0 ad=0.286p pd=2.18u as=0.21025p ps=1.35u w=0.65u l=0.5u
X2 a_2384_156# SETN VDD VNW pfet_05v0 ad=0.26825p pd=1.68u as=0.3102p ps=2.29u w=0.705u l=0.5u
X3 a_1248_472# a_448_472# a_1044_472# VNW pfet_05v0 ad=72.59999f pd=0.845u as=0.1573p ps=1.125u w=0.605u l=0.5u
X4 VDD a_3148_126# a_2384_156# VNW pfet_05v0 ad=0.2427p pd=1.435u as=0.26825p ps=1.68u w=0.58u l=0.5u
X5 VDD a_1296_336# a_1248_472# VNW pfet_05v0 ad=0.38775p pd=2.135u as=72.59999f ps=0.845u w=0.605u l=0.5u
X6 a_840_156# D VSS VPW nfet_05v0 ad=0.1178p pd=1u as=0.1672p ps=1.64u w=0.38u l=0.6u
X7 a_2384_156# a_448_472# a_2160_156# VPW nfet_05v0 ad=0.1672p pd=1.64u as=98.8f ps=0.9u w=0.38u l=0.6u
X8 a_1044_472# a_448_472# a_840_156# VPW nfet_05v0 ad=98.8f pd=0.9u as=0.1178p ps=1u w=0.38u l=0.6u
X9 VDD CLKN a_36_124# VNW pfet_05v0 ad=0.2444p pd=1.46u as=0.4136p ps=2.76u w=0.94u l=0.5u
X10 a_1296_336# SETN a_1708_156# VPW nfet_05v0 ad=98.8f pd=0.9u as=0.1026p ps=0.92u w=0.38u l=0.6u
X11 a_2160_156# a_448_472# a_1296_336# VNW pfet_05v0 ad=0.21025p pd=1.35u as=0.2354p ps=1.95u w=0.535u l=0.5u
X12 a_3148_126# a_2160_156# VSS VPW nfet_05v0 ad=0.165p pd=1.63u as=0.129p ps=1.115u w=0.375u l=0.6u
X13 a_448_472# a_36_124# VDD VNW pfet_05v0 ad=0.4136p pd=2.76u as=0.2444p ps=1.46u w=0.94u l=0.5u
X14 a_448_472# a_36_124# VSS VPW nfet_05v0 ad=0.2376p pd=1.96u as=0.1404p ps=1.06u w=0.54u l=0.6u
X15 a_3148_126# a_2160_156# VDD VNW pfet_05v0 ad=0.2882p pd=2.19u as=0.2427p ps=1.435u w=0.655u l=0.5u
X16 a_3008_145# SETN a_2384_156# VPW nfet_05v0 ad=0.1335p pd=1.135u as=0.1914p ps=1.75u w=0.435u l=0.6u
X17 a_2160_156# a_36_124# a_1296_336# VPW nfet_05v0 ad=98.8f pd=0.9u as=98.8f ps=0.9u w=0.38u l=0.6u
X18 VSS a_1296_336# a_1308_156# VPW nfet_05v0 ad=0.1064p pd=0.94u as=45.6f ps=0.62u w=0.38u l=0.6u
X19 a_1708_156# a_1044_472# VSS VPW nfet_05v0 ad=0.1026p pd=0.92u as=0.1064p ps=0.94u w=0.38u l=0.6u
X20 Q a_3148_126# VSS VPW nfet_05v0 ad=0.3586p pd=2.51u as=0.3586p ps=2.51u w=0.815u l=0.6u
X21 a_840_156# D VDD VNW pfet_05v0 ad=0.1573p pd=1.125u as=0.5199p ps=3.2u w=0.605u l=0.5u
X22 VDD SETN a_1296_336# VNW pfet_05v0 ad=0.2772p pd=2.14u as=0.23515p ps=1.615u w=0.63u l=0.5u
X23 Q a_3148_126# VDD VNW pfet_05v0 ad=0.5346p pd=3.31u as=0.5346p ps=3.31u w=1.215u l=0.5u
X24 VSS a_3148_126# a_3008_145# VPW nfet_05v0 ad=0.129p pd=1.115u as=0.1335p ps=1.135u w=0.31u l=0.6u
X25 a_1296_336# a_1044_472# VDD VNW pfet_05v0 ad=0.23515p pd=1.615u as=0.38775p ps=2.135u w=0.57u l=0.5u
X26 a_1044_472# a_36_124# a_840_156# VNW pfet_05v0 ad=0.1573p pd=1.125u as=0.1573p ps=1.125u w=0.605u l=0.5u
X27 VSS CLKN a_36_124# VPW nfet_05v0 ad=0.1404p pd=1.06u as=0.2376p ps=1.96u w=0.54u l=0.6u
.ends

.subckt gf180mcu_fd_sc_mcu7t5v0__buf_2 I Z VDD VNW VPW VSS
X0 Z a_36_68# VDD VNW pfet_05v0 ad=0.3782p pd=1.84u as=0.4941p ps=2.03u w=1.22u l=0.5u
X1 VSS I a_36_68# VPW nfet_05v0 ad=0.2911p pd=1.53u as=0.3608p ps=2.52u w=0.82u l=0.6u
X2 Z a_36_68# VSS VPW nfet_05v0 ad=0.2132p pd=1.34u as=0.2911p ps=1.53u w=0.82u l=0.6u
X3 VDD I a_36_68# VNW pfet_05v0 ad=0.4941p pd=2.03u as=0.5368p ps=3.32u w=1.22u l=0.5u
X4 VSS a_36_68# Z VPW nfet_05v0 ad=0.3608p pd=2.52u as=0.2132p ps=1.34u w=0.82u l=0.6u
X5 VDD a_36_68# Z VNW pfet_05v0 ad=0.5368p pd=3.32u as=0.3782p ps=1.84u w=1.22u l=0.5u
.ends

.subckt gf180mcu_fd_sc_mcu7t5v0__nand3_1 A1 A2 A3 ZN VDD VNW VPW VSS
X0 ZN A1 a_455_68# VPW nfet_05v0 ad=0.3608p pd=2.52u as=0.1722p ps=1.24u w=0.82u l=0.6u
X1 ZN A3 VDD VNW pfet_05v0 ad=0.2561p pd=1.505u as=0.4334p ps=2.85u w=0.985u l=0.5u
X2 VDD A2 ZN VNW pfet_05v0 ad=0.2561p pd=1.505u as=0.2561p ps=1.505u w=0.985u l=0.5u
X3 ZN A1 VDD VNW pfet_05v0 ad=0.4334p pd=2.85u as=0.2561p ps=1.505u w=0.985u l=0.5u
X4 a_271_68# A3 VSS VPW nfet_05v0 ad=0.1312p pd=1.14u as=0.3608p ps=2.52u w=0.82u l=0.6u
X5 a_455_68# A2 a_271_68# VPW nfet_05v0 ad=0.1722p pd=1.24u as=0.1312p ps=1.14u w=0.82u l=0.6u
.ends

.subckt gf180mcu_fd_sc_mcu7t5v0__and2_1 A1 A2 Z VDD VNW VPW VSS
X0 VDD A2 a_36_159# VNW pfet_05v0 ad=0.40575p pd=2.055u as=0.156p ps=1.12u w=0.6u l=0.5u
X1 Z a_36_159# VDD VNW pfet_05v0 ad=0.5346p pd=3.31u as=0.40575p ps=2.055u w=1.215u l=0.5u
X2 Z a_36_159# VSS VPW nfet_05v0 ad=0.3586p pd=2.51u as=0.23405p ps=1.555u w=0.815u l=0.6u
X3 VSS A2 a_244_159# VPW nfet_05v0 ad=0.23405p pd=1.555u as=58.39999f ps=0.685u w=0.365u l=0.6u
X4 a_244_159# A1 a_36_159# VPW nfet_05v0 ad=58.39999f pd=0.685u as=0.1606p ps=1.61u w=0.365u l=0.6u
X5 a_36_159# A1 VDD VNW pfet_05v0 ad=0.156p pd=1.12u as=0.264p ps=2.08u w=0.6u l=0.5u
.ends

.subckt gf180mcu_fd_sc_mcu7t5v0__oai31_2 A1 A2 A3 B ZN VDD VNW VPW VSS
X0 VDD A3 a_1612_497# VNW pfet_05v0 ad=0.4818p pd=3.07u as=0.4599p ps=1.935u w=1.095u l=0.5u
X1 a_960_497# A2 a_692_497# VNW pfet_05v0 ad=0.33945p pd=1.715u as=0.4599p ps=1.935u w=1.095u l=0.5u
X2 ZN A3 a_36_68# VPW nfet_05v0 ad=0.30965p pd=1.685u as=0.2132p ps=1.34u w=0.82u l=0.6u
X3 VSS B a_36_68# VPW nfet_05v0 ad=0.2132p pd=1.34u as=0.3608p ps=2.52u w=0.82u l=0.6u
X4 a_36_68# A3 ZN VPW nfet_05v0 ad=0.3608p pd=2.52u as=0.30965p ps=1.685u w=0.82u l=0.6u
X5 a_36_68# A2 ZN VPW nfet_05v0 ad=0.2132p pd=1.34u as=0.30965p ps=1.685u w=0.82u l=0.6u
X6 ZN B VDD VNW pfet_05v0 ad=0.2808p pd=1.6u as=0.5292p ps=3.14u w=1.08u l=0.5u
X7 a_36_68# A1 ZN VPW nfet_05v0 ad=0.2132p pd=1.34u as=0.2132p ps=1.34u w=0.82u l=0.6u
X8 a_692_497# A3 VDD VNW pfet_05v0 ad=0.4599p pd=1.935u as=0.3918p ps=1.815u w=1.095u l=0.5u
X9 VDD B ZN VNW pfet_05v0 ad=0.3918p pd=1.815u as=0.2808p ps=1.6u w=1.08u l=0.5u
X10 a_1612_497# A2 a_1388_497# VNW pfet_05v0 ad=0.4599p pd=1.935u as=0.33945p ps=1.715u w=1.095u l=0.5u
X11 ZN A2 a_36_68# VPW nfet_05v0 ad=0.30965p pd=1.685u as=0.2132p ps=1.34u w=0.82u l=0.6u
X12 ZN A1 a_960_497# VNW pfet_05v0 ad=0.2847p pd=1.615u as=0.33945p ps=1.715u w=1.095u l=0.5u
X13 a_36_68# B VSS VPW nfet_05v0 ad=0.2132p pd=1.34u as=0.2132p ps=1.34u w=0.82u l=0.6u
X14 ZN A1 a_36_68# VPW nfet_05v0 ad=0.2132p pd=1.34u as=0.2132p ps=1.34u w=0.82u l=0.6u
X15 a_1388_497# A1 ZN VNW pfet_05v0 ad=0.33945p pd=1.715u as=0.2847p ps=1.615u w=1.095u l=0.5u
.ends

.subckt gf180mcu_fd_sc_mcu7t5v0__dffrnq_2 D RN CLK Q VDD VNW VPW VSS
X0 VSS CLK a_36_151# VPW nfet_05v0 ad=0.1053p pd=0.925u as=0.1782p ps=1.69u w=0.405u l=0.6u
X1 Q a_2665_112# VDD VNW pfet_05v0 ad=0.3159p pd=1.735u as=0.5346p ps=3.31u w=1.215u l=0.5u
X2 VSS RN a_1456_156# VPW nfet_05v0 ad=0.2016p pd=1.48u as=43.2f ps=0.6u w=0.36u l=0.6u
X3 VDD a_2665_112# Q VNW pfet_05v0 ad=0.5346p pd=3.31u as=0.3159p ps=1.735u w=1.215u l=0.5u
X4 a_796_472# D VSS VPW nfet_05v0 ad=93.59999f pd=0.88u as=0.1584p ps=1.6u w=0.36u l=0.6u
X5 VSS a_2665_112# a_2560_156# VPW nfet_05v0 ad=0.1224p pd=1.04u as=94.5f ps=0.885u w=0.36u l=0.6u
X6 a_1000_472# a_448_472# a_796_472# VNW pfet_05v0 ad=0.2028p pd=1.3u as=0.2028p ps=1.3u w=0.78u l=0.5u
X7 a_2248_156# a_36_151# a_1308_423# VNW pfet_05v0 ad=0.25375p pd=1.51u as=0.2424p ps=1.465u w=0.505u l=0.5u
X8 a_2248_156# a_448_472# a_1308_423# VPW nfet_05v0 ad=0.2007p pd=1.475u as=0.2007p ps=1.475u w=0.36u l=0.6u
X9 VDD CLK a_36_151# VNW pfet_05v0 ad=0.2249p pd=1.385u as=0.3806p ps=2.61u w=0.865u l=0.5u
X10 a_1456_156# a_1308_423# a_1288_156# VPW nfet_05v0 ad=43.2f pd=0.6u as=43.2f ps=0.6u w=0.36u l=0.6u
X11 a_1308_423# a_1000_472# VSS VPW nfet_05v0 ad=0.2007p pd=1.475u as=0.2016p ps=1.48u w=0.36u l=0.6u
X12 Q a_2665_112# VSS VPW nfet_05v0 ad=0.2119p pd=1.335u as=0.3586p ps=2.51u w=0.815u l=0.6u
X13 a_2665_112# a_2248_156# a_3041_156# VPW nfet_05v0 ad=0.3586p pd=2.51u as=0.217p ps=1.515u w=0.815u l=0.6u
X14 a_448_472# a_36_151# VDD VNW pfet_05v0 ad=0.3806p pd=2.61u as=0.2249p ps=1.385u w=0.865u l=0.5u
X15 a_1204_472# a_36_151# a_1000_472# VNW pfet_05v0 ad=0.2028p pd=1.3u as=0.2028p ps=1.3u w=0.78u l=0.5u
X16 a_1204_472# RN VDD VNW pfet_05v0 ad=0.3432p pd=2.44u as=0.45p ps=2.02u w=0.78u l=0.5u
X17 a_2560_156# a_36_151# a_2248_156# VPW nfet_05v0 ad=94.5f pd=0.885u as=0.2007p ps=1.475u w=0.36u l=0.6u
X18 a_1288_156# a_448_472# a_1000_472# VPW nfet_05v0 ad=43.2f pd=0.6u as=93.59999f ps=0.88u w=0.36u l=0.6u
X19 a_2665_112# RN VDD VNW pfet_05v0 ad=0.3159p pd=1.735u as=0.33755p ps=1.955u w=1.215u l=0.5u
X20 VDD a_1308_423# a_1204_472# VNW pfet_05v0 ad=0.45p pd=2.02u as=0.2028p ps=1.3u w=0.78u l=0.5u
X21 a_2560_156# a_448_472# a_2248_156# VNW pfet_05v0 ad=0.1313p pd=1.025u as=0.25375p ps=1.51u w=0.505u l=0.5u
X22 a_448_472# a_36_151# VSS VPW nfet_05v0 ad=0.1782p pd=1.69u as=0.1053p ps=0.925u w=0.405u l=0.6u
X23 VDD a_2248_156# a_2665_112# VNW pfet_05v0 ad=0.5346p pd=3.31u as=0.3159p ps=1.735u w=1.215u l=0.5u
X24 a_3041_156# RN VSS VPW nfet_05v0 ad=0.217p pd=1.515u as=0.1224p ps=1.04u w=0.36u l=0.6u
X25 VSS a_2665_112# Q VPW nfet_05v0 ad=0.3586p pd=2.51u as=0.2119p ps=1.335u w=0.815u l=0.6u
X26 VDD a_2665_112# a_2560_156# VNW pfet_05v0 ad=0.33755p pd=1.955u as=0.1313p ps=1.025u w=0.505u l=0.5u
X27 a_1308_423# a_1000_472# VDD VNW pfet_05v0 ad=0.2424p pd=1.465u as=0.2222p ps=1.89u w=0.505u l=0.5u
X28 a_1000_472# a_36_151# a_796_472# VPW nfet_05v0 ad=93.59999f pd=0.88u as=93.59999f ps=0.88u w=0.36u l=0.6u
X29 a_796_472# D VDD VNW pfet_05v0 ad=0.2028p pd=1.3u as=0.3432p ps=2.44u w=0.78u l=0.5u
.ends

.subckt gf180mcu_fd_sc_mcu7t5v0__or2_1 A1 A2 Z VDD VNW VPW VSS
X0 a_255_603# A1 a_67_603# VNW pfet_05v0 ad=0.1469p pd=1.085u as=0.2486p ps=2.01u w=0.565u l=0.5u
X1 Z a_67_603# VSS VPW nfet_05v0 ad=0.3608p pd=2.52u as=0.2288p ps=1.58u w=0.82u l=0.6u
X2 VDD A2 a_255_603# VNW pfet_05v0 ad=0.38705p pd=2.08u as=0.1469p ps=1.085u w=0.565u l=0.5u
X3 VSS A2 a_67_603# VPW nfet_05v0 ad=0.2288p pd=1.58u as=93.59999f ps=0.88u w=0.36u l=0.6u
X4 Z a_67_603# VDD VNW pfet_05v0 ad=0.5368p pd=3.32u as=0.38705p ps=2.08u w=1.22u l=0.5u
X5 a_67_603# A1 VSS VPW nfet_05v0 ad=93.59999f pd=0.88u as=0.1584p ps=1.6u w=0.36u l=0.6u
.ends

.subckt gf180mcu_fd_sc_mcu7t5v0__nor4_2 A1 A2 A3 A4 ZN VDD VNW VPW VSS
X0 VSS A3 ZN VPW nfet_05v0 ad=0.126p pd=1.06u as=0.126p ps=1.06u w=0.36u l=0.6u
X1 a_1213_472# A2 a_943_472# VNW pfet_05v0 ad=0.3477p pd=1.79u as=0.5185p ps=2.07u w=1.22u l=0.5u
X2 VSS A2 ZN VPW nfet_05v0 ad=0.1584p pd=1.6u as=93.59999f ps=0.88u w=0.36u l=0.6u
X3 a_943_472# A3 a_683_472# VNW pfet_05v0 ad=0.5185p pd=2.07u as=0.488p ps=2.02u w=1.22u l=0.5u
X4 VSS A1 ZN VPW nfet_05v0 ad=93.59999f pd=0.88u as=93.59999f ps=0.88u w=0.36u l=0.6u
X5 a_1661_472# A1 ZN VNW pfet_05v0 ad=0.3172p pd=1.74u as=0.4087p ps=1.89u w=1.22u l=0.5u
X6 VSS A4 ZN VPW nfet_05v0 ad=93.59999f pd=0.88u as=93.59999f ps=0.88u w=0.36u l=0.6u
X7 a_57_472# A2 a_1661_472# VNW pfet_05v0 ad=0.5368p pd=3.32u as=0.3172p ps=1.74u w=1.22u l=0.5u
X8 ZN A1 VSS VPW nfet_05v0 ad=93.59999f pd=0.88u as=93.59999f ps=0.88u w=0.36u l=0.6u
X9 VDD A4 a_245_472# VNW pfet_05v0 ad=0.3782p pd=1.84u as=0.3477p ps=1.79u w=1.22u l=0.5u
X10 ZN A2 VSS VPW nfet_05v0 ad=93.59999f pd=0.88u as=0.126p ps=1.06u w=0.36u l=0.6u
X11 ZN A4 VSS VPW nfet_05v0 ad=0.126p pd=1.06u as=93.59999f ps=0.88u w=0.36u l=0.6u
X12 a_245_472# A3 a_57_472# VNW pfet_05v0 ad=0.3477p pd=1.79u as=0.5368p ps=3.32u w=1.22u l=0.5u
X13 ZN A3 VSS VPW nfet_05v0 ad=93.59999f pd=0.88u as=0.1584p ps=1.6u w=0.36u l=0.6u
X14 ZN A1 a_1213_472# VNW pfet_05v0 ad=0.4087p pd=1.89u as=0.3477p ps=1.79u w=1.22u l=0.5u
X15 a_683_472# A4 VDD VNW pfet_05v0 ad=0.488p pd=2.02u as=0.3782p ps=1.84u w=1.22u l=0.5u
.ends

.subckt gf180mcu_fd_sc_mcu7t5v0__oai31_1 A1 A2 A3 B ZN VDD VNW VPW VSS
X0 a_468_497# A1 ZN VNW pfet_05v0 ad=0.58035p pd=2.155u as=0.4012p ps=1.85u w=1.095u l=0.5u
X1 a_244_69# A2 ZN VPW nfet_05v0 ad=0.2119p pd=1.335u as=0.4137p ps=1.9u w=0.815u l=0.6u
X2 a_780_497# A2 a_468_497# VNW pfet_05v0 ad=0.2847p pd=1.615u as=0.58035p ps=2.155u w=1.095u l=0.5u
X3 ZN A1 a_244_69# VPW nfet_05v0 ad=0.4137p pd=1.9u as=0.2119p ps=1.335u w=0.815u l=0.6u
X4 VDD A3 a_780_497# VNW pfet_05v0 ad=0.5913p pd=3.27u as=0.2847p ps=1.615u w=1.095u l=0.5u
X5 a_244_69# B VSS VPW nfet_05v0 ad=0.2119p pd=1.335u as=0.3586p ps=2.51u w=0.815u l=0.6u
X6 ZN B VDD VNW pfet_05v0 ad=0.4012p pd=1.85u as=0.4972p ps=3.14u w=1.13u l=0.5u
X7 ZN A3 a_244_69# VPW nfet_05v0 ad=0.3586p pd=2.51u as=0.2119p ps=1.335u w=0.815u l=0.6u
.ends

.subckt gf180mcu_fd_sc_mcu7t5v0__inv_1 I ZN VDD VNW VPW VSS
X0 ZN I VSS VPW nfet_05v0 ad=0.3608p pd=2.52u as=0.3608p ps=2.52u w=0.82u l=0.6u
X1 ZN I VDD VNW pfet_05v0 ad=0.5368p pd=3.32u as=0.5368p ps=3.32u w=1.22u l=0.5u
.ends

.subckt pll_analog vco_out pfd_up pfd_dn pll_en cp_trim0 cp_trim1 vctrl bias_ref vdd
+ vss
X0 vbh vbh vdd vdd pfet_03v3 ad=2.6p pd=9.3u as=2.6p ps=9.3u w=4u l=2u
X1 up_b pfd_up vdd vdd pfet_03v3 ad=1.3p pd=5.3u as=1.3p ps=5.3u w=2u l=0.28u
X2 vcp_n vbp vdd vdd pfet_03v3 ad=2.6p pd=9.3u as=2.6p ps=9.3u w=4u l=2u
X3 vctrl pfd_dn dn_s vss nfet_03v3 ad=1.22p pd=5.22u as=1.22p ps=5.22u w=2u l=0.5u
X4 r3 r2 a_18360_3004# vdd pfet_03v3 ad=0.78p pd=3.52u as=1.95p ps=7.3u w=3u l=0.28u
X5 t1a vbp vdd vdd pfet_03v3 ad=2.6p pd=9.3u as=2.6p ps=9.3u w=4u l=2u
X6 vcp_n vbp vdd vdd pfet_03v3 ad=2.6p pd=9.3u as=2.6p ps=9.3u w=4u l=2u
X7 a_8020_18650# a_8620_12518# vss ppolyf_u r_width=1u r_length=30u
X8 a_21100_1860# r4 r5 vss nfet_03v3 ad=0.915p pd=4.22u as=0.39p ps=2.02u w=1.5u l=0.28u
X9 a_19728_3004# r3 r4 vdd pfet_03v3 ad=1.95p pd=7.3u as=0.78p ps=3.52u w=3u l=0.28u
X10 vcl vref vss vss nfet_03v3 ad=6.1p pd=21.22u as=6.1p ps=21.22u w=10u l=2u
X11 vcp_p vcp_n vss vss nfet_03v3 ad=6.1p pd=21.22u as=6.1p ps=21.22u w=10u l=2u
X12 vdump dn_b dn_s vss nfet_03v3 ad=1.22p pd=5.22u as=1.22p ps=5.22u w=2u l=0.5u
X13 t1c cp_trim0 t1b vss nfet_03v3 ad=1.22p pd=5.22u as=1.22p ps=5.22u w=2u l=0.28u
X14 vnt vref vss vss nfet_03v3 ad=1.22p pd=5.22u as=1.22p ps=5.22u w=2u l=2u
X15 vdd vbp_vco a_20412_3004# vdd pfet_03v3 ad=3.25p pd=11.3u as=1.3p ps=5.52u w=5u l=0.5u
X16 vfilt vss cap_nmos_03v3_b c_width=35u c_length=12u
X17 vdump vdump vbt vdd pfet_03v3 ad=3.25p pd=11.3u as=3.25p ps=11.3u w=5u l=1u
X18 r5 r4 a_21100_1860# vss nfet_03v3 ad=0.39p pd=2.02u as=0.915p ps=4.22u w=1.5u l=0.28u
X19 vbp vbp vdd vdd pfet_03v3 ad=2.6p pd=9.3u as=2.6p ps=9.3u w=4u l=2u
X20 vi vref vss vss nfet_03v3 ad=1.22p pd=5.22u as=1.22p ps=5.22u w=2u l=2u
X21 a_14620_19970# a_14020_12518# vss ppolyf_u r_width=1u r_length=36.6u
X22 r4 r3 a_19728_3004# vdd pfet_03v3 ad=0.78p pd=3.52u as=1.95p ps=7.3u w=3u l=0.28u
X23 vdd r5 nb vdd pfet_03v3 ad=1.3p pd=5.3u as=0.52p ps=2.52u w=2u l=0.28u
X24 va en_b vss vss nfet_03v3 ad=0.61p pd=3.22u as=0.61p ps=3.22u w=1u l=0.28u
X25 en_b pll_en vss vss nfet_03v3 ad=0.61p pd=3.22u as=0.61p ps=3.22u w=1u l=0.28u
X26 vss pll_en a_21784_1760# vss nfet_03v3 ad=1.22p pd=5.22u as=0.52p ps=2.52u w=2u l=0.28u
X27 vfilt vss cap_nmos_03v3_b c_width=35u c_length=12u
X28 vdump vbh vdd vdd pfet_03v3 ad=2.6p pd=9.3u as=2.6p ps=9.3u w=4u l=2u
X29 a_18360_3004# vbp_vco vdd vdd pfet_03v3 ad=1.3p pd=5.52u as=3.25p ps=11.3u w=5u l=0.5u
X30 vctrl vss cap_nmos_03v3_b c_width=43u c_length=12u
X31 r3 r2 a_18364_1860# vss nfet_03v3 ad=0.39p pd=2.02u as=0.915p ps=4.22u w=1.5u l=0.28u
X32 va vbp vdd vdd pfet_03v3 ad=2.6p pd=9.3u as=2.6p ps=9.3u w=4u l=2u
X33 a_11020_19970# a_11620_12518# vss ppolyf_u r_width=1u r_length=36.6u
X34 a_21784_1760# pll_en vss vss nfet_03v3 ad=0.52p pd=2.52u as=1.22p ps=5.22u w=2u l=0.28u
X35 vnt vref vss vss nfet_03v3 ad=1.22p pd=5.22u as=1.22p ps=5.22u w=2u l=2u
X36 dn_s vcp_n vss vss nfet_03v3 ad=6.1p pd=21.22u as=6.1p ps=21.22u w=10u l=2u
X37 vbl vctrl vbt vdd pfet_03v3 ad=3.25p pd=11.3u as=3.25p ps=11.3u w=5u l=1u
X38 a_20412_3004# r5 r1 vdd pfet_03v3 ad=1.95p pd=7.3u as=0.78p ps=3.52u w=3u l=0.28u
X39 vcl vref vss vss nfet_03v3 ad=6.1p pd=21.22u as=6.1p ps=21.22u w=10u l=2u
X40 dn_s vcp_n vss vss nfet_03v3 ad=6.1p pd=21.22u as=6.1p ps=21.22u w=10u l=2u
X41 vdd vbp_vco a_19728_3004# vdd pfet_03v3 ad=3.25p pd=11.3u as=1.3p ps=5.52u w=5u l=0.5u
X42 vbn_vco vbn_vco vss vss nfet_03v3 ad=2.44p pd=9.22u as=2.44p ps=9.22u w=4u l=0.5u
X43 r2 r1 a_19044_3004# vdd pfet_03v3 ad=0.78p pd=3.52u as=1.95p ps=7.3u w=3u l=0.28u
X44 a_19728_3004# vbp_vco vdd vdd pfet_03v3 ad=1.3p pd=5.52u as=3.25p ps=11.3u w=5u l=0.5u
X45 vdump vdump vbt vdd pfet_03v3 ad=3.25p pd=11.3u as=3.25p ps=11.3u w=5u l=1u
X46 a_6820_18650# a_7420_12518# vss ppolyf_u r_width=1u r_length=30u
X47 vbn_vco vbp_vco vdd vdd pfet_03v3 ad=3.25p pd=11.3u as=3.25p ps=11.3u w=5u l=0.5u
X48 nb r5 a_21784_1760# vss nfet_03v3 ad=0.52p pd=2.52u as=1.22p ps=5.22u w=2u l=0.28u
X49 vcp_n cp_trim1 t2 vss nfet_03v3 ad=1.22p pd=5.22u as=1.22p ps=5.22u w=2u l=0.28u
X50 vdump pfd_up up_s vdd pfet_03v3 ad=2.6p pd=9.3u as=2.6p ps=9.3u w=4u l=0.5u
X51 vdump vbh vdd vdd pfet_03v3 ad=2.6p pd=9.3u as=2.6p ps=9.3u w=4u l=2u
X52 vctrl a_620_12518# vss ppolyf_u r_width=2u r_length=37.5u
X53 up_b pfd_up vss vss nfet_03v3 ad=0.61p pd=3.22u as=0.61p ps=3.22u w=1u l=0.28u
X54 a_13420_19970# a_12820_12518# vss ppolyf_u r_width=1u r_length=36.6u
X55 vs a_4420_12518# vss ppolyf_u r_width=1u r_length=17.5u
X56 vdd nb vco_out vdd pfet_03v3 ad=1.95p pd=7.3u as=0.78p ps=3.52u w=3u l=0.28u
X57 vfilt vss cap_nmos_03v3_b c_width=35u c_length=12u
X58 a_19048_1860# r1 r2 vss nfet_03v3 ad=0.915p pd=4.22u as=0.39p ps=2.02u w=1.5u l=0.28u
X59 vbp_vco pll_en vi vss nfet_03v3 ad=3.05p pd=11.22u as=3.05p ps=11.22u w=5u l=0.28u
X60 a_19044_3004# vbp_vco vdd vdd pfet_03v3 ad=1.3p pd=5.52u as=3.25p ps=11.3u w=5u l=0.5u
X61 vco_out nb vdd vdd pfet_03v3 ad=0.78p pd=3.52u as=1.95p ps=7.3u w=3u l=0.28u
X62 bias_ref a_10420_12518# vss ppolyf_u r_width=1u r_length=36.6u
X63 vfilt vss cap_nmos_03v3_b c_width=35u c_length=12u
X64 a_1420_20150# a_620_12518# vss ppolyf_u r_width=2u r_length=37.5u
X65 bias_ref a_8620_12518# vss ppolyf_u r_width=1u r_length=30u
X66 vbl vctrl vbt vdd pfet_03v3 ad=3.25p pd=11.3u as=3.25p ps=11.3u w=5u l=1u
X67 a_19048_1860# vbn_vco vss vss nfet_03v3 ad=0.52p pd=2.52u as=1.22p ps=5.22u w=2u l=0.5u
X68 vss nb vco_out vss nfet_03v3 ad=1.83p pd=7.22u as=0.78p ps=3.52u w=3u l=0.28u
X69 vst vref vss vss nfet_03v3 ad=3.05p pd=11.22u as=3.05p ps=11.22u w=5u l=1u
X70 vctrl up_b up_s vdd pfet_03v3 ad=2.6p pd=9.3u as=2.6p ps=9.3u w=4u l=0.5u
X71 vdd pll_en nb vdd pfet_03v3 ad=1.3p pd=5.3u as=0.52p ps=2.52u w=2u l=0.28u
X72 a_14620_19970# a_15220_12518# vss ppolyf_u r_width=1u r_length=36.6u
X73 vdump vdump vbt vdd pfet_03v3 ad=3.25p pd=11.3u as=3.25p ps=11.3u w=5u l=1u
X74 a_19732_1860# r3 r4 vss nfet_03v3 ad=0.915p pd=4.22u as=0.39p ps=2.02u w=1.5u l=0.28u
X75 vbp vst vss vss nfet_03v3 ad=0.305p pd=2.22u as=0.305p ps=2.22u w=0.5u l=4u
X76 vref a_6220_12518# vss ppolyf_u r_width=1u r_length=30u
X77 vst en_b vss vss nfet_03v3 ad=0.61p pd=3.22u as=0.61p ps=3.22u w=1u l=0.28u
X78 vdump vdump vnt vss nfet_03v3 ad=3.05p pd=11.22u as=3.05p ps=11.22u w=5u l=1u
X79 nb pll_en vdd vdd pfet_03v3 ad=0.52p pd=2.52u as=1.3p ps=5.3u w=2u l=0.28u
X80 r1 r5 a_20412_3004# vdd pfet_03v3 ad=0.78p pd=3.52u as=1.95p ps=7.3u w=3u l=0.28u
X81 vbp_vco pll_en vdd vdd pfet_03v3 ad=0.65p pd=3.3u as=0.65p ps=3.3u w=1u l=0.28u
X82 vss vbn_vco a_19048_1860# vss nfet_03v3 ad=1.22p pd=5.22u as=0.52p ps=2.52u w=2u l=0.5u
X83 vi vctrl vs vss nfet_03v3 ad=3.05p pd=11.22u as=3.05p ps=11.22u w=5u l=1u
X84 a_19732_1860# vbn_vco vss vss nfet_03v3 ad=0.52p pd=2.52u as=1.22p ps=5.22u w=2u l=0.5u
X85 r4 r3 a_19732_1860# vss nfet_03v3 ad=0.39p pd=2.02u as=0.915p ps=4.22u w=1.5u l=0.28u
X86 a_12220_19970# a_11620_12518# vss ppolyf_u r_width=1u r_length=36.6u
X87 vbl vctrl vbt vdd pfet_03v3 ad=3.25p pd=11.3u as=3.25p ps=11.3u w=5u l=1u
X88 vfilt vss cap_nmos_03v3_b c_width=35u c_length=12u
X89 va vref vss vss nfet_03v3 ad=1.22p pd=5.22u as=1.22p ps=5.22u w=2u l=2u
X90 en_b pll_en vdd vdd pfet_03v3 ad=1.3p pd=5.3u as=1.3p ps=5.3u w=2u l=0.28u
X91 a_18364_1860# vbn_vco vss vss nfet_03v3 ad=0.52p pd=2.52u as=1.22p ps=5.22u w=2u l=0.5u
X92 a_1420_20150# a_2220_12518# vss ppolyf_u r_width=2u r_length=37.5u
X93 vdd vbp_vco a_21096_3004# vdd pfet_03v3 ad=3.25p pd=11.3u as=1.3p ps=5.52u w=5u l=0.5u
X94 vdump vbl vss vss nfet_03v3 ad=1.22p pd=5.22u as=1.22p ps=5.22u w=2u l=2u
X95 vcp_p vcp_n vss vss nfet_03v3 ad=6.1p pd=21.22u as=6.1p ps=21.22u w=10u l=2u
X96 vbn_vco en_b vss vss nfet_03v3 ad=0.61p pd=3.22u as=0.61p ps=3.22u w=1u l=0.28u
X97 vfilt vss cap_nmos_03v3_b c_width=35u c_length=12u
X98 a_21100_1860# vbn_vco vss vss nfet_03v3 ad=0.52p pd=2.52u as=1.22p ps=5.22u w=2u l=0.5u
X99 a_21784_1760# r5 nb vss nfet_03v3 ad=1.22p pd=5.22u as=0.52p ps=2.52u w=2u l=0.28u
X100 a_20416_1860# r5 r1 vss nfet_03v3 ad=0.915p pd=4.22u as=0.39p ps=2.02u w=1.5u l=0.28u
X101 a_8020_18650# a_7420_12518# vss ppolyf_u r_width=1u r_length=30u
X102 a_20412_3004# vbp_vco vdd vdd pfet_03v3 ad=1.3p pd=5.52u as=3.25p ps=11.3u w=5u l=0.5u
X103 vbp_vco vbp_vco vdd vdd pfet_03v3 ad=3.25p pd=11.3u as=3.25p ps=11.3u w=5u l=0.5u
X104 vbp pll_en vdd vdd pfet_03v3 ad=0.65p pd=3.3u as=0.65p ps=3.3u w=1u l=0.28u
X105 vbh vctrl vnt vss nfet_03v3 ad=3.05p pd=11.22u as=3.05p ps=11.22u w=5u l=1u
X106 r1 r5 a_20416_1860# vss nfet_03v3 ad=0.39p pd=2.02u as=0.915p ps=4.22u w=1.5u l=0.28u
X107 vss vbn_vco a_18364_1860# vss nfet_03v3 ad=1.22p pd=5.22u as=0.52p ps=2.52u w=2u l=0.5u
X108 vi vctrl vs vss nfet_03v3 ad=3.05p pd=11.22u as=3.05p ps=11.22u w=5u l=1u
X109 vst en_b vdd vdd pfet_03v3 ad=0.325p pd=2.3u as=0.325p ps=2.3u w=0.5u l=10u
X110 vfilt vss cap_nmos_03v3_b c_width=35u c_length=12u
X111 vbt vbp vdd vdd pfet_03v3 ad=2.6p pd=9.3u as=2.6p ps=9.3u w=4u l=2u
X112 r2 r1 a_19048_1860# vss nfet_03v3 ad=0.39p pd=2.02u as=0.915p ps=4.22u w=1.5u l=0.28u
X113 vdd nb vco_out vdd pfet_03v3 ad=1.95p pd=7.3u as=0.78p ps=3.52u w=3u l=0.28u
X114 vdd vbp_vco a_18360_3004# vdd pfet_03v3 ad=3.25p pd=11.3u as=1.3p ps=5.52u w=5u l=0.5u
X115 vcp_n cp_trim1 t1c vss nfet_03v3 ad=1.22p pd=5.22u as=1.22p ps=5.22u w=2u l=0.28u
X116 a_13420_19970# a_14020_12518# vss ppolyf_u r_width=1u r_length=36.6u
X117 a_21096_3004# r4 r5 vdd pfet_03v3 ad=1.95p pd=7.3u as=0.78p ps=3.52u w=3u l=0.28u
X118 vcl a_4420_12518# vss ppolyf_u r_width=1u r_length=17.5u
X119 vcp_n vcp_n vss vss nfet_03v3 ad=6.1p pd=21.22u as=6.1p ps=21.22u w=10u l=2u
X120 vcp_n en_b vss vss nfet_03v3 ad=0.61p pd=3.22u as=0.61p ps=3.22u w=1u l=0.28u
X121 vco_out nb vss vss nfet_03v3 ad=0.78p pd=3.52u as=1.83p ps=7.22u w=3u l=0.28u
X122 vss vbn_vco a_21100_1860# vss nfet_03v3 ad=1.22p pd=5.22u as=0.52p ps=2.52u w=2u l=0.5u
X123 r5 r4 a_21096_3004# vdd pfet_03v3 ad=0.78p pd=3.52u as=1.95p ps=7.3u w=3u l=0.28u
X124 vcp_n cp_trim0 t1a vss nfet_03v3 ad=1.22p pd=5.22u as=1.22p ps=5.22u w=2u l=0.28u
X125 vfilt vss cap_nmos_03v3_b c_width=35u c_length=12u
X126 vfilt a_2220_12518# vss ppolyf_u r_width=2u r_length=37.5u
X127 vbn_vco vbp_vco vdd vdd pfet_03v3 ad=3.25p pd=11.3u as=3.25p ps=11.3u w=5u l=0.5u
X128 vcl vref vss vss nfet_03v3 ad=6.1p pd=21.22u as=6.1p ps=21.22u w=10u l=2u
X129 vss vbn_vco a_19732_1860# vss nfet_03v3 ad=1.22p pd=5.22u as=0.52p ps=2.52u w=2u l=0.5u
X130 vref en_b vss vss nfet_03v3 ad=0.61p pd=3.22u as=0.61p ps=3.22u w=1u l=0.28u
X131 vbl vbl vss vss nfet_03v3 ad=1.22p pd=5.22u as=1.22p ps=5.22u w=2u l=2u
X132 a_11020_19970# a_10420_12518# vss ppolyf_u r_width=1u r_length=36.6u
X133 a_20416_1860# vbn_vco vss vss nfet_03v3 ad=0.52p pd=2.52u as=1.22p ps=5.22u w=2u l=0.5u
X134 up_s vcp_p vdd vdd pfet_03v3 ad=16.25p pd=51.3u as=16.25p ps=51.3u w=25u l=2u
X135 a_18360_3004# r2 r3 vdd pfet_03v3 ad=1.95p pd=7.3u as=0.78p ps=3.52u w=3u l=0.28u
X136 vcp_p vcp_p vdd vdd pfet_03v3 ad=16.25p pd=51.3u as=16.25p ps=51.3u w=25u l=2u
X137 dn_b pfd_dn vdd vdd pfet_03v3 ad=1.3p pd=5.3u as=1.3p ps=5.3u w=2u l=0.28u
X138 dn_b pfd_dn vss vss nfet_03v3 ad=0.61p pd=3.22u as=0.61p ps=3.22u w=1u l=0.28u
X139 vbt vbp vdd vdd pfet_03v3 ad=2.6p pd=9.3u as=2.6p ps=9.3u w=4u l=2u
X140 vcp_n vcp_n vss vss nfet_03v3 ad=6.1p pd=21.22u as=6.1p ps=21.22u w=10u l=2u
X141 vbp va vref vss nfet_03v3 ad=2.44p pd=9.22u as=2.44p ps=9.22u w=4u l=1u
X142 vnt vref vss vss nfet_03v3 ad=1.22p pd=5.22u as=1.22p ps=5.22u w=2u l=2u
X143 vbh vctrl vnt vss nfet_03v3 ad=3.05p pd=11.22u as=3.05p ps=11.22u w=5u l=1u
X144 up_s vcp_p vdd vdd pfet_03v3 ad=16.25p pd=51.3u as=16.25p ps=51.3u w=25u l=2u
X145 vss vbn_vco a_20416_1860# vss nfet_03v3 ad=1.22p pd=5.22u as=0.52p ps=2.52u w=2u l=0.5u
X146 a_21096_3004# vbp_vco vdd vdd pfet_03v3 ad=1.3p pd=5.52u as=3.25p ps=11.3u w=5u l=0.5u
X147 vcp_n vbp vdd vdd pfet_03v3 ad=2.6p pd=9.3u as=2.6p ps=9.3u w=4u l=2u
X148 vfilt vss cap_nmos_03v3_b c_width=35u c_length=12u
X149 nb r5 vdd vdd pfet_03v3 ad=0.52p pd=2.52u as=1.3p ps=5.3u w=2u l=0.28u
X150 vnt vref vss vss nfet_03v3 ad=1.22p pd=5.22u as=1.22p ps=5.22u w=2u l=2u
X151 vdump vbl vss vss nfet_03v3 ad=1.22p pd=5.22u as=1.22p ps=5.22u w=2u l=2u
X152 vbp_vco vbp_vco vdd vdd pfet_03v3 ad=3.25p pd=11.3u as=3.25p ps=11.3u w=5u l=0.5u
X153 vbp_vco pll_en vi vss nfet_03v3 ad=3.05p pd=11.22u as=3.05p ps=11.22u w=5u l=0.28u
X154 vbh vbh vdd vdd pfet_03v3 ad=2.6p pd=9.3u as=2.6p ps=9.3u w=4u l=2u
X155 vcp_n vbp vdd vdd pfet_03v3 ad=2.6p pd=9.3u as=2.6p ps=9.3u w=4u l=2u
X156 vbl vbl vss vss nfet_03v3 ad=1.22p pd=5.22u as=1.22p ps=5.22u w=2u l=2u
X157 vcp_p pll_en vdd vdd pfet_03v3 ad=0.65p pd=3.3u as=0.65p ps=3.3u w=1u l=0.28u
X158 vdd vbp_vco a_19044_3004# vdd pfet_03v3 ad=3.25p pd=11.3u as=1.3p ps=5.52u w=5u l=0.5u
X159 vcp_p vcp_p vdd vdd pfet_03v3 ad=16.25p pd=51.3u as=16.25p ps=51.3u w=25u l=2u
X160 a_18364_1860# r2 r3 vss nfet_03v3 ad=0.915p pd=4.22u as=0.39p ps=2.02u w=1.5u l=0.28u
X161 vfilt vss cap_nmos_03v3_b c_width=35u c_length=12u
X162 t2 vbp vdd vdd pfet_03v3 ad=2.6p pd=9.3u as=2.6p ps=9.3u w=4u l=2u
X163 vdump vdump vbt vdd pfet_03v3 ad=3.25p pd=11.3u as=3.25p ps=11.3u w=5u l=1u
X164 vss a_15220_12518# vss ppolyf_u r_width=1u r_length=36.6u
X165 vfilt vss cap_nmos_03v3_b c_width=35u c_length=12u
X166 t1b vbp vdd vdd pfet_03v3 ad=2.6p pd=9.3u as=2.6p ps=9.3u w=4u l=2u
X167 a_6820_18650# a_6220_12518# vss ppolyf_u r_width=1u r_length=30u
X168 vbt vbp vdd vdd pfet_03v3 ad=2.6p pd=9.3u as=2.6p ps=9.3u w=4u l=2u
X169 vco_out nb vdd vdd pfet_03v3 ad=0.78p pd=3.52u as=1.95p ps=7.3u w=3u l=0.28u
X170 vdump vdump vnt vss nfet_03v3 ad=3.05p pd=11.22u as=3.05p ps=11.22u w=5u l=1u
X171 vst vref vss vss nfet_03v3 ad=3.05p pd=11.22u as=3.05p ps=11.22u w=5u l=1u
X172 vbt vbp vdd vdd pfet_03v3 ad=2.6p pd=9.3u as=2.6p ps=9.3u w=4u l=2u
X173 vbl vctrl vbt vdd pfet_03v3 ad=3.25p pd=11.3u as=3.25p ps=11.3u w=5u l=1u
X174 a_19044_3004# r1 r2 vdd pfet_03v3 ad=1.95p pd=7.3u as=0.78p ps=3.52u w=3u l=0.28u
X175 vfilt vss cap_nmos_03v3_b c_width=35u c_length=12u
X176 vcl vref vss vss nfet_03v3 ad=6.1p pd=21.22u as=6.1p ps=21.22u w=10u l=2u
X177 t2 vbp vdd vdd pfet_03v3 ad=2.6p pd=9.3u as=2.6p ps=9.3u w=4u l=2u
X178 a_12220_19970# a_12820_12518# vss ppolyf_u r_width=1u r_length=36.6u
.ends

.subckt gf180mcu_fd_sc_mcu7t5v0__nand4_1 A1 A2 A3 A4 ZN VDD VNW VPW VSS
X0 ZN A4 VDD VNW pfet_05v0 ad=0.2197p pd=1.365u as=0.3718p ps=2.57u w=0.845u l=0.5u
X1 VDD A3 ZN VNW pfet_05v0 ad=0.2197p pd=1.365u as=0.2197p ps=1.365u w=0.845u l=0.5u
X2 ZN A2 VDD VNW pfet_05v0 ad=0.2197p pd=1.365u as=0.2197p ps=1.365u w=0.845u l=0.5u
X3 VDD A1 ZN VNW pfet_05v0 ad=0.3718p pd=2.57u as=0.2197p ps=1.365u w=0.845u l=0.5u
X4 a_275_68# A4 VSS VPW nfet_05v0 ad=0.1517p pd=1.19u as=0.3608p ps=2.52u w=0.82u l=0.6u
X5 a_673_68# A2 a_469_68# VPW nfet_05v0 ad=0.1517p pd=1.19u as=0.1722p ps=1.24u w=0.82u l=0.6u
X6 a_469_68# A3 a_275_68# VPW nfet_05v0 ad=0.1722p pd=1.24u as=0.1517p ps=1.19u w=0.82u l=0.6u
X7 ZN A1 a_673_68# VPW nfet_05v0 ad=0.3608p pd=2.52u as=0.1517p ps=1.19u w=0.82u l=0.6u
.ends

.subckt gf180mcu_fd_sc_mcu7t5v0__xnor2_1 A1 A2 ZN VDD VNW VPW VSS
X0 ZN a_64_93# VDD VNW pfet_05v0 ad=0.31207p pd=1.665u as=0.34437p ps=1.895u w=1.095u l=0.5u
X1 a_272_93# A2 a_64_93# VPW nfet_05v0 ad=57.59999f pd=0.68u as=0.1584p ps=1.6u w=0.36u l=0.6u
X2 VSS A1 a_272_93# VPW nfet_05v0 ad=0.218p pd=1.52u as=57.59999f ps=0.68u w=0.36u l=0.6u
X3 a_716_68# a_64_93# VSS VPW nfet_05v0 ad=0.2132p pd=1.34u as=0.218p ps=1.52u w=0.82u l=0.6u
X4 VDD A2 a_930_497# VNW pfet_05v0 ad=0.4818p pd=3.07u as=0.55297p ps=2.105u w=1.095u l=0.5u
X5 ZN A1 a_716_68# VPW nfet_05v0 ad=0.4161p pd=1.905u as=0.2132p ps=1.34u w=0.82u l=0.6u
X6 a_64_93# A2 VDD VNW pfet_05v0 ad=0.1456p pd=1.08u as=0.2464p ps=2u w=0.56u l=0.5u
X7 a_716_68# A2 ZN VPW nfet_05v0 ad=0.3608p pd=2.52u as=0.4161p ps=1.905u w=0.82u l=0.6u
X8 VDD A1 a_64_93# VNW pfet_05v0 ad=0.34437p pd=1.895u as=0.1456p ps=1.08u w=0.56u l=0.5u
X9 a_930_497# A1 ZN VNW pfet_05v0 ad=0.55297p pd=2.105u as=0.31207p ps=1.665u w=1.095u l=0.5u
.ends

.subckt gf180mcu_fd_sc_mcu7t5v0__nor4_1 A1 A2 A3 A4 ZN VDD VNW VPW VSS
X0 a_672_472# A2 a_448_472# VNW pfet_05v0 ad=0.3782p pd=1.84u as=0.3782p ps=1.84u w=1.22u l=0.5u
X1 VSS A1 ZN VPW nfet_05v0 ad=0.1584p pd=1.6u as=93.59999f ps=0.88u w=0.36u l=0.6u
X2 VSS A3 ZN VPW nfet_05v0 ad=93.59999f pd=0.88u as=93.59999f ps=0.88u w=0.36u l=0.6u
X3 a_244_472# A4 VDD VNW pfet_05v0 ad=0.3172p pd=1.74u as=0.5368p ps=3.32u w=1.22u l=0.5u
X4 a_448_472# A3 a_244_472# VNW pfet_05v0 ad=0.3782p pd=1.84u as=0.3172p ps=1.74u w=1.22u l=0.5u
X5 ZN A2 VSS VPW nfet_05v0 ad=93.59999f pd=0.88u as=93.59999f ps=0.88u w=0.36u l=0.6u
X6 ZN A4 VSS VPW nfet_05v0 ad=93.59999f pd=0.88u as=0.1584p ps=1.6u w=0.36u l=0.6u
X7 ZN A1 a_672_472# VNW pfet_05v0 ad=0.5368p pd=3.32u as=0.3782p ps=1.84u w=1.22u l=0.5u
.ends

.subckt gf180mcu_fd_sc_mcu7t5v0__antenna I VDD VNW VPW VSS
D0 VPW I diode_nd2ps_06v0 pj=1.86u area=0.2052p
D1 I VNW diode_pd2nw_06v0 pj=1.86u area=0.2052p
.ends

.subckt gf180mcu_fd_sc_mcu7t5v0__aoi211_2 A1 A2 B C ZN VDD VNW VPW VSS
X0 VSS B ZN VPW nfet_05v0 ad=0.2266p pd=1.91u as=0.1339p ps=1.035u w=0.515u l=0.6u
X1 VSS C ZN VPW nfet_05v0 ad=0.1339p pd=1.035u as=0.1339p ps=1.035u w=0.515u l=0.6u
X2 a_244_68# A2 VSS VPW nfet_05v0 ad=93.59999f pd=1.02u as=0.3432p ps=2.44u w=0.78u l=0.6u
X3 ZN A1 a_244_68# VPW nfet_05v0 ad=0.2028p pd=1.3u as=93.59999f ps=1.02u w=0.78u l=0.6u
X4 ZN C VSS VPW nfet_05v0 ad=0.1339p pd=1.035u as=0.1339p ps=1.035u w=0.515u l=0.6u
X5 VDD C a_1044_488# VNW pfet_05v0 ad=0.3534p pd=1.76u as=0.3534p ps=1.76u w=1.14u l=0.5u
X6 ZN A1 a_36_488# VNW pfet_05v0 ad=0.2964p pd=1.66u as=0.3078p ps=1.68u w=1.14u l=0.5u
X7 ZN B VSS VPW nfet_05v0 ad=0.1339p pd=1.035u as=0.23325p ps=1.48u w=0.515u l=0.6u
X8 ZN A2 a_36_488# VNW pfet_05v0 ad=0.2964p pd=1.66u as=0.5016p ps=3.16u w=1.14u l=0.5u
X9 a_36_488# A2 ZN VNW pfet_05v0 ad=0.2964p pd=1.66u as=0.2964p ps=1.66u w=1.14u l=0.5u
X10 a_1044_488# B a_36_488# VNW pfet_05v0 ad=0.3534p pd=1.76u as=0.2964p ps=1.66u w=1.14u l=0.5u
X11 a_36_488# A1 ZN VNW pfet_05v0 ad=0.3078p pd=1.68u as=0.2964p ps=1.66u w=1.14u l=0.5u
X12 a_36_488# B a_1492_488# VNW pfet_05v0 ad=0.5016p pd=3.16u as=0.3534p ps=1.76u w=1.14u l=0.5u
X13 a_636_68# A1 ZN VPW nfet_05v0 ad=93.59999f pd=1.02u as=0.2028p ps=1.3u w=0.78u l=0.6u
X14 a_1492_488# C VDD VNW pfet_05v0 ad=0.3534p pd=1.76u as=0.3534p ps=1.76u w=1.14u l=0.5u
X15 VSS A2 a_636_68# VPW nfet_05v0 ad=0.23325p pd=1.48u as=93.59999f ps=1.02u w=0.78u l=0.6u
.ends

.subckt tt_um_ihsan_sa_pll VGND VPWR clk ena rst_n ua[0] ua[1] ua[2] ua[3] ua[4] ua[5]
+ ua[6] ua[7] ui_in[0] ui_in[1] ui_in[2] ui_in[3] ui_in[4] ui_in[5] ui_in[6] ui_in[7]
+ uio_in[0] uio_in[1] uio_in[2] uio_in[3] uio_in[4] uio_in[5] uio_in[6] uio_in[7]
+ uio_oe[0] uio_oe[1] uio_oe[2] uio_oe[3] uio_oe[4] uio_oe[5] uio_oe[6] uio_oe[7]
+ uio_out[0] uio_out[1] uio_out[2] uio_out[3] uio_out[4] uio_out[5] uio_out[6] uio_out[7]
+ uo_out[0] uo_out[1] uo_out[2] uo_out[3] uo_out[4] uo_out[5] uo_out[6] uo_out[7]
XFILLER_67_542 VPWR VPWR VGND VGND gf180mcu_fd_sc_mcu7t5v0__fillcap_32
XFILLER_35_472 VPWR VPWR VGND VGND gf180mcu_fd_sc_mcu7t5v0__fillcap_64
XFILLER_2_527 VPWR VPWR VGND VGND gf180mcu_fd_sc_mcu7t5v0__fillcap_64
XFILLER_73_534 VPWR VPWR VGND VGND gf180mcu_fd_sc_mcu7t5v0__fillcap_4
XFILLER_14_601 VPWR VPWR VGND VGND gf180mcu_fd_sc_mcu7t5v0__fillcap_4
XFILLER_49_542 VPWR VPWR VGND VGND gf180mcu_fd_sc_mcu7t5v0__fillcap_32
XFILLER_80_2 VPWR VPWR VGND VGND gf180mcu_fd_sc_mcu7t5v0__fillcap_32
XFILLER_17_472 VPWR VPWR VGND VGND gf180mcu_fd_sc_mcu7t5v0__fillcap_64
XFILLER_6_107 VPWR VPWR VGND VGND gf180mcu_fd_sc_mcu7t5v0__fillcap_32
XFILLER_46_501 VPWR VPWR VGND VGND gf180mcu_fd_sc_mcu7t5v0__fillcap_4
XFILLER_77_136 VPWR VPWR VGND VGND gf180mcu_fd_sc_mcu7t5v0__fillcap_4
XFILLER_61_526 VPWR VPWR VGND VGND gf180mcu_fd_sc_mcu7t5v0__fillcap_8
XFILLER_53_72 VPWR VPWR VGND VGND gf180mcu_fd_sc_mcu7t5v0__fillcap_64
XFILLER_28_501 VPWR VPWR VGND VGND gf180mcu_fd_sc_mcu7t5v0__fillcap_4
XFILLER_59_136 VPWR VPWR VGND VGND gf180mcu_fd_sc_mcu7t5v0__fillcap_4
XFILLER_74_139 VPWR VPWR VGND VGND gf180mcu_fd_sc_mcu7t5v0__fillcap_4
X_131_ _131_/A1 input4/Z _131_/B _133_/A2 VPWR VPWR VGND VGND gf180mcu_fd_sc_mcu7t5v0__aoi21_1
XFILLER_80_109 VPWR VPWR VGND VGND gf180mcu_fd_sc_mcu7t5v0__fillcap_8
XFILLER_9_66 VPWR VPWR VGND VGND gf180mcu_fd_sc_mcu7t5v0__fillcap_4
XFILLER_80_70 VPWR VPWR VGND VGND gf180mcu_fd_sc_mcu7t5v0__fillcap_8
XFILLER_43_2 VPWR VPWR VGND VGND gf180mcu_fd_sc_mcu7t5v0__fillcap_64
XFILLER_56_139 VPWR VPWR VGND VGND gf180mcu_fd_sc_mcu7t5v0__fillcap_4
XFILLER_40_507 VPWR VPWR VGND VGND gf180mcu_fd_sc_mcu7t5v0__fillcap_64
XFILLER_38_139 VPWR VPWR VGND VGND gf180mcu_fd_sc_mcu7t5v0__fillcap_4
XFILLER_22_507 VPWR VPWR VGND VGND gf180mcu_fd_sc_mcu7t5v0__fillcap_64
XFILLER_72_429 VPWR VPWR VGND VGND gf180mcu_fd_sc_mcu7t5v0__fillcap_4
XFILLER_48_437 VPWR VPWR VGND VGND gf180mcu_fd_sc_mcu7t5v0__fillcap_64
XFILLER_0_444 VPWR VPWR VGND VGND gf180mcu_fd_sc_mcu7t5v0__fillcap_32
XFILLER_61_72 VPWR VPWR VGND VGND gf180mcu_fd_sc_mcu7t5v0__fillcap_64
XFILLER_8_577 VPWR VPWR VGND VGND gf180mcu_fd_sc_mcu7t5v0__fillcap_16
XFILLER_3_282 VPWR VPWR VGND VGND gf180mcu_fd_sc_mcu7t5v0__fillcap_64
XFILLER_40_101 VPWR VPWR VGND VGND gf180mcu_fd_sc_mcu7t5v0__fillcap_4
Xtt_um_ihsan_sa_pll_29 uio_oe[7] VPWR VPWR VGND VGND gf180mcu_fd_sc_mcu7t5v0__tiel
XFILLER_5_536 VPWR VPWR VGND VGND gf180mcu_fd_sc_mcu7t5v0__fillcap_4
XFILLER_0_274 VPWR VPWR VGND VGND gf180mcu_fd_sc_mcu7t5v0__fillcap_32
XFILLER_4_580 VPWR VPWR VGND VGND gf180mcu_fd_sc_mcu7t5v0__fillcap_16
XFILLER_67_598 VPWR VPWR VGND VGND gf180mcu_fd_sc_mcu7t5v0__fillcap_4
XFILLER_22_101 VPWR VPWR VGND VGND gf180mcu_fd_sc_mcu7t5v0__fillcap_4
XFILLER_1_594 VPWR VPWR VGND VGND gf180mcu_fd_sc_mcu7t5v0__fillcap_8
XFILLER_64_557 VPWR VPWR VGND VGND gf180mcu_fd_sc_mcu7t5v0__fillcap_16
XFILLER_49_598 VPWR VPWR VGND VGND gf180mcu_fd_sc_mcu7t5v0__fillcap_4
XFILLER_73_2 VPWR VPWR VGND VGND gf180mcu_fd_sc_mcu7t5v0__fillcap_64
XFILLER_63_590 VPWR VPWR VGND VGND gf180mcu_fd_sc_mcu7t5v0__fillcap_8
XFILLER_45_590 VPWR VPWR VGND VGND gf180mcu_fd_sc_mcu7t5v0__fillcap_8
XFILLER_60_593 VPWR VPWR VGND VGND gf180mcu_fd_sc_mcu7t5v0__fillcap_8
XFILLER_60_571 VPWR VPWR VGND VGND gf180mcu_fd_sc_mcu7t5v0__fillcap_4
XFILLER_20_402 VPWR VPWR VGND VGND gf180mcu_fd_sc_mcu7t5v0__fillcap_32
XFILLER_74_107 VPWR VPWR VGND VGND gf180mcu_fd_sc_mcu7t5v0__fillcap_32
X_130_ _167_/Q input4/Z _130_/B _134_/A1 VPWR VPWR VGND VGND gf180mcu_fd_sc_mcu7t5v0__oai21_1
XFILLER_11_402 VPWR VPWR VGND VGND gf180mcu_fd_sc_mcu7t5v0__fillcap_64
XFILLER_2_177 VPWR VPWR VGND VGND gf180mcu_fd_sc_mcu7t5v0__fillcap_64
XFILLER_3_2 VPWR VPWR VGND VGND gf180mcu_fd_sc_mcu7t5v0__fillcap_64
Xclkbuf_1_1__f_u_ihsan_sa_pll.u_pre.pre_q1 _171_/Q _172_/CLK VPWR VPWR VGND VGND gf180mcu_fd_sc_mcu7t5v0__clkbuf_8
XFILLER_27_590 VPWR VPWR VGND VGND gf180mcu_fd_sc_mcu7t5v0__fillcap_8
XFILLER_0_36 VPWR VPWR VGND VGND gf180mcu_fd_sc_mcu7t5v0__fillcap_32
XFILLER_42_571 VPWR VPWR VGND VGND gf180mcu_fd_sc_mcu7t5v0__fillcap_4
XFILLER_42_593 VPWR VPWR VGND VGND gf180mcu_fd_sc_mcu7t5v0__fillcap_8
XFILLER_36_2 VPWR VPWR VGND VGND gf180mcu_fd_sc_mcu7t5v0__fillcap_32
XFILLER_56_107 VPWR VPWR VGND VGND gf180mcu_fd_sc_mcu7t5v0__fillcap_32
XFILLER_24_571 VPWR VPWR VGND VGND gf180mcu_fd_sc_mcu7t5v0__fillcap_4
XFILLER_24_593 VPWR VPWR VGND VGND gf180mcu_fd_sc_mcu7t5v0__fillcap_8
X_113_ _113_/I _113_/ZN VPWR VPWR VGND VGND gf180mcu_fd_sc_mcu7t5v0__clkinv_1
XFILLER_3_486 VPWR VPWR VGND VGND gf180mcu_fd_sc_mcu7t5v0__fillcap_4
Xload_slew20 _168_/RN _156_/RN VPWR VPWR VGND VGND gf180mcu_fd_sc_mcu7t5v0__buf_1
XFILLER_38_107 VPWR VPWR VGND VGND gf180mcu_fd_sc_mcu7t5v0__fillcap_32
XFILLER_59_72 VPWR VPWR VGND VGND gf180mcu_fd_sc_mcu7t5v0__fillcap_64
XFILLER_21_574 VPWR VPWR VGND VGND gf180mcu_fd_sc_mcu7t5v0__fillcap_16
XFILLER_4_206 VPWR VPWR VGND VGND gf180mcu_fd_sc_mcu7t5v0__fillcap_32
XFILLER_0_478 VPWR VPWR VGND VGND gf180mcu_fd_sc_mcu7t5v0__fillcap_32
XFILLER_8_501 VPWR VPWR VGND VGND gf180mcu_fd_sc_mcu7t5v0__fillcap_4
XFILLER_62_452 VPWR VPWR VGND VGND gf180mcu_fd_sc_mcu7t5v0__fillcap_8
XFILLER_15_66 VPWR VPWR VGND VGND gf180mcu_fd_sc_mcu7t5v0__fillcap_4
XFILLER_76_566 VPWR VPWR VGND VGND gf180mcu_fd_sc_mcu7t5v0__fillcap_8
Xu_ihsan_sa_pll.u_pre.u_pre_ckbuf0 u_ihsan_sa_pll.u_pre.u_pre_ff0/Q _171_/CLK VPWR
+ VPWR VGND VGND gf180mcu_fd_sc_mcu7t5v0__clkbuf_1
XFILLER_58_577 VPWR VPWR VGND VGND gf180mcu_fd_sc_mcu7t5v0__fillcap_16
XFILLER_41_466 VPWR VPWR VGND VGND gf180mcu_fd_sc_mcu7t5v0__fillcap_4
XFILLER_67_72 VPWR VPWR VGND VGND gf180mcu_fd_sc_mcu7t5v0__fillcap_64
XFILLER_1_562 VPWR VPWR VGND VGND gf180mcu_fd_sc_mcu7t5v0__fillcap_32
XFILLER_66_2 VPWR VPWR VGND VGND gf180mcu_fd_sc_mcu7t5v0__fillcap_32
XFILLER_55_536 VPWR VPWR VGND VGND gf180mcu_fd_sc_mcu7t5v0__fillcap_4
XFILLER_23_466 VPWR VPWR VGND VGND gf180mcu_fd_sc_mcu7t5v0__fillcap_4
XFILLER_37_536 VPWR VPWR VGND VGND gf180mcu_fd_sc_mcu7t5v0__fillcap_4
XFILLER_23_66 VPWR VPWR VGND VGND gf180mcu_fd_sc_mcu7t5v0__fillcap_4
XFILLER_2_101 VPWR VPWR VGND VGND gf180mcu_fd_sc_mcu7t5v0__fillcap_4
XFILLER_19_536 VPWR VPWR VGND VGND gf180mcu_fd_sc_mcu7t5v0__fillcap_4
XFILLER_80_83 VPWR VPWR VGND VGND gf180mcu_fd_sc_mcu7t5v0__fillcap_8
XFILLER_29_2 VPWR VPWR VGND VGND gf180mcu_fd_sc_mcu7t5v0__fillcap_64
X_112_ _143_/Q _125_/A2 VPWR VPWR VGND VGND gf180mcu_fd_sc_mcu7t5v0__clkinv_1
Xload_slew10 wire11/Z _113_/I VPWR VPWR VGND VGND gf180mcu_fd_sc_mcu7t5v0__clkbuf_2
XFILLER_62_601 VPWR VPWR VGND VGND gf180mcu_fd_sc_mcu7t5v0__fillcap_4
XFILLER_75_72 VPWR VPWR VGND VGND gf180mcu_fd_sc_mcu7t5v0__fillcap_64
Xfanout9 _161_/RN _158_/RN VPWR VPWR VGND VGND gf180mcu_fd_sc_mcu7t5v0__dlyb_1
XFILLER_21_542 VPWR VPWR VGND VGND gf180mcu_fd_sc_mcu7t5v0__fillcap_32
XFILLER_44_601 VPWR VPWR VGND VGND gf180mcu_fd_sc_mcu7t5v0__fillcap_4
XFILLER_47_472 VPWR VPWR VGND VGND gf180mcu_fd_sc_mcu7t5v0__fillcap_64
XFILLER_7_590 VPWR VPWR VGND VGND gf180mcu_fd_sc_mcu7t5v0__fillcap_8
XFILLER_26_601 VPWR VPWR VGND VGND gf180mcu_fd_sc_mcu7t5v0__fillcap_4
XFILLER_31_66 VPWR VPWR VGND VGND gf180mcu_fd_sc_mcu7t5v0__fillcap_4
XFILLER_29_472 VPWR VPWR VGND VGND gf180mcu_fd_sc_mcu7t5v0__fillcap_64
XFILLER_31_136 VPWR VPWR VGND VGND gf180mcu_fd_sc_mcu7t5v0__fillcap_4
XFILLER_11_2 VPWR VPWR VGND VGND gf180mcu_fd_sc_mcu7t5v0__fillcap_64
XFILLER_58_501 VPWR VPWR VGND VGND gf180mcu_fd_sc_mcu7t5v0__fillcap_4
XFILLER_13_136 VPWR VPWR VGND VGND gf180mcu_fd_sc_mcu7t5v0__fillcap_4
XFILLER_76_342 VPWR VPWR VGND VGND gf180mcu_fd_sc_mcu7t5v0__fillcap_32
XFILLER_59_2 VPWR VPWR VGND VGND gf180mcu_fd_sc_mcu7t5v0__fillcap_64
XFILLER_70_507 VPWR VPWR VGND VGND gf180mcu_fd_sc_mcu7t5v0__fillcap_16
XFILLER_10_139 VPWR VPWR VGND VGND gf180mcu_fd_sc_mcu7t5v0__fillcap_4
XFILLER_52_507 VPWR VPWR VGND VGND gf180mcu_fd_sc_mcu7t5v0__fillcap_64
XFILLER_68_139 VPWR VPWR VGND VGND gf180mcu_fd_sc_mcu7t5v0__fillcap_4
XFILLER_76_172 VPWR VPWR VGND VGND gf180mcu_fd_sc_mcu7t5v0__fillcap_32
XFILLER_20_437 VPWR VPWR VGND VGND gf180mcu_fd_sc_mcu7t5v0__fillcap_64
XFILLER_34_507 VPWR VPWR VGND VGND gf180mcu_fd_sc_mcu7t5v0__fillcap_64
XFILLER_69_459 VPWR VPWR VGND VGND gf180mcu_fd_sc_mcu7t5v0__fillcap_8
XFILLER_16_507 VPWR VPWR VGND VGND gf180mcu_fd_sc_mcu7t5v0__fillcap_64
XFILLER_70_101 VPWR VPWR VGND VGND gf180mcu_fd_sc_mcu7t5v0__fillcap_4
X_111_ _111_/A1 _113_/ZN _165_/RN VPWR VPWR VGND VGND gf180mcu_fd_sc_mcu7t5v0__nor2_1
XFILLER_3_422 VPWR VPWR VGND VGND gf180mcu_fd_sc_mcu7t5v0__fillcap_64
Xload_slew22 fanout21/Z _161_/RN VPWR VPWR VGND VGND gf180mcu_fd_sc_mcu7t5v0__buf_1
XFILLER_41_2 VPWR VPWR VGND VGND gf180mcu_fd_sc_mcu7t5v0__fillcap_64
XFILLER_52_101 VPWR VPWR VGND VGND gf180mcu_fd_sc_mcu7t5v0__fillcap_4
XFILLER_80_410 VPWR VPWR VGND VGND gf180mcu_fd_sc_mcu7t5v0__fillcap_16
XFILLER_21_598 VPWR VPWR VGND VGND gf180mcu_fd_sc_mcu7t5v0__fillcap_4
XFILLER_29_66 VPWR VPWR VGND VGND gf180mcu_fd_sc_mcu7t5v0__fillcap_4
XFILLER_6_37 VPWR VPWR VGND VGND gf180mcu_fd_sc_mcu7t5v0__fillcap_64
XFILLER_34_101 VPWR VPWR VGND VGND gf180mcu_fd_sc_mcu7t5v0__fillcap_4
XFILLER_80_240 VPWR VPWR VGND VGND gf180mcu_fd_sc_mcu7t5v0__fillcap_8
XFILLER_76_546 VPWR VPWR VGND VGND gf180mcu_fd_sc_mcu7t5v0__fillcap_4
XFILLER_16_101 VPWR VPWR VGND VGND gf180mcu_fd_sc_mcu7t5v0__fillcap_4
XFILLER_50_402 VPWR VPWR VGND VGND gf180mcu_fd_sc_mcu7t5v0__fillcap_32
XFILLER_41_402 VPWR VPWR VGND VGND gf180mcu_fd_sc_mcu7t5v0__fillcap_64
XFILLER_57_590 VPWR VPWR VGND VGND gf180mcu_fd_sc_mcu7t5v0__fillcap_8
XFILLER_76_376 VPWR VPWR VGND VGND gf180mcu_fd_sc_mcu7t5v0__fillcap_4
XFILLER_72_593 VPWR VPWR VGND VGND gf180mcu_fd_sc_mcu7t5v0__fillcap_8
XFILLER_72_571 VPWR VPWR VGND VGND gf180mcu_fd_sc_mcu7t5v0__fillcap_4
XFILLER_32_402 VPWR VPWR VGND VGND gf180mcu_fd_sc_mcu7t5v0__fillcap_32
XFILLER_23_402 VPWR VPWR VGND VGND gf180mcu_fd_sc_mcu7t5v0__fillcap_64
XFILLER_10_107 VPWR VPWR VGND VGND gf180mcu_fd_sc_mcu7t5v0__fillcap_32
XFILLER_2_317 VPWR VPWR VGND VGND gf180mcu_fd_sc_mcu7t5v0__fillcap_64
XFILLER_39_590 VPWR VPWR VGND VGND gf180mcu_fd_sc_mcu7t5v0__fillcap_8
XFILLER_37_66 VPWR VPWR VGND VGND gf180mcu_fd_sc_mcu7t5v0__fillcap_4
XFILLER_54_571 VPWR VPWR VGND VGND gf180mcu_fd_sc_mcu7t5v0__fillcap_4
XFILLER_54_593 VPWR VPWR VGND VGND gf180mcu_fd_sc_mcu7t5v0__fillcap_8
XFILLER_14_402 VPWR VPWR VGND VGND gf180mcu_fd_sc_mcu7t5v0__fillcap_32
XFILLER_6_601 VPWR VPWR VGND VGND gf180mcu_fd_sc_mcu7t5v0__fillcap_4
XFILLER_68_107 VPWR VPWR VGND VGND gf180mcu_fd_sc_mcu7t5v0__fillcap_32
XFILLER_71_2 VPWR VPWR VGND VGND gf180mcu_fd_sc_mcu7t5v0__fillcap_64
XFILLER_9_472 VPWR VPWR VGND VGND gf180mcu_fd_sc_mcu7t5v0__fillcap_64
XFILLER_4_70 VPWR VPWR VGND VGND gf180mcu_fd_sc_mcu7t5v0__fillcap_32
XFILLER_51_574 VPWR VPWR VGND VGND gf180mcu_fd_sc_mcu7t5v0__fillcap_16
XFILLER_36_571 VPWR VPWR VGND VGND gf180mcu_fd_sc_mcu7t5v0__fillcap_4
XFILLER_36_593 VPWR VPWR VGND VGND gf180mcu_fd_sc_mcu7t5v0__fillcap_8
XFILLER_80_96 VPWR VPWR VGND VGND gf180mcu_fd_sc_mcu7t5v0__fillcap_4
XFILLER_18_593 VPWR VPWR VGND VGND gf180mcu_fd_sc_mcu7t5v0__fillcap_8
XFILLER_18_571 VPWR VPWR VGND VGND gf180mcu_fd_sc_mcu7t5v0__fillcap_4
XFILLER_33_574 VPWR VPWR VGND VGND gf180mcu_fd_sc_mcu7t5v0__fillcap_16
X_110_ _125_/A2 _110_/A2 _110_/B _143_/D VPWR VPWR VGND VGND gf180mcu_fd_sc_mcu7t5v0__aoi21_1
Xclkload0 _161_/CLK clkload0/Z VPWR VPWR VGND VGND gf180mcu_fd_sc_mcu7t5v0__clkbuf_2
XFILLER_1_2 VPWR VPWR VGND VGND gf180mcu_fd_sc_mcu7t5v0__fillcap_64
Xload_slew12 _158_/RN wire11/I VPWR VPWR VGND VGND gf180mcu_fd_sc_mcu7t5v0__clkbuf_2
XFILLER_30_577 VPWR VPWR VGND VGND gf180mcu_fd_sc_mcu7t5v0__fillcap_16
XFILLER_15_574 VPWR VPWR VGND VGND gf180mcu_fd_sc_mcu7t5v0__fillcap_16
XFILLER_34_2 VPWR VPWR VGND VGND gf180mcu_fd_sc_mcu7t5v0__fillcap_32
XFILLER_45_66 VPWR VPWR VGND VGND gf180mcu_fd_sc_mcu7t5v0__fillcap_4
XFILLER_12_577 VPWR VPWR VGND VGND gf180mcu_fd_sc_mcu7t5v0__fillcap_16
XFILLER_53_466 VPWR VPWR VGND VGND gf180mcu_fd_sc_mcu7t5v0__fillcap_4
XFILLER_80_252 VPWR VPWR VGND VGND gf180mcu_fd_sc_mcu7t5v0__fillcap_8
XFILLER_79_352 VPWR VPWR VGND VGND gf180mcu_fd_sc_mcu7t5v0__fillcap_8
XFILLER_35_466 VPWR VPWR VGND VGND gf180mcu_fd_sc_mcu7t5v0__fillcap_4
XFILLER_49_536 VPWR VPWR VGND VGND gf180mcu_fd_sc_mcu7t5v0__fillcap_4
XFILLER_17_466 VPWR VPWR VGND VGND gf180mcu_fd_sc_mcu7t5v0__fillcap_4
XFILLER_12_37 VPWR VPWR VGND VGND gf180mcu_fd_sc_mcu7t5v0__fillcap_64
XFILLER_53_66 VPWR VPWR VGND VGND gf180mcu_fd_sc_mcu7t5v0__fillcap_4
X_164__44 _164_/D VPWR VPWR VGND VGND gf180mcu_fd_sc_mcu7t5v0__tieh
XFILLER_64_2 VPWR VPWR VGND VGND gf180mcu_fd_sc_mcu7t5v0__fillcap_32
XFILLER_51_542 VPWR VPWR VGND VGND gf180mcu_fd_sc_mcu7t5v0__fillcap_32
XFILLER_74_601 VPWR VPWR VGND VGND gf180mcu_fd_sc_mcu7t5v0__fillcap_4
XFILLER_33_542 VPWR VPWR VGND VGND gf180mcu_fd_sc_mcu7t5v0__fillcap_32
XFILLER_56_601 VPWR VPWR VGND VGND gf180mcu_fd_sc_mcu7t5v0__fillcap_4
Xclkload1 _163_/CLK clkload1/Z VPWR VPWR VGND VGND gf180mcu_fd_sc_mcu7t5v0__clkbuf_2
XFILLER_59_472 VPWR VPWR VGND VGND gf180mcu_fd_sc_mcu7t5v0__fillcap_64
XFILLER_78_247 VPWR VPWR VGND VGND gf180mcu_fd_sc_mcu7t5v0__fillcap_64
XFILLER_30_501 VPWR VPWR VGND VGND gf180mcu_fd_sc_mcu7t5v0__fillcap_4
XFILLER_61_136 VPWR VPWR VGND VGND gf180mcu_fd_sc_mcu7t5v0__fillcap_4
XFILLER_15_542 VPWR VPWR VGND VGND gf180mcu_fd_sc_mcu7t5v0__fillcap_32
X_169_ _169_/D _169_/RN _168_/CLK _169_/Q VPWR VPWR VGND VGND gf180mcu_fd_sc_mcu7t5v0__dffnrnq_1
XFILLER_27_2 VPWR VPWR VGND VGND gf180mcu_fd_sc_mcu7t5v0__fillcap_64
XFILLER_38_601 VPWR VPWR VGND VGND gf180mcu_fd_sc_mcu7t5v0__fillcap_4
XFILLER_1_72 VPWR VPWR VGND VGND gf180mcu_fd_sc_mcu7t5v0__fillcap_64
XFILLER_20_37 VPWR VPWR VGND VGND gf180mcu_fd_sc_mcu7t5v0__fillcap_64
XFILLER_43_136 VPWR VPWR VGND VGND gf180mcu_fd_sc_mcu7t5v0__fillcap_4
XFILLER_12_501 VPWR VPWR VGND VGND gf180mcu_fd_sc_mcu7t5v0__fillcap_4
XFILLER_61_66 VPWR VPWR VGND VGND gf180mcu_fd_sc_mcu7t5v0__fillcap_4
XFILLER_3_276 VPWR VPWR VGND VGND gf180mcu_fd_sc_mcu7t5v0__fillcap_4
XFILLER_79_578 VPWR VPWR VGND VGND gf180mcu_fd_sc_mcu7t5v0__fillcap_16
XFILLER_25_136 VPWR VPWR VGND VGND gf180mcu_fd_sc_mcu7t5v0__fillcap_4
XFILLER_40_139 VPWR VPWR VGND VGND gf180mcu_fd_sc_mcu7t5v0__fillcap_4
XFILLER_79_375 VPWR VPWR VGND VGND gf180mcu_fd_sc_mcu7t5v0__fillcap_32
XFILLER_4_596 VPWR VPWR VGND VGND gf180mcu_fd_sc_mcu7t5v0__fillcap_8
XFILLER_50_437 VPWR VPWR VGND VGND gf180mcu_fd_sc_mcu7t5v0__fillcap_64
XFILLER_22_139 VPWR VPWR VGND VGND gf180mcu_fd_sc_mcu7t5v0__fillcap_4
XFILLER_66_570 VPWR VPWR VGND VGND gf180mcu_fd_sc_mcu7t5v0__fillcap_4
XFILLER_32_437 VPWR VPWR VGND VGND gf180mcu_fd_sc_mcu7t5v0__fillcap_64
XFILLER_46_507 VPWR VPWR VGND VGND gf180mcu_fd_sc_mcu7t5v0__fillcap_64
XFILLER_14_437 VPWR VPWR VGND VGND gf180mcu_fd_sc_mcu7t5v0__fillcap_64
XFILLER_1_352 VPWR VPWR VGND VGND gf180mcu_fd_sc_mcu7t5v0__fillcap_64
XFILLER_57_2 VPWR VPWR VGND VGND gf180mcu_fd_sc_mcu7t5v0__fillcap_64
XFILLER_28_507 VPWR VPWR VGND VGND gf180mcu_fd_sc_mcu7t5v0__fillcap_64
XFILLER_51_598 VPWR VPWR VGND VGND gf180mcu_fd_sc_mcu7t5v0__fillcap_4
XFILLER_77_473 VPWR VPWR VGND VGND gf180mcu_fd_sc_mcu7t5v0__fillcap_8
XFILLER_64_101 VPWR VPWR VGND VGND gf180mcu_fd_sc_mcu7t5v0__fillcap_4
XFILLER_33_598 VPWR VPWR VGND VGND gf180mcu_fd_sc_mcu7t5v0__fillcap_4
XFILLER_18_37 VPWR VPWR VGND VGND gf180mcu_fd_sc_mcu7t5v0__fillcap_64
Xclkload2 _156_/CLK clkload2/Z VPWR VPWR VGND VGND gf180mcu_fd_sc_mcu7t5v0__clkbuf_2
XFILLER_59_66 VPWR VPWR VGND VGND gf180mcu_fd_sc_mcu7t5v0__fillcap_4
XFILLER_46_101 VPWR VPWR VGND VGND gf180mcu_fd_sc_mcu7t5v0__fillcap_4
Xload_slew14 wire15/Z _151_/RN VPWR VPWR VGND VGND gf180mcu_fd_sc_mcu7t5v0__clkbuf_2
XFILLER_15_598 VPWR VPWR VGND VGND gf180mcu_fd_sc_mcu7t5v0__fillcap_4
X_168_ _168_/D _168_/RN _168_/CLK _168_/Q VPWR VPWR VGND VGND gf180mcu_fd_sc_mcu7t5v0__dffrnq_1
X_099_ _099_/A1 _098_/Z _161_/D VPWR VPWR VGND VGND gf180mcu_fd_sc_mcu7t5v0__nor2_1
XFILLER_80_402 VPWR VPWR VGND VGND gf180mcu_fd_sc_mcu7t5v0__fillcap_4
XFILLER_80_435 VPWR VPWR VGND VGND gf180mcu_fd_sc_mcu7t5v0__fillcap_4
XFILLER_28_101 VPWR VPWR VGND VGND gf180mcu_fd_sc_mcu7t5v0__fillcap_4
Xu_ihsan_sa_pll.u_pfd.pfd_dly0 _129_/Z u_ihsan_sa_pll.u_pfd.pfd_dly1/I VPWR VPWR VGND
+ VGND gf180mcu_fd_sc_mcu7t5v0__dlya_1
XFILLER_79_568 VPWR VPWR VGND VGND gf180mcu_fd_sc_mcu7t5v0__fillcap_4
XFILLER_70_490 VPWR VPWR VGND VGND gf180mcu_fd_sc_mcu7t5v0__fillcap_4
XFILLER_11_590 VPWR VPWR VGND VGND gf180mcu_fd_sc_mcu7t5v0__fillcap_8
XFILLER_40_107 VPWR VPWR VGND VGND gf180mcu_fd_sc_mcu7t5v0__fillcap_32
XFILLER_53_402 VPWR VPWR VGND VGND gf180mcu_fd_sc_mcu7t5v0__fillcap_64
XFILLER_80_265 VPWR VPWR VGND VGND gf180mcu_fd_sc_mcu7t5v0__fillcap_4
XFILLER_76_538 VPWR VPWR VGND VGND gf180mcu_fd_sc_mcu7t5v0__fillcap_4
XFILLER_69_590 VPWR VPWR VGND VGND gf180mcu_fd_sc_mcu7t5v0__fillcap_8
XFILLER_44_402 VPWR VPWR VGND VGND gf180mcu_fd_sc_mcu7t5v0__fillcap_32
XFILLER_22_107 VPWR VPWR VGND VGND gf180mcu_fd_sc_mcu7t5v0__fillcap_32
XFILLER_35_402 VPWR VPWR VGND VGND gf180mcu_fd_sc_mcu7t5v0__fillcap_64
XFILLER_7_72 VPWR VPWR VGND VGND gf180mcu_fd_sc_mcu7t5v0__fillcap_64
XFILLER_66_593 VPWR VPWR VGND VGND gf180mcu_fd_sc_mcu7t5v0__fillcap_8
XFILLER_26_37 VPWR VPWR VGND VGND gf180mcu_fd_sc_mcu7t5v0__fillcap_64
XFILLER_26_402 VPWR VPWR VGND VGND gf180mcu_fd_sc_mcu7t5v0__fillcap_32
XFILLER_67_66 VPWR VPWR VGND VGND gf180mcu_fd_sc_mcu7t5v0__fillcap_4
XFILLER_1_556 VPWR VPWR VGND VGND gf180mcu_fd_sc_mcu7t5v0__fillcap_4
XFILLER_17_402 VPWR VPWR VGND VGND gf180mcu_fd_sc_mcu7t5v0__fillcap_64
XFILLER_48_571 VPWR VPWR VGND VGND gf180mcu_fd_sc_mcu7t5v0__fillcap_4
XFILLER_48_593 VPWR VPWR VGND VGND gf180mcu_fd_sc_mcu7t5v0__fillcap_8
XFILLER_5_136 VPWR VPWR VGND VGND gf180mcu_fd_sc_mcu7t5v0__fillcap_4
XFILLER_77_600 VPWR VPWR VGND VGND gf180mcu_fd_sc_mcu7t5v0__fillcap_4
XFILLER_60_577 VPWR VPWR VGND VGND gf180mcu_fd_sc_mcu7t5v0__fillcap_16
XFILLER_45_574 VPWR VPWR VGND VGND gf180mcu_fd_sc_mcu7t5v0__fillcap_16
XFILLER_42_577 VPWR VPWR VGND VGND gf180mcu_fd_sc_mcu7t5v0__fillcap_16
XFILLER_27_574 VPWR VPWR VGND VGND gf180mcu_fd_sc_mcu7t5v0__fillcap_16
XFILLER_24_577 VPWR VPWR VGND VGND gf180mcu_fd_sc_mcu7t5v0__fillcap_16
XFILLER_34_37 VPWR VPWR VGND VGND gf180mcu_fd_sc_mcu7t5v0__fillcap_64
Xclkload3 _172_/CLK clkload3/Z VPWR VPWR VGND VGND gf180mcu_fd_sc_mcu7t5v0__clkbuf_2
XFILLER_75_66 VPWR VPWR VGND VGND gf180mcu_fd_sc_mcu7t5v0__fillcap_4
X_167_ _167_/D _167_/RN _170_/CLK _167_/Q VPWR VPWR VGND VGND gf180mcu_fd_sc_mcu7t5v0__dffrnq_1
X_098_ _161_/Q _098_/A2 _098_/Z VPWR VPWR VGND VGND gf180mcu_fd_sc_mcu7t5v0__xor2_1
XFILLER_77_282 VPWR VPWR VGND VGND gf180mcu_fd_sc_mcu7t5v0__fillcap_64
XFILLER_21_536 VPWR VPWR VGND VGND gf180mcu_fd_sc_mcu7t5v0__fillcap_4
XFILLER_71_436 VPWR VPWR VGND VGND gf180mcu_fd_sc_mcu7t5v0__fillcap_4
XFILLER_8_507 VPWR VPWR VGND VGND gf180mcu_fd_sc_mcu7t5v0__fillcap_64
XFILLER_3_212 VPWR VPWR VGND VGND gf180mcu_fd_sc_mcu7t5v0__fillcap_64
Xu_ihsan_sa_pll.u_pfd.pfd_dly1 u_ihsan_sa_pll.u_pfd.pfd_dly1/I _111_/A1 VPWR VPWR
+ VGND VGND gf180mcu_fd_sc_mcu7t5v0__dlya_1
XFILLER_47_466 VPWR VPWR VGND VGND gf180mcu_fd_sc_mcu7t5v0__fillcap_4
XFILLER_32_2 VPWR VPWR VGND VGND gf180mcu_fd_sc_mcu7t5v0__fillcap_32
XFILLER_80_200 VPWR VPWR VGND VGND gf180mcu_fd_sc_mcu7t5v0__fillcap_4
XFILLER_61_480 VPWR VPWR VGND VGND gf180mcu_fd_sc_mcu7t5v0__fillcap_4
XFILLER_29_466 VPWR VPWR VGND VGND gf180mcu_fd_sc_mcu7t5v0__fillcap_4
Xclkbuf_0_clk clk clkbuf_0_clk/Z VPWR VPWR VGND VGND gf180mcu_fd_sc_mcu7t5v0__clkbuf_8
XFILLER_42_37 VPWR VPWR VGND VGND gf180mcu_fd_sc_mcu7t5v0__fillcap_64
XFILLER_8_101 VPWR VPWR VGND VGND gf180mcu_fd_sc_mcu7t5v0__fillcap_4
XFILLER_63_542 VPWR VPWR VGND VGND gf180mcu_fd_sc_mcu7t5v0__fillcap_8
XFILLER_63_531 VPWR VPWR VGND VGND gf180mcu_fd_sc_mcu7t5v0__fillcap_8
XFILLER_31_472 VPWR VPWR VGND VGND gf180mcu_fd_sc_mcu7t5v0__fillcap_64
XFILLER_10_601 VPWR VPWR VGND VGND gf180mcu_fd_sc_mcu7t5v0__fillcap_4
XFILLER_45_542 VPWR VPWR VGND VGND gf180mcu_fd_sc_mcu7t5v0__fillcap_32
XFILLER_13_472 VPWR VPWR VGND VGND gf180mcu_fd_sc_mcu7t5v0__fillcap_64
XFILLER_68_601 VPWR VPWR VGND VGND gf180mcu_fd_sc_mcu7t5v0__fillcap_4
XFILLER_2_107 VPWR VPWR VGND VGND gf180mcu_fd_sc_mcu7t5v0__fillcap_64
XFILLER_27_542 VPWR VPWR VGND VGND gf180mcu_fd_sc_mcu7t5v0__fillcap_32
XFILLER_73_136 VPWR VPWR VGND VGND gf180mcu_fd_sc_mcu7t5v0__fillcap_4
XFILLER_42_501 VPWR VPWR VGND VGND gf180mcu_fd_sc_mcu7t5v0__fillcap_4
XFILLER_13_72 VPWR VPWR VGND VGND gf180mcu_fd_sc_mcu7t5v0__fillcap_64
XFILLER_6_402 VPWR VPWR VGND VGND gf180mcu_fd_sc_mcu7t5v0__fillcap_32
XFILLER_62_2 VPWR VPWR VGND VGND gf180mcu_fd_sc_mcu7t5v0__fillcap_32
XFILLER_55_136 VPWR VPWR VGND VGND gf180mcu_fd_sc_mcu7t5v0__fillcap_4
XFILLER_24_501 VPWR VPWR VGND VGND gf180mcu_fd_sc_mcu7t5v0__fillcap_4
XFILLER_70_139 VPWR VPWR VGND VGND gf180mcu_fd_sc_mcu7t5v0__fillcap_4
Xclkload4 _168_/CLK clkload4/Z VPWR VPWR VGND VGND gf180mcu_fd_sc_mcu7t5v0__clkbuf_4
XFILLER_50_37 VPWR VPWR VGND VGND gf180mcu_fd_sc_mcu7t5v0__fillcap_64
XFILLER_3_416 VPWR VPWR VGND VGND gf180mcu_fd_sc_mcu7t5v0__fillcap_4
X_166_ _166_/D _167_/RN _168_/CLK _166_/Q VPWR VPWR VGND VGND gf180mcu_fd_sc_mcu7t5v0__dffrnq_1
X_097_ _159_/Q _160_/Q _161_/Q _083_/Z _097_/Z VPWR VPWR VGND VGND gf180mcu_fd_sc_mcu7t5v0__and4_1
XFILLER_37_136 VPWR VPWR VGND VGND gf180mcu_fd_sc_mcu7t5v0__fillcap_4
XFILLER_52_139 VPWR VPWR VGND VGND gf180mcu_fd_sc_mcu7t5v0__fillcap_4
XFILLER_19_136 VPWR VPWR VGND VGND gf180mcu_fd_sc_mcu7t5v0__fillcap_4
XFILLER_34_139 VPWR VPWR VGND VGND gf180mcu_fd_sc_mcu7t5v0__fillcap_4
X_149_ _149_/D _151_/RN _164_/CLK _149_/Q VPWR VPWR VGND VGND gf180mcu_fd_sc_mcu7t5v0__dffrnq_1
XFILLER_7_574 VPWR VPWR VGND VGND gf180mcu_fd_sc_mcu7t5v0__fillcap_16
XFILLER_25_2 VPWR VPWR VGND VGND gf180mcu_fd_sc_mcu7t5v0__fillcap_64
XFILLER_80_278 VPWR VPWR VGND VGND gf180mcu_fd_sc_mcu7t5v0__fillcap_8
XFILLER_44_437 VPWR VPWR VGND VGND gf180mcu_fd_sc_mcu7t5v0__fillcap_64
XFILLER_16_139 VPWR VPWR VGND VGND gf180mcu_fd_sc_mcu7t5v0__fillcap_4
XFILLER_21_72 VPWR VPWR VGND VGND gf180mcu_fd_sc_mcu7t5v0__fillcap_64
XFILLER_58_507 VPWR VPWR VGND VGND gf180mcu_fd_sc_mcu7t5v0__fillcap_64
XFILLER_26_437 VPWR VPWR VGND VGND gf180mcu_fd_sc_mcu7t5v0__fillcap_64
XFILLER_79_142 VPWR VPWR VGND VGND gf180mcu_fd_sc_mcu7t5v0__fillcap_64
XFILLER_0_580 VPWR VPWR VGND VGND gf180mcu_fd_sc_mcu7t5v0__fillcap_16
XFILLER_63_598 VPWR VPWR VGND VGND gf180mcu_fd_sc_mcu7t5v0__fillcap_4
Xclkbuf_2_0__f_clk clkbuf_0_clk/Z _164_/CLK VPWR VPWR VGND VGND gf180mcu_fd_sc_mcu7t5v0__clkbuf_8
XFILLER_45_598 VPWR VPWR VGND VGND gf180mcu_fd_sc_mcu7t5v0__fillcap_4
XFILLER_9_466 VPWR VPWR VGND VGND gf180mcu_fd_sc_mcu7t5v0__fillcap_4
XFILLER_48_37 VPWR VPWR VGND VGND gf180mcu_fd_sc_mcu7t5v0__fillcap_64
XFILLER_58_101 VPWR VPWR VGND VGND gf180mcu_fd_sc_mcu7t5v0__fillcap_4
XFILLER_27_598 VPWR VPWR VGND VGND gf180mcu_fd_sc_mcu7t5v0__fillcap_4
XFILLER_80_57 VPWR VPWR VGND VGND gf180mcu_fd_sc_mcu7t5v0__fillcap_4
XFILLER_41_590 VPWR VPWR VGND VGND gf180mcu_fd_sc_mcu7t5v0__fillcap_8
XFILLER_55_2 VPWR VPWR VGND VGND gf180mcu_fd_sc_mcu7t5v0__fillcap_64
XFILLER_70_107 VPWR VPWR VGND VGND gf180mcu_fd_sc_mcu7t5v0__fillcap_32
XFILLER_74_402 VPWR VPWR VGND VGND gf180mcu_fd_sc_mcu7t5v0__fillcap_4
X_165_ _165_/D _165_/RN _165_/CLK _165_/Q VPWR VPWR VGND VGND gf180mcu_fd_sc_mcu7t5v0__dffrnq_1
XFILLER_23_590 VPWR VPWR VGND VGND gf180mcu_fd_sc_mcu7t5v0__fillcap_8
X_096_ _110_/A2 _098_/A2 _096_/A3 _160_/D VPWR VPWR VGND VGND gf180mcu_fd_sc_mcu7t5v0__and3_1
XFILLER_52_107 VPWR VPWR VGND VGND gf180mcu_fd_sc_mcu7t5v0__fillcap_32
XFILLER_56_402 VPWR VPWR VGND VGND gf180mcu_fd_sc_mcu7t5v0__fillcap_32
XFILLER_20_593 VPWR VPWR VGND VGND gf180mcu_fd_sc_mcu7t5v0__fillcap_8
XFILLER_20_571 VPWR VPWR VGND VGND gf180mcu_fd_sc_mcu7t5v0__fillcap_4
XFILLER_19_72 VPWR VPWR VGND VGND gf180mcu_fd_sc_mcu7t5v0__fillcap_64
XFILLER_47_402 VPWR VPWR VGND VGND gf180mcu_fd_sc_mcu7t5v0__fillcap_64
XFILLER_34_107 VPWR VPWR VGND VGND gf180mcu_fd_sc_mcu7t5v0__fillcap_32
X_148_ _148_/D wire11/Z _164_/CLK _148_/Q VPWR VPWR VGND VGND gf180mcu_fd_sc_mcu7t5v0__dffrnq_1
XFILLER_7_542 VPWR VPWR VGND VGND gf180mcu_fd_sc_mcu7t5v0__fillcap_32
X_079_ _099_/A1 _079_/A2 _078_/Z _156_/D VPWR VPWR VGND VGND gf180mcu_fd_sc_mcu7t5v0__nor3_1
XFILLER_38_402 VPWR VPWR VGND VGND gf180mcu_fd_sc_mcu7t5v0__fillcap_32
XFILLER_18_2 VPWR VPWR VGND VGND gf180mcu_fd_sc_mcu7t5v0__fillcap_32
XFILLER_80_213 VPWR VPWR VGND VGND gf180mcu_fd_sc_mcu7t5v0__fillcap_8
XFILLER_0_206 VPWR VPWR VGND VGND gf180mcu_fd_sc_mcu7t5v0__fillcap_32
XFILLER_56_37 VPWR VPWR VGND VGND gf180mcu_fd_sc_mcu7t5v0__fillcap_64
XFILLER_29_402 VPWR VPWR VGND VGND gf180mcu_fd_sc_mcu7t5v0__fillcap_64
XFILLER_16_107 VPWR VPWR VGND VGND gf180mcu_fd_sc_mcu7t5v0__fillcap_32
XFILLER_4_512 VPWR VPWR VGND VGND gf180mcu_fd_sc_mcu7t5v0__fillcap_32
XFILLER_67_508 VPWR VPWR VGND VGND gf180mcu_fd_sc_mcu7t5v0__fillcap_16
XFILLER_79_346 VPWR VPWR VGND VGND gf180mcu_fd_sc_mcu7t5v0__fillcap_4
XFILLER_72_555 VPWR VPWR VGND VGND gf180mcu_fd_sc_mcu7t5v0__fillcap_16
XFILLER_57_574 VPWR VPWR VGND VGND gf180mcu_fd_sc_mcu7t5v0__fillcap_16
XFILLER_72_577 VPWR VPWR VGND VGND gf180mcu_fd_sc_mcu7t5v0__fillcap_16
XFILLER_4_342 VPWR VPWR VGND VGND gf180mcu_fd_sc_mcu7t5v0__fillcap_32
XFILLER_39_574 VPWR VPWR VGND VGND gf180mcu_fd_sc_mcu7t5v0__fillcap_16
XFILLER_54_577 VPWR VPWR VGND VGND gf180mcu_fd_sc_mcu7t5v0__fillcap_16
XFILLER_27_72 VPWR VPWR VGND VGND gf180mcu_fd_sc_mcu7t5v0__fillcap_64
XFILLER_4_172 VPWR VPWR VGND VGND gf180mcu_fd_sc_mcu7t5v0__fillcap_32
XFILLER_51_536 VPWR VPWR VGND VGND gf180mcu_fd_sc_mcu7t5v0__fillcap_4
XFILLER_36_577 VPWR VPWR VGND VGND gf180mcu_fd_sc_mcu7t5v0__fillcap_16
XFILLER_64_37 VPWR VPWR VGND VGND gf180mcu_fd_sc_mcu7t5v0__fillcap_64
XFILLER_80_36 VPWR VPWR VGND VGND gf180mcu_fd_sc_mcu7t5v0__fillcap_16
XFILLER_1_142 VPWR VPWR VGND VGND gf180mcu_fd_sc_mcu7t5v0__fillcap_64
XFILLER_6_437 VPWR VPWR VGND VGND gf180mcu_fd_sc_mcu7t5v0__fillcap_64
XFILLER_77_422 VPWR VPWR VGND VGND gf180mcu_fd_sc_mcu7t5v0__fillcap_8
XFILLER_33_536 VPWR VPWR VGND VGND gf180mcu_fd_sc_mcu7t5v0__fillcap_4
XFILLER_18_577 VPWR VPWR VGND VGND gf180mcu_fd_sc_mcu7t5v0__fillcap_16
XFILLER_48_2 VPWR VPWR VGND VGND gf180mcu_fd_sc_mcu7t5v0__fillcap_32
Xload_slew18 _167_/RN _169_/RN VPWR VPWR VGND VGND gf180mcu_fd_sc_mcu7t5v0__clkbuf_2
XFILLER_15_536 VPWR VPWR VGND VGND gf180mcu_fd_sc_mcu7t5v0__fillcap_4
X_095_ _117_/ZN _109_/A2 _096_/A3 VPWR VPWR VGND VGND gf180mcu_fd_sc_mcu7t5v0__nand2_1
X_164_ _164_/D _164_/RN _164_/CLK _164_/Q VPWR VPWR VGND VGND gf180mcu_fd_sc_mcu7t5v0__dffrnq_1
XFILLER_2_451 VPWR VPWR VGND VGND gf180mcu_fd_sc_mcu7t5v0__fillcap_4
XFILLER_65_436 VPWR VPWR VGND VGND gf180mcu_fd_sc_mcu7t5v0__fillcap_4
XFILLER_1_66 VPWR VPWR VGND VGND gf180mcu_fd_sc_mcu7t5v0__fillcap_4
XFILLER_62_428 VPWR VPWR VGND VGND gf180mcu_fd_sc_mcu7t5v0__fillcap_4
XFILLER_35_72 VPWR VPWR VGND VGND gf180mcu_fd_sc_mcu7t5v0__fillcap_64
X_078_ _153_/Q _154_/Q _155_/Q _156_/Q _078_/Z VPWR VPWR VGND VGND gf180mcu_fd_sc_mcu7t5v0__and4_1
X_147_ _147_/D _113_/I _164_/CLK _147_/Q VPWR VPWR VGND VGND gf180mcu_fd_sc_mcu7t5v0__dffnsnq_1
XFILLER_7_598 VPWR VPWR VGND VGND gf180mcu_fd_sc_mcu7t5v0__fillcap_4
XFILLER_78_561 VPWR VPWR VGND VGND gf180mcu_fd_sc_mcu7t5v0__fillcap_32
XFILLER_61_472 VPWR VPWR VGND VGND gf180mcu_fd_sc_mcu7t5v0__fillcap_8
XFILLER_61_494 VPWR VPWR VGND VGND gf180mcu_fd_sc_mcu7t5v0__fillcap_32
XFILLER_40_601 VPWR VPWR VGND VGND gf180mcu_fd_sc_mcu7t5v0__fillcap_4
XFILLER_72_37 VPWR VPWR VGND VGND gf180mcu_fd_sc_mcu7t5v0__fillcap_64
XFILLER_4_546 VPWR VPWR VGND VGND gf180mcu_fd_sc_mcu7t5v0__fillcap_32
XFILLER_75_586 VPWR VPWR VGND VGND gf180mcu_fd_sc_mcu7t5v0__fillcap_16
XFILLER_75_542 VPWR VPWR VGND VGND gf180mcu_fd_sc_mcu7t5v0__fillcap_4
XFILLER_43_472 VPWR VPWR VGND VGND gf180mcu_fd_sc_mcu7t5v0__fillcap_64
XFILLER_30_2 VPWR VPWR VGND VGND gf180mcu_fd_sc_mcu7t5v0__fillcap_32
XFILLER_22_601 VPWR VPWR VGND VGND gf180mcu_fd_sc_mcu7t5v0__fillcap_4
XFILLER_57_542 VPWR VPWR VGND VGND gf180mcu_fd_sc_mcu7t5v0__fillcap_32
XFILLER_25_472 VPWR VPWR VGND VGND gf180mcu_fd_sc_mcu7t5v0__fillcap_64
XFILLER_4_376 VPWR VPWR VGND VGND gf180mcu_fd_sc_mcu7t5v0__fillcap_32
XFILLER_78_2 VPWR VPWR VGND VGND gf180mcu_fd_sc_mcu7t5v0__fillcap_32
XFILLER_54_501 VPWR VPWR VGND VGND gf180mcu_fd_sc_mcu7t5v0__fillcap_4
XFILLER_39_542 VPWR VPWR VGND VGND gf180mcu_fd_sc_mcu7t5v0__fillcap_32
XFILLER_1_346 VPWR VPWR VGND VGND gf180mcu_fd_sc_mcu7t5v0__fillcap_4
XFILLER_43_72 VPWR VPWR VGND VGND gf180mcu_fd_sc_mcu7t5v0__fillcap_64
XFILLER_9_402 VPWR VPWR VGND VGND gf180mcu_fd_sc_mcu7t5v0__fillcap_64
XFILLER_36_501 VPWR VPWR VGND VGND gf180mcu_fd_sc_mcu7t5v0__fillcap_4
XFILLER_67_136 VPWR VPWR VGND VGND gf180mcu_fd_sc_mcu7t5v0__fillcap_4
Xfanout21 input1/Z fanout21/Z VPWR VPWR VGND VGND gf180mcu_fd_sc_mcu7t5v0__dlyb_1
XFILLER_8_2 VPWR VPWR VGND VGND gf180mcu_fd_sc_mcu7t5v0__fillcap_32
XFILLER_49_136 VPWR VPWR VGND VGND gf180mcu_fd_sc_mcu7t5v0__fillcap_4
XFILLER_64_139 VPWR VPWR VGND VGND gf180mcu_fd_sc_mcu7t5v0__fillcap_4
XFILLER_18_501 VPWR VPWR VGND VGND gf180mcu_fd_sc_mcu7t5v0__fillcap_4
Xload_slew19 _156_/RN _167_/RN VPWR VPWR VGND VGND gf180mcu_fd_sc_mcu7t5v0__buf_2
XFILLER_46_139 VPWR VPWR VGND VGND gf180mcu_fd_sc_mcu7t5v0__fillcap_4
XFILLER_30_507 VPWR VPWR VGND VGND gf180mcu_fd_sc_mcu7t5v0__fillcap_64
X_094_ _159_/Q _160_/Q _083_/Z _098_/A2 VPWR VPWR VGND VGND gf180mcu_fd_sc_mcu7t5v0__nand3_1
X_163_ _163_/D wire15/Z _163_/CLK _198_/I VPWR VPWR VGND VGND gf180mcu_fd_sc_mcu7t5v0__dffrnq_1
XFILLER_60_2 VPWR VPWR VGND VGND gf180mcu_fd_sc_mcu7t5v0__fillcap_32
XFILLER_56_437 VPWR VPWR VGND VGND gf180mcu_fd_sc_mcu7t5v0__fillcap_64
XFILLER_28_139 VPWR VPWR VGND VGND gf180mcu_fd_sc_mcu7t5v0__fillcap_4
XFILLER_64_470 VPWR VPWR VGND VGND gf180mcu_fd_sc_mcu7t5v0__fillcap_8
XFILLER_12_507 VPWR VPWR VGND VGND gf180mcu_fd_sc_mcu7t5v0__fillcap_64
XFILLER_51_72 VPWR VPWR VGND VGND gf180mcu_fd_sc_mcu7t5v0__fillcap_64
X_077_ _156_/Q _075_/Z _079_/A2 VPWR VPWR VGND VGND gf180mcu_fd_sc_mcu7t5v0__nor2_1
X_146_ _146_/D wire15/Z _163_/CLK _146_/Q VPWR VPWR VGND VGND gf180mcu_fd_sc_mcu7t5v0__dffrnq_1
XFILLER_38_437 VPWR VPWR VGND VGND gf180mcu_fd_sc_mcu7t5v0__fillcap_64
XFILLER_80_226 VPWR VPWR VGND VGND gf180mcu_fd_sc_mcu7t5v0__fillcap_8
XFILLER_75_554 VPWR VPWR VGND VGND gf180mcu_fd_sc_mcu7t5v0__fillcap_32
XFILLER_30_101 VPWR VPWR VGND VGND gf180mcu_fd_sc_mcu7t5v0__fillcap_4
XFILLER_7_66 VPWR VPWR VGND VGND gf180mcu_fd_sc_mcu7t5v0__fillcap_4
X_129_ _164_/Q _165_/Q _129_/Z VPWR VPWR VGND VGND gf180mcu_fd_sc_mcu7t5v0__and2_1
XFILLER_66_554 VPWR VPWR VGND VGND gf180mcu_fd_sc_mcu7t5v0__fillcap_16
XFILLER_23_2 VPWR VPWR VGND VGND gf180mcu_fd_sc_mcu7t5v0__fillcap_64
XFILLER_57_598 VPWR VPWR VGND VGND gf180mcu_fd_sc_mcu7t5v0__fillcap_4
XFILLER_12_101 VPWR VPWR VGND VGND gf180mcu_fd_sc_mcu7t5v0__fillcap_4
XFILLER_71_590 VPWR VPWR VGND VGND gf180mcu_fd_sc_mcu7t5v0__fillcap_8
XFILLER_39_598 VPWR VPWR VGND VGND gf180mcu_fd_sc_mcu7t5v0__fillcap_4
XFILLER_78_37 VPWR VPWR VGND VGND gf180mcu_fd_sc_mcu7t5v0__fillcap_64
XFILLER_76_104 VPWR VPWR VGND VGND gf180mcu_fd_sc_mcu7t5v0__fillcap_32
XFILLER_53_590 VPWR VPWR VGND VGND gf180mcu_fd_sc_mcu7t5v0__fillcap_8
XFILLER_35_590 VPWR VPWR VGND VGND gf180mcu_fd_sc_mcu7t5v0__fillcap_8
XFILLER_10_402 VPWR VPWR VGND VGND gf180mcu_fd_sc_mcu7t5v0__fillcap_32
XFILLER_50_593 VPWR VPWR VGND VGND gf180mcu_fd_sc_mcu7t5v0__fillcap_8
XFILLER_50_571 VPWR VPWR VGND VGND gf180mcu_fd_sc_mcu7t5v0__fillcap_4
XFILLER_64_107 VPWR VPWR VGND VGND gf180mcu_fd_sc_mcu7t5v0__fillcap_32
XFILLER_5_472 VPWR VPWR VGND VGND gf180mcu_fd_sc_mcu7t5v0__fillcap_64
XFILLER_17_590 VPWR VPWR VGND VGND gf180mcu_fd_sc_mcu7t5v0__fillcap_8
XFILLER_32_571 VPWR VPWR VGND VGND gf180mcu_fd_sc_mcu7t5v0__fillcap_4
XFILLER_32_593 VPWR VPWR VGND VGND gf180mcu_fd_sc_mcu7t5v0__fillcap_8
XFILLER_46_107 VPWR VPWR VGND VGND gf180mcu_fd_sc_mcu7t5v0__fillcap_32
X_162_ _162_/D wire11/I _164_/CLK _162_/Q VPWR VPWR VGND VGND gf180mcu_fd_sc_mcu7t5v0__dffrnq_1
X_093_ _099_/A1 _090_/Z _093_/A3 _093_/B _110_/A2 VPWR VPWR VGND VGND gf180mcu_fd_sc_mcu7t5v0__oai31_2
XFILLER_49_72 VPWR VPWR VGND VGND gf180mcu_fd_sc_mcu7t5v0__fillcap_64
XFILLER_77_276 VPWR VPWR VGND VGND gf180mcu_fd_sc_mcu7t5v0__fillcap_4
XFILLER_14_593 VPWR VPWR VGND VGND gf180mcu_fd_sc_mcu7t5v0__fillcap_8
XFILLER_14_571 VPWR VPWR VGND VGND gf180mcu_fd_sc_mcu7t5v0__fillcap_4
XFILLER_53_2 VPWR VPWR VGND VGND gf180mcu_fd_sc_mcu7t5v0__fillcap_64
Xinput1 rst_n input1/Z VPWR VPWR VGND VGND gf180mcu_fd_sc_mcu7t5v0__buf_1
XFILLER_28_107 VPWR VPWR VGND VGND gf180mcu_fd_sc_mcu7t5v0__fillcap_32
XFILLER_3_206 VPWR VPWR VGND VGND gf180mcu_fd_sc_mcu7t5v0__fillcap_4
X_145_ _145_/D wire16/I _156_/CLK _145_/Q VPWR VPWR VGND VGND gf180mcu_fd_sc_mcu7t5v0__dffrnq_2
XFILLER_11_574 VPWR VPWR VGND VGND gf180mcu_fd_sc_mcu7t5v0__fillcap_16
X_076_ _099_/A1 _076_/A2 _075_/Z _155_/D VPWR VPWR VGND VGND gf180mcu_fd_sc_mcu7t5v0__nor3_1
XFILLER_76_70 VPWR VPWR VGND VGND gf180mcu_fd_sc_mcu7t5v0__fillcap_32
Xu_ihsan_sa_pll.u_obs_obuf _107_/ZN _196_/I VPWR VPWR VGND VGND gf180mcu_fd_sc_mcu7t5v0__clkbuf_8
XFILLER_69_574 VPWR VPWR VGND VGND gf180mcu_fd_sc_mcu7t5v0__fillcap_16
X_128_ _128_/A1 _169_/Q _128_/Z VPWR VPWR VGND VGND gf180mcu_fd_sc_mcu7t5v0__and2_1
XFILLER_66_577 VPWR VPWR VGND VGND gf180mcu_fd_sc_mcu7t5v0__fillcap_16
XFILLER_16_2 VPWR VPWR VGND VGND gf180mcu_fd_sc_mcu7t5v0__fillcap_32
XFILLER_76_308 VPWR VPWR VGND VGND gf180mcu_fd_sc_mcu7t5v0__fillcap_32
XFILLER_80_580 VPWR VPWR VGND VGND gf180mcu_fd_sc_mcu7t5v0__fillcap_16
XFILLER_8_139 VPWR VPWR VGND VGND gf180mcu_fd_sc_mcu7t5v0__fillcap_4
XFILLER_63_558 VPWR VPWR VGND VGND gf180mcu_fd_sc_mcu7t5v0__fillcap_32
XFILLER_48_577 VPWR VPWR VGND VGND gf180mcu_fd_sc_mcu7t5v0__fillcap_16
XFILLER_57_72 VPWR VPWR VGND VGND gf180mcu_fd_sc_mcu7t5v0__fillcap_64
XFILLER_31_466 VPWR VPWR VGND VGND gf180mcu_fd_sc_mcu7t5v0__fillcap_4
XFILLER_45_536 VPWR VPWR VGND VGND gf180mcu_fd_sc_mcu7t5v0__fillcap_4
XFILLER_76_138 VPWR VPWR VGND VGND gf180mcu_fd_sc_mcu7t5v0__fillcap_32
XFILLER_13_466 VPWR VPWR VGND VGND gf180mcu_fd_sc_mcu7t5v0__fillcap_4
XFILLER_27_536 VPWR VPWR VGND VGND gf180mcu_fd_sc_mcu7t5v0__fillcap_4
XFILLER_13_66 VPWR VPWR VGND VGND gf180mcu_fd_sc_mcu7t5v0__fillcap_4
XFILLER_70_601 VPWR VPWR VGND VGND gf180mcu_fd_sc_mcu7t5v0__fillcap_4
XFILLER_74_417 VPWR VPWR VGND VGND gf180mcu_fd_sc_mcu7t5v0__fillcap_16
X_161_ _161_/D _161_/RN _161_/CLK _161_/Q VPWR VPWR VGND VGND gf180mcu_fd_sc_mcu7t5v0__dffrnq_1
X_092_ _090_/Z _093_/A3 _109_/A3 VPWR VPWR VGND VGND gf180mcu_fd_sc_mcu7t5v0__nor2_1
XFILLER_65_72 VPWR VPWR VGND VGND gf180mcu_fd_sc_mcu7t5v0__fillcap_64
XFILLER_46_2 VPWR VPWR VGND VGND gf180mcu_fd_sc_mcu7t5v0__fillcap_32
Xinput2 ui_in[0] _131_/B VPWR VPWR VGND VGND gf180mcu_fd_sc_mcu7t5v0__buf_1
XFILLER_52_601 VPWR VPWR VGND VGND gf180mcu_fd_sc_mcu7t5v0__fillcap_4
XFILLER_55_472 VPWR VPWR VGND VGND gf180mcu_fd_sc_mcu7t5v0__fillcap_64
X_075_ _153_/Q _154_/Q _155_/Q _075_/Z VPWR VPWR VGND VGND gf180mcu_fd_sc_mcu7t5v0__and3_1
X_144_ _144_/D wire16/Z _163_/CLK _144_/Q VPWR VPWR VGND VGND gf180mcu_fd_sc_mcu7t5v0__dffrnq_1
XFILLER_11_542 VPWR VPWR VGND VGND gf180mcu_fd_sc_mcu7t5v0__fillcap_32
XFILLER_78_597 VPWR VPWR VGND VGND gf180mcu_fd_sc_mcu7t5v0__fillcap_8
XFILLER_34_601 VPWR VPWR VGND VGND gf180mcu_fd_sc_mcu7t5v0__fillcap_4
XFILLER_69_542 VPWR VPWR VGND VGND gf180mcu_fd_sc_mcu7t5v0__fillcap_32
XFILLER_37_472 VPWR VPWR VGND VGND gf180mcu_fd_sc_mcu7t5v0__fillcap_64
XFILLER_21_66 VPWR VPWR VGND VGND gf180mcu_fd_sc_mcu7t5v0__fillcap_4
XFILLER_16_601 VPWR VPWR VGND VGND gf180mcu_fd_sc_mcu7t5v0__fillcap_4
X_127_ _164_/Q _126_/Z _147_/D VPWR VPWR VGND VGND gf180mcu_fd_sc_mcu7t5v0__or2_1
XFILLER_19_472 VPWR VPWR VGND VGND gf180mcu_fd_sc_mcu7t5v0__fillcap_64
XFILLER_21_136 VPWR VPWR VGND VGND gf180mcu_fd_sc_mcu7t5v0__fillcap_4
XFILLER_8_107 VPWR VPWR VGND VGND gf180mcu_fd_sc_mcu7t5v0__fillcap_32
Xclkbuf_0_u_ihsan_sa_pll.clk_pre_regs clkbuf_regs_0_clk_pre/Z clkbuf_0_u_ihsan_sa_pll.clk_pre_regs/Z
+ VPWR VPWR VGND VGND gf180mcu_fd_sc_mcu7t5v0__clkbuf_8
XFILLER_48_501 VPWR VPWR VGND VGND gf180mcu_fd_sc_mcu7t5v0__fillcap_4
XFILLER_79_136 VPWR VPWR VGND VGND gf180mcu_fd_sc_mcu7t5v0__fillcap_4
XFILLER_0_596 VPWR VPWR VGND VGND gf180mcu_fd_sc_mcu7t5v0__fillcap_8
XFILLER_73_72 VPWR VPWR VGND VGND gf180mcu_fd_sc_mcu7t5v0__fillcap_64
XFILLER_60_507 VPWR VPWR VGND VGND gf180mcu_fd_sc_mcu7t5v0__fillcap_64
XFILLER_4_36 VPWR VPWR VGND VGND gf180mcu_fd_sc_mcu7t5v0__fillcap_32
XFILLER_76_2 VPWR VPWR VGND VGND gf180mcu_fd_sc_mcu7t5v0__fillcap_32
XFILLER_58_139 VPWR VPWR VGND VGND gf180mcu_fd_sc_mcu7t5v0__fillcap_4
XFILLER_42_507 VPWR VPWR VGND VGND gf180mcu_fd_sc_mcu7t5v0__fillcap_64
Xfanout13 fanout21/Z wire16/I VPWR VPWR VGND VGND gf180mcu_fd_sc_mcu7t5v0__dlyb_1
XFILLER_10_437 VPWR VPWR VGND VGND gf180mcu_fd_sc_mcu7t5v0__fillcap_64
XFILLER_68_437 VPWR VPWR VGND VGND gf180mcu_fd_sc_mcu7t5v0__fillcap_4
XFILLER_24_507 VPWR VPWR VGND VGND gf180mcu_fd_sc_mcu7t5v0__fillcap_64
X_160_ _160_/D _161_/RN _161_/CLK _160_/Q VPWR VPWR VGND VGND gf180mcu_fd_sc_mcu7t5v0__dffrnq_1
X_091_ _125_/A2 _160_/Q _161_/Q _162_/Q _093_/A3 VPWR VPWR VGND VGND gf180mcu_fd_sc_mcu7t5v0__nor4_2
XFILLER_6_2 VPWR VPWR VGND VGND gf180mcu_fd_sc_mcu7t5v0__fillcap_32
XFILLER_77_212 VPWR VPWR VGND VGND gf180mcu_fd_sc_mcu7t5v0__fillcap_64
XFILLER_60_101 VPWR VPWR VGND VGND gf180mcu_fd_sc_mcu7t5v0__fillcap_4
XFILLER_39_2 VPWR VPWR VGND VGND gf180mcu_fd_sc_mcu7t5v0__fillcap_64
Xinput3 ui_in[1] _130_/B VPWR VPWR VGND VGND gf180mcu_fd_sc_mcu7t5v0__buf_1
XFILLER_19_66 VPWR VPWR VGND VGND gf180mcu_fd_sc_mcu7t5v0__fillcap_4
XFILLER_42_101 VPWR VPWR VGND VGND gf180mcu_fd_sc_mcu7t5v0__fillcap_4
X_074_ _153_/Q _154_/Q _155_/Q _076_/A2 VPWR VPWR VGND VGND gf180mcu_fd_sc_mcu7t5v0__aoi21_1
X_143_ _143_/D wire11/Z _164_/CLK _143_/Q VPWR VPWR VGND VGND gf180mcu_fd_sc_mcu7t5v0__dffrnq_1
XFILLER_7_536 VPWR VPWR VGND VGND gf180mcu_fd_sc_mcu7t5v0__fillcap_4
XFILLER_11_598 VPWR VPWR VGND VGND gf180mcu_fd_sc_mcu7t5v0__fillcap_4
XFILLER_2_241 VPWR VPWR VGND VGND gf180mcu_fd_sc_mcu7t5v0__fillcap_4
XFILLER_61_410 VPWR VPWR VGND VGND gf180mcu_fd_sc_mcu7t5v0__fillcap_4
XFILLER_69_598 VPWR VPWR VGND VGND gf180mcu_fd_sc_mcu7t5v0__fillcap_4
XFILLER_24_101 VPWR VPWR VGND VGND gf180mcu_fd_sc_mcu7t5v0__fillcap_4
X_126_ _143_/Q _165_/Q _126_/Z VPWR VPWR VGND VGND gf180mcu_fd_sc_mcu7t5v0__or2_1
XFILLER_3_594 VPWR VPWR VGND VGND gf180mcu_fd_sc_mcu7t5v0__fillcap_8
XFILLER_65_590 VPWR VPWR VGND VGND gf180mcu_fd_sc_mcu7t5v0__fillcap_8
XFILLER_40_402 VPWR VPWR VGND VGND gf180mcu_fd_sc_mcu7t5v0__fillcap_32
XFILLER_31_402 VPWR VPWR VGND VGND gf180mcu_fd_sc_mcu7t5v0__fillcap_64
X_109_ _125_/A2 _109_/A2 _109_/A3 _109_/B _110_/B VPWR VPWR VGND VGND gf180mcu_fd_sc_mcu7t5v0__oai31_1
XFILLER_47_590 VPWR VPWR VGND VGND gf180mcu_fd_sc_mcu7t5v0__fillcap_8
XFILLER_21_2 VPWR VPWR VGND VGND gf180mcu_fd_sc_mcu7t5v0__fillcap_64
XFILLER_62_593 VPWR VPWR VGND VGND gf180mcu_fd_sc_mcu7t5v0__fillcap_8
XFILLER_22_402 VPWR VPWR VGND VGND gf180mcu_fd_sc_mcu7t5v0__fillcap_32
Xclkbuf_1_0__f_u_ihsan_sa_pll.clk_pre clkbuf_0_u_ihsan_sa_pll.clk_pre/Z _128_/A1 VPWR
+ VPWR VGND VGND gf180mcu_fd_sc_mcu7t5v0__clkbuf_8
XFILLER_27_66 VPWR VPWR VGND VGND gf180mcu_fd_sc_mcu7t5v0__fillcap_4
XFILLER_13_402 VPWR VPWR VGND VGND gf180mcu_fd_sc_mcu7t5v0__fillcap_64
XFILLER_29_590 VPWR VPWR VGND VGND gf180mcu_fd_sc_mcu7t5v0__fillcap_8
XFILLER_44_593 VPWR VPWR VGND VGND gf180mcu_fd_sc_mcu7t5v0__fillcap_8
XFILLER_44_571 VPWR VPWR VGND VGND gf180mcu_fd_sc_mcu7t5v0__fillcap_4
XFILLER_69_2 VPWR VPWR VGND VGND gf180mcu_fd_sc_mcu7t5v0__fillcap_64
XFILLER_58_107 VPWR VPWR VGND VGND gf180mcu_fd_sc_mcu7t5v0__fillcap_32
XFILLER_1_136 VPWR VPWR VGND VGND gf180mcu_fd_sc_mcu7t5v0__fillcap_4
XFILLER_41_574 VPWR VPWR VGND VGND gf180mcu_fd_sc_mcu7t5v0__fillcap_16
XFILLER_26_571 VPWR VPWR VGND VGND gf180mcu_fd_sc_mcu7t5v0__fillcap_4
XFILLER_26_593 VPWR VPWR VGND VGND gf180mcu_fd_sc_mcu7t5v0__fillcap_8
XFILLER_79_72 VPWR VPWR VGND VGND gf180mcu_fd_sc_mcu7t5v0__fillcap_64
XFILLER_59_438 VPWR VPWR VGND VGND gf180mcu_fd_sc_mcu7t5v0__fillcap_32
XFILLER_23_574 VPWR VPWR VGND VGND gf180mcu_fd_sc_mcu7t5v0__fillcap_16
X_090_ _125_/A2 _160_/Q _161_/Q _162_/Q _090_/Z VPWR VPWR VGND VGND gf180mcu_fd_sc_mcu7t5v0__and4_1
Xinput4 ui_in[2] input4/Z VPWR VPWR VGND VGND gf180mcu_fd_sc_mcu7t5v0__buf_1
Xclkbuf_2_1__f_clk clkbuf_0_clk/Z _161_/CLK VPWR VPWR VGND VGND gf180mcu_fd_sc_mcu7t5v0__clkbuf_8
XFILLER_64_430 VPWR VPWR VGND VGND gf180mcu_fd_sc_mcu7t5v0__fillcap_4
XFILLER_20_577 VPWR VPWR VGND VGND gf180mcu_fd_sc_mcu7t5v0__fillcap_16
X_142_ _147_/Q _122_/Z _142_/A3 _151_/D VPWR VPWR VGND VGND gf180mcu_fd_sc_mcu7t5v0__nor3_1
XFILLER_35_66 VPWR VPWR VGND VGND gf180mcu_fd_sc_mcu7t5v0__fillcap_4
X_073_ _153_/Q _154_/Q _073_/B _154_/D VPWR VPWR VGND VGND gf180mcu_fd_sc_mcu7t5v0__aoi21_1
XFILLER_69_522 VPWR VPWR VGND VGND gf180mcu_fd_sc_mcu7t5v0__fillcap_4
XFILLER_51_2 VPWR VPWR VGND VGND gf180mcu_fd_sc_mcu7t5v0__fillcap_64
XFILLER_43_466 VPWR VPWR VGND VGND gf180mcu_fd_sc_mcu7t5v0__fillcap_4
X_125_ _164_/Q _125_/A2 _125_/Z VPWR VPWR VGND VGND gf180mcu_fd_sc_mcu7t5v0__and2_1
XFILLER_3_562 VPWR VPWR VGND VGND gf180mcu_fd_sc_mcu7t5v0__fillcap_32
XFILLER_57_536 VPWR VPWR VGND VGND gf180mcu_fd_sc_mcu7t5v0__fillcap_4
XFILLER_25_466 VPWR VPWR VGND VGND gf180mcu_fd_sc_mcu7t5v0__fillcap_4
X_108_ _111_/A1 _113_/ZN _164_/RN VPWR VPWR VGND VGND gf180mcu_fd_sc_mcu7t5v0__nor2_1
XFILLER_78_171 VPWR VPWR VGND VGND gf180mcu_fd_sc_mcu7t5v0__fillcap_4
XFILLER_39_536 VPWR VPWR VGND VGND gf180mcu_fd_sc_mcu7t5v0__fillcap_4
XFILLER_14_2 VPWR VPWR VGND VGND gf180mcu_fd_sc_mcu7t5v0__fillcap_32
XFILLER_43_66 VPWR VPWR VGND VGND gf180mcu_fd_sc_mcu7t5v0__fillcap_4
XFILLER_41_542 VPWR VPWR VGND VGND gf180mcu_fd_sc_mcu7t5v0__fillcap_32
XFILLER_64_601 VPWR VPWR VGND VGND gf180mcu_fd_sc_mcu7t5v0__fillcap_4
XFILLER_68_428 VPWR VPWR VGND VGND gf180mcu_fd_sc_mcu7t5v0__fillcap_4
XFILLER_23_542 VPWR VPWR VGND VGND gf180mcu_fd_sc_mcu7t5v0__fillcap_32
XFILLER_46_601 VPWR VPWR VGND VGND gf180mcu_fd_sc_mcu7t5v0__fillcap_4
XFILLER_2_457 VPWR VPWR VGND VGND gf180mcu_fd_sc_mcu7t5v0__fillcap_64
Xinput5 ui_in[6] _145_/D VPWR VPWR VGND VGND gf180mcu_fd_sc_mcu7t5v0__buf_1
XFILLER_49_472 VPWR VPWR VGND VGND gf180mcu_fd_sc_mcu7t5v0__fillcap_64
XFILLER_51_136 VPWR VPWR VGND VGND gf180mcu_fd_sc_mcu7t5v0__fillcap_4
XFILLER_20_501 VPWR VPWR VGND VGND gf180mcu_fd_sc_mcu7t5v0__fillcap_4
XFILLER_10_37 VPWR VPWR VGND VGND gf180mcu_fd_sc_mcu7t5v0__fillcap_64
XFILLER_9_590 VPWR VPWR VGND VGND gf180mcu_fd_sc_mcu7t5v0__fillcap_8
XFILLER_28_601 VPWR VPWR VGND VGND gf180mcu_fd_sc_mcu7t5v0__fillcap_4
X_141_ _151_/Q _121_/Z _142_/A3 VPWR VPWR VGND VGND gf180mcu_fd_sc_mcu7t5v0__nor2_1
XFILLER_51_66 VPWR VPWR VGND VGND gf180mcu_fd_sc_mcu7t5v0__fillcap_4
X_072_ _153_/Q _154_/Q _109_/B _073_/B VPWR VPWR VGND VGND gf180mcu_fd_sc_mcu7t5v0__oai21_1
XFILLER_33_136 VPWR VPWR VGND VGND gf180mcu_fd_sc_mcu7t5v0__fillcap_4
XFILLER_6_571 VPWR VPWR VGND VGND gf180mcu_fd_sc_mcu7t5v0__fillcap_4
XFILLER_44_2 VPWR VPWR VGND VGND gf180mcu_fd_sc_mcu7t5v0__fillcap_32
XFILLER_6_593 VPWR VPWR VGND VGND gf180mcu_fd_sc_mcu7t5v0__fillcap_8
XFILLER_15_136 VPWR VPWR VGND VGND gf180mcu_fd_sc_mcu7t5v0__fillcap_4
X_124_ _147_/Q _123_/Z _152_/D VPWR VPWR VGND VGND gf180mcu_fd_sc_mcu7t5v0__nor2_1
XFILLER_30_139 VPWR VPWR VGND VGND gf180mcu_fd_sc_mcu7t5v0__fillcap_4
XFILLER_72_507 VPWR VPWR VGND VGND gf180mcu_fd_sc_mcu7t5v0__fillcap_4
XFILLER_40_437 VPWR VPWR VGND VGND gf180mcu_fd_sc_mcu7t5v0__fillcap_64
XFILLER_12_139 VPWR VPWR VGND VGND gf180mcu_fd_sc_mcu7t5v0__fillcap_4
X_107_ _107_/A1 input6/Z _107_/B _107_/ZN VPWR VPWR VGND VGND gf180mcu_fd_sc_mcu7t5v0__oai21_1
XFILLER_54_507 VPWR VPWR VGND VGND gf180mcu_fd_sc_mcu7t5v0__fillcap_64
XFILLER_22_437 VPWR VPWR VGND VGND gf180mcu_fd_sc_mcu7t5v0__fillcap_64
XFILLER_36_507 VPWR VPWR VGND VGND gf180mcu_fd_sc_mcu7t5v0__fillcap_64
XFILLER_72_101 VPWR VPWR VGND VGND gf180mcu_fd_sc_mcu7t5v0__fillcap_4
XFILLER_18_507 VPWR VPWR VGND VGND gf180mcu_fd_sc_mcu7t5v0__fillcap_64
XFILLER_41_598 VPWR VPWR VGND VGND gf180mcu_fd_sc_mcu7t5v0__fillcap_4
Xclkbuf_1_0__f_u_ihsan_sa_pll.clk_fb_int_regs clkbuf_0_u_ihsan_sa_pll.clk_fb_int_regs/Z
+ _165_/CLK VPWR VPWR VGND VGND gf180mcu_fd_sc_mcu7t5v0__clkbuf_8
XFILLER_5_466 VPWR VPWR VGND VGND gf180mcu_fd_sc_mcu7t5v0__fillcap_4
XFILLER_74_2 VPWR VPWR VGND VGND gf180mcu_fd_sc_mcu7t5v0__fillcap_32
XFILLER_54_101 VPWR VPWR VGND VGND gf180mcu_fd_sc_mcu7t5v0__fillcap_4
XFILLER_23_598 VPWR VPWR VGND VGND gf180mcu_fd_sc_mcu7t5v0__fillcap_4
XFILLER_49_66 VPWR VPWR VGND VGND gf180mcu_fd_sc_mcu7t5v0__fillcap_4
Xinput6 ui_in[7] input6/Z VPWR VPWR VGND VGND gf180mcu_fd_sc_mcu7t5v0__buf_1
XFILLER_64_443 VPWR VPWR VGND VGND gf180mcu_fd_sc_mcu7t5v0__fillcap_16
XFILLER_36_101 VPWR VPWR VGND VGND gf180mcu_fd_sc_mcu7t5v0__fillcap_4
Xdelaybuf_0_clk_pre _172_/Q delaybuf_0_clk_pre/Z VPWR VPWR VGND VGND gf180mcu_fd_sc_mcu7t5v0__clkbuf_8
X_071_ _153_/Q _099_/A1 _153_/D VPWR VPWR VGND VGND gf180mcu_fd_sc_mcu7t5v0__nor2_1
X_140_ _147_/Q _121_/Z _140_/A3 _150_/D VPWR VPWR VGND VGND gf180mcu_fd_sc_mcu7t5v0__nor3_1
XFILLER_4_2 VPWR VPWR VGND VGND gf180mcu_fd_sc_mcu7t5v0__fillcap_32
XFILLER_18_101 VPWR VPWR VGND VGND gf180mcu_fd_sc_mcu7t5v0__fillcap_4
XFILLER_61_402 VPWR VPWR VGND VGND gf180mcu_fd_sc_mcu7t5v0__fillcap_8
XFILLER_69_535 VPWR VPWR VGND VGND gf180mcu_fd_sc_mcu7t5v0__fillcap_4
XFILLER_37_2 VPWR VPWR VGND VGND gf180mcu_fd_sc_mcu7t5v0__fillcap_64
XFILLER_52_402 VPWR VPWR VGND VGND gf180mcu_fd_sc_mcu7t5v0__fillcap_32
XFILLER_30_107 VPWR VPWR VGND VGND gf180mcu_fd_sc_mcu7t5v0__fillcap_32
XFILLER_43_402 VPWR VPWR VGND VGND gf180mcu_fd_sc_mcu7t5v0__fillcap_64
X_123_ _135_/A1 _122_/Z _123_/Z VPWR VPWR VGND VGND gf180mcu_fd_sc_mcu7t5v0__xor2_1
XFILLER_74_593 VPWR VPWR VGND VGND gf180mcu_fd_sc_mcu7t5v0__fillcap_8
XFILLER_59_590 VPWR VPWR VGND VGND gf180mcu_fd_sc_mcu7t5v0__fillcap_8
XFILLER_34_402 VPWR VPWR VGND VGND gf180mcu_fd_sc_mcu7t5v0__fillcap_32
XFILLER_80_574 VPWR VPWR VGND VGND gf180mcu_fd_sc_mcu7t5v0__fillcap_4
XFILLER_80_596 VPWR VPWR VGND VGND gf180mcu_fd_sc_mcu7t5v0__fillcap_8
XFILLER_16_37 VPWR VPWR VGND VGND gf180mcu_fd_sc_mcu7t5v0__fillcap_64
XFILLER_12_107 VPWR VPWR VGND VGND gf180mcu_fd_sc_mcu7t5v0__fillcap_32
XFILLER_25_402 VPWR VPWR VGND VGND gf180mcu_fd_sc_mcu7t5v0__fillcap_64
XFILLER_0_512 VPWR VPWR VGND VGND gf180mcu_fd_sc_mcu7t5v0__fillcap_32
XFILLER_56_593 VPWR VPWR VGND VGND gf180mcu_fd_sc_mcu7t5v0__fillcap_8
XFILLER_56_571 VPWR VPWR VGND VGND gf180mcu_fd_sc_mcu7t5v0__fillcap_4
XFILLER_57_66 VPWR VPWR VGND VGND gf180mcu_fd_sc_mcu7t5v0__fillcap_4
XFILLER_16_402 VPWR VPWR VGND VGND gf180mcu_fd_sc_mcu7t5v0__fillcap_32
XFILLER_71_574 VPWR VPWR VGND VGND gf180mcu_fd_sc_mcu7t5v0__fillcap_16
XFILLER_8_601 VPWR VPWR VGND VGND gf180mcu_fd_sc_mcu7t5v0__fillcap_4
X_106_ _170_/Q input6/Z _107_/B VPWR VPWR VGND VGND gf180mcu_fd_sc_mcu7t5v0__nand2_1
XFILLER_38_593 VPWR VPWR VGND VGND gf180mcu_fd_sc_mcu7t5v0__fillcap_8
XFILLER_38_571 VPWR VPWR VGND VGND gf180mcu_fd_sc_mcu7t5v0__fillcap_4
XFILLER_53_574 VPWR VPWR VGND VGND gf180mcu_fd_sc_mcu7t5v0__fillcap_16
Xclkbuf_0_u_ihsan_sa_pll.clk_fb_int_regs clkbuf_regs_1_clk_pre/Z clkbuf_0_u_ihsan_sa_pll.clk_fb_int_regs/Z
+ VPWR VPWR VGND VGND gf180mcu_fd_sc_mcu7t5v0__clkbuf_8
XFILLER_0_342 VPWR VPWR VGND VGND gf180mcu_fd_sc_mcu7t5v0__fillcap_32
Xfanout17 fanout21/Z _168_/RN VPWR VPWR VGND VGND gf180mcu_fd_sc_mcu7t5v0__dlyb_1
XFILLER_50_577 VPWR VPWR VGND VGND gf180mcu_fd_sc_mcu7t5v0__fillcap_16
XFILLER_35_574 VPWR VPWR VGND VGND gf180mcu_fd_sc_mcu7t5v0__fillcap_16
XFILLER_76_452 VPWR VPWR VGND VGND gf180mcu_fd_sc_mcu7t5v0__fillcap_4
XFILLER_0_172 VPWR VPWR VGND VGND gf180mcu_fd_sc_mcu7t5v0__fillcap_32
XFILLER_32_577 VPWR VPWR VGND VGND gf180mcu_fd_sc_mcu7t5v0__fillcap_16
XFILLER_17_574 VPWR VPWR VGND VGND gf180mcu_fd_sc_mcu7t5v0__fillcap_16
XFILLER_67_2 VPWR VPWR VGND VGND gf180mcu_fd_sc_mcu7t5v0__fillcap_64
XFILLER_5_72 VPWR VPWR VGND VGND gf180mcu_fd_sc_mcu7t5v0__fillcap_64
XFILLER_24_37 VPWR VPWR VGND VGND gf180mcu_fd_sc_mcu7t5v0__fillcap_64
XFILLER_65_66 VPWR VPWR VGND VGND gf180mcu_fd_sc_mcu7t5v0__fillcap_4
XFILLER_14_577 VPWR VPWR VGND VGND gf180mcu_fd_sc_mcu7t5v0__fillcap_16
XFILLER_1_492 VPWR VPWR VGND VGND gf180mcu_fd_sc_mcu7t5v0__fillcap_64
Xinput7 uio_in[0] _144_/D VPWR VPWR VGND VGND gf180mcu_fd_sc_mcu7t5v0__buf_1
XFILLER_55_466 VPWR VPWR VGND VGND gf180mcu_fd_sc_mcu7t5v0__fillcap_4
X_070_ _145_/Q _116_/ZN _099_/A1 VPWR VPWR VGND VGND gf180mcu_fd_sc_mcu7t5v0__nand2_1
XFILLER_11_536 VPWR VPWR VGND VGND gf180mcu_fd_sc_mcu7t5v0__fillcap_4
XFILLER_37_466 VPWR VPWR VGND VGND gf180mcu_fd_sc_mcu7t5v0__fillcap_4
X_122_ _151_/Q _121_/Z _122_/Z VPWR VPWR VGND VGND gf180mcu_fd_sc_mcu7t5v0__and2_1
XFILLER_78_311 VPWR VPWR VGND VGND gf180mcu_fd_sc_mcu7t5v0__fillcap_4
XFILLER_19_466 VPWR VPWR VGND VGND gf180mcu_fd_sc_mcu7t5v0__fillcap_4
XFILLER_32_37 VPWR VPWR VGND VGND gf180mcu_fd_sc_mcu7t5v0__fillcap_64
XFILLER_0_546 VPWR VPWR VGND VGND gf180mcu_fd_sc_mcu7t5v0__fillcap_32
XFILLER_71_542 VPWR VPWR VGND VGND gf180mcu_fd_sc_mcu7t5v0__fillcap_32
XFILLER_73_66 VPWR VPWR VGND VGND gf180mcu_fd_sc_mcu7t5v0__fillcap_4
X_105_ _167_/Q _166_/Q _134_/A1 _134_/A2 _168_/D VPWR VPWR VGND VGND gf180mcu_fd_sc_mcu7t5v0__and4_1
XFILLER_62_542 VPWR VPWR VGND VGND gf180mcu_fd_sc_mcu7t5v0__fillcap_32
XFILLER_53_542 VPWR VPWR VGND VGND gf180mcu_fd_sc_mcu7t5v0__fillcap_32
XFILLER_21_472 VPWR VPWR VGND VGND gf180mcu_fd_sc_mcu7t5v0__fillcap_64
XFILLER_4_104 VPWR VPWR VGND VGND gf180mcu_fd_sc_mcu7t5v0__fillcap_32
XFILLER_0_376 VPWR VPWR VGND VGND gf180mcu_fd_sc_mcu7t5v0__fillcap_32
Xclkbuf_0_u_ihsan_sa_pll.clk_fb_int _128_/Z clkbuf_0_u_ihsan_sa_pll.clk_fb_int/Z VPWR
+ VPWR VGND VGND gf180mcu_fd_sc_mcu7t5v0__clkbuf_8
XFILLER_50_501 VPWR VPWR VGND VGND gf180mcu_fd_sc_mcu7t5v0__fillcap_4
XFILLER_35_542 VPWR VPWR VGND VGND gf180mcu_fd_sc_mcu7t5v0__fillcap_32
XFILLER_12_2 VPWR VPWR VGND VGND gf180mcu_fd_sc_mcu7t5v0__fillcap_32
XFILLER_58_601 VPWR VPWR VGND VGND gf180mcu_fd_sc_mcu7t5v0__fillcap_4
XFILLER_77_409 VPWR VPWR VGND VGND gf180mcu_fd_sc_mcu7t5v0__fillcap_8
XFILLER_5_402 VPWR VPWR VGND VGND gf180mcu_fd_sc_mcu7t5v0__fillcap_64
XFILLER_63_136 VPWR VPWR VGND VGND gf180mcu_fd_sc_mcu7t5v0__fillcap_4
XFILLER_17_542 VPWR VPWR VGND VGND gf180mcu_fd_sc_mcu7t5v0__fillcap_32
XFILLER_32_501 VPWR VPWR VGND VGND gf180mcu_fd_sc_mcu7t5v0__fillcap_4
XFILLER_40_37 VPWR VPWR VGND VGND gf180mcu_fd_sc_mcu7t5v0__fillcap_64
XFILLER_77_206 VPWR VPWR VGND VGND gf180mcu_fd_sc_mcu7t5v0__fillcap_4
XFILLER_45_136 VPWR VPWR VGND VGND gf180mcu_fd_sc_mcu7t5v0__fillcap_4
XFILLER_60_139 VPWR VPWR VGND VGND gf180mcu_fd_sc_mcu7t5v0__fillcap_4
XFILLER_14_501 VPWR VPWR VGND VGND gf180mcu_fd_sc_mcu7t5v0__fillcap_4
Xinput8 uio_in[1] _146_/D VPWR VPWR VGND VGND gf180mcu_fd_sc_mcu7t5v0__buf_1
XFILLER_64_478 VPWR VPWR VGND VGND gf180mcu_fd_sc_mcu7t5v0__fillcap_4
XFILLER_27_136 VPWR VPWR VGND VGND gf180mcu_fd_sc_mcu7t5v0__fillcap_4
XFILLER_42_139 VPWR VPWR VGND VGND gf180mcu_fd_sc_mcu7t5v0__fillcap_4
X_198_ _198_/I uo_out[2] VPWR VPWR VGND VGND gf180mcu_fd_sc_mcu7t5v0__buf_2
XFILLER_52_437 VPWR VPWR VGND VGND gf180mcu_fd_sc_mcu7t5v0__fillcap_64
XFILLER_24_139 VPWR VPWR VGND VGND gf180mcu_fd_sc_mcu7t5v0__fillcap_4
X_121_ _149_/Q _150_/Q _148_/Q _121_/Z VPWR VPWR VGND VGND gf180mcu_fd_sc_mcu7t5v0__and3_1
XFILLER_11_72 VPWR VPWR VGND VGND gf180mcu_fd_sc_mcu7t5v0__fillcap_64
XFILLER_66_507 VPWR VPWR VGND VGND gf180mcu_fd_sc_mcu7t5v0__fillcap_4
XFILLER_34_437 VPWR VPWR VGND VGND gf180mcu_fd_sc_mcu7t5v0__fillcap_64
XFILLER_42_2 VPWR VPWR VGND VGND gf180mcu_fd_sc_mcu7t5v0__fillcap_32
XFILLER_4_308 VPWR VPWR VGND VGND gf180mcu_fd_sc_mcu7t5v0__fillcap_32
XFILLER_48_507 VPWR VPWR VGND VGND gf180mcu_fd_sc_mcu7t5v0__fillcap_64
XFILLER_71_598 VPWR VPWR VGND VGND gf180mcu_fd_sc_mcu7t5v0__fillcap_4
XFILLER_16_437 VPWR VPWR VGND VGND gf180mcu_fd_sc_mcu7t5v0__fillcap_64
X_104_ _169_/D _103_/Z _167_/D VPWR VPWR VGND VGND gf180mcu_fd_sc_mcu7t5v0__nor2_1
XFILLER_3_352 VPWR VPWR VGND VGND gf180mcu_fd_sc_mcu7t5v0__fillcap_64
XFILLER_53_598 VPWR VPWR VGND VGND gf180mcu_fd_sc_mcu7t5v0__fillcap_4
XFILLER_4_138 VPWR VPWR VGND VGND gf180mcu_fd_sc_mcu7t5v0__fillcap_32
XFILLER_66_101 VPWR VPWR VGND VGND gf180mcu_fd_sc_mcu7t5v0__fillcap_4
XFILLER_35_598 VPWR VPWR VGND VGND gf180mcu_fd_sc_mcu7t5v0__fillcap_4
XFILLER_38_37 VPWR VPWR VGND VGND gf180mcu_fd_sc_mcu7t5v0__fillcap_64
XFILLER_48_101 VPWR VPWR VGND VGND gf180mcu_fd_sc_mcu7t5v0__fillcap_4
XFILLER_79_66 VPWR VPWR VGND VGND gf180mcu_fd_sc_mcu7t5v0__fillcap_4
XFILLER_76_410 VPWR VPWR VGND VGND gf180mcu_fd_sc_mcu7t5v0__fillcap_16
XFILLER_17_598 VPWR VPWR VGND VGND gf180mcu_fd_sc_mcu7t5v0__fillcap_4
XFILLER_31_590 VPWR VPWR VGND VGND gf180mcu_fd_sc_mcu7t5v0__fillcap_8
XFILLER_60_107 VPWR VPWR VGND VGND gf180mcu_fd_sc_mcu7t5v0__fillcap_32
XFILLER_76_240 VPWR VPWR VGND VGND gf180mcu_fd_sc_mcu7t5v0__fillcap_32
XFILLER_72_2 VPWR VPWR VGND VGND gf180mcu_fd_sc_mcu7t5v0__fillcap_32
XFILLER_13_590 VPWR VPWR VGND VGND gf180mcu_fd_sc_mcu7t5v0__fillcap_8
XFILLER_42_107 VPWR VPWR VGND VGND gf180mcu_fd_sc_mcu7t5v0__fillcap_32
XFILLER_55_402 VPWR VPWR VGND VGND gf180mcu_fd_sc_mcu7t5v0__fillcap_64
XFILLER_2_247 VPWR VPWR VGND VGND gf180mcu_fd_sc_mcu7t5v0__fillcap_64
XFILLER_46_402 VPWR VPWR VGND VGND gf180mcu_fd_sc_mcu7t5v0__fillcap_32
XFILLER_61_438 VPWR VPWR VGND VGND gf180mcu_fd_sc_mcu7t5v0__fillcap_32
X_197_ _197_/I uo_out[1] VPWR VPWR VGND VGND gf180mcu_fd_sc_mcu7t5v0__buf_1
XFILLER_10_593 VPWR VPWR VGND VGND gf180mcu_fd_sc_mcu7t5v0__fillcap_8
XFILLER_10_571 VPWR VPWR VGND VGND gf180mcu_fd_sc_mcu7t5v0__fillcap_4
XFILLER_24_107 VPWR VPWR VGND VGND gf180mcu_fd_sc_mcu7t5v0__fillcap_32
XFILLER_37_402 VPWR VPWR VGND VGND gf180mcu_fd_sc_mcu7t5v0__fillcap_64
XFILLER_68_593 VPWR VPWR VGND VGND gf180mcu_fd_sc_mcu7t5v0__fillcap_8
XFILLER_28_402 VPWR VPWR VGND VGND gf180mcu_fd_sc_mcu7t5v0__fillcap_32
XFILLER_46_37 VPWR VPWR VGND VGND gf180mcu_fd_sc_mcu7t5v0__fillcap_64
XFILLER_2_2 VPWR VPWR VGND VGND gf180mcu_fd_sc_mcu7t5v0__fillcap_32
XFILLER_3_556 VPWR VPWR VGND VGND gf180mcu_fd_sc_mcu7t5v0__fillcap_4
XFILLER_19_402 VPWR VPWR VGND VGND gf180mcu_fd_sc_mcu7t5v0__fillcap_64
XFILLER_35_2 VPWR VPWR VGND VGND gf180mcu_fd_sc_mcu7t5v0__fillcap_64
XFILLER_65_574 VPWR VPWR VGND VGND gf180mcu_fd_sc_mcu7t5v0__fillcap_16
X_103_ _131_/A1 _166_/Q _103_/Z VPWR VPWR VGND VGND gf180mcu_fd_sc_mcu7t5v0__xor2_1
XFILLER_7_136 VPWR VPWR VGND VGND gf180mcu_fd_sc_mcu7t5v0__fillcap_4
XFILLER_47_574 VPWR VPWR VGND VGND gf180mcu_fd_sc_mcu7t5v0__fillcap_16
XFILLER_62_577 VPWR VPWR VGND VGND gf180mcu_fd_sc_mcu7t5v0__fillcap_16
XFILLER_29_574 VPWR VPWR VGND VGND gf180mcu_fd_sc_mcu7t5v0__fillcap_16
XFILLER_17_72 VPWR VPWR VGND VGND gf180mcu_fd_sc_mcu7t5v0__fillcap_64
Xu_ihsan_sa_pll.u_pre.u_pre_inv0 u_ihsan_sa_pll.u_pre.u_pre_ff0/Q u_ihsan_sa_pll.u_pre.u_pre_ff0/D
+ VPWR VPWR VGND VGND gf180mcu_fd_sc_mcu7t5v0__inv_1
XFILLER_44_577 VPWR VPWR VGND VGND gf180mcu_fd_sc_mcu7t5v0__fillcap_16
XFILLER_54_37 VPWR VPWR VGND VGND gf180mcu_fd_sc_mcu7t5v0__fillcap_64
XFILLER_41_536 VPWR VPWR VGND VGND gf180mcu_fd_sc_mcu7t5v0__fillcap_4
XFILLER_26_577 VPWR VPWR VGND VGND gf180mcu_fd_sc_mcu7t5v0__fillcap_16
XFILLER_76_444 VPWR VPWR VGND VGND gf180mcu_fd_sc_mcu7t5v0__fillcap_4
XFILLER_79_282 VPWR VPWR VGND VGND gf180mcu_fd_sc_mcu7t5v0__fillcap_64
XFILLER_23_536 VPWR VPWR VGND VGND gf180mcu_fd_sc_mcu7t5v0__fillcap_4
XFILLER_49_466 VPWR VPWR VGND VGND gf180mcu_fd_sc_mcu7t5v0__fillcap_4
XFILLER_76_274 VPWR VPWR VGND VGND gf180mcu_fd_sc_mcu7t5v0__fillcap_32
XFILLER_65_2 VPWR VPWR VGND VGND gf180mcu_fd_sc_mcu7t5v0__fillcap_64
XFILLER_25_72 VPWR VPWR VGND VGND gf180mcu_fd_sc_mcu7t5v0__fillcap_64
X_196_ _196_/I uo_out[0] VPWR VPWR VGND VGND gf180mcu_fd_sc_mcu7t5v0__buf_1
XFILLER_69_506 VPWR VPWR VGND VGND gf180mcu_fd_sc_mcu7t5v0__fillcap_16
XFILLER_51_472 VPWR VPWR VGND VGND gf180mcu_fd_sc_mcu7t5v0__fillcap_64
XFILLER_62_37 VPWR VPWR VGND VGND gf180mcu_fd_sc_mcu7t5v0__fillcap_64
XFILLER_30_601 VPWR VPWR VGND VGND gf180mcu_fd_sc_mcu7t5v0__fillcap_4
XFILLER_65_542 VPWR VPWR VGND VGND gf180mcu_fd_sc_mcu7t5v0__fillcap_32
XFILLER_28_2 VPWR VPWR VGND VGND gf180mcu_fd_sc_mcu7t5v0__fillcap_32
XFILLER_33_472 VPWR VPWR VGND VGND gf180mcu_fd_sc_mcu7t5v0__fillcap_64
Xclkbuf_2_2__f_clk clkbuf_0_clk/Z _163_/CLK VPWR VPWR VGND VGND gf180mcu_fd_sc_mcu7t5v0__clkbuf_8
XFILLER_12_601 VPWR VPWR VGND VGND gf180mcu_fd_sc_mcu7t5v0__fillcap_4
X_102_ _166_/Q _169_/D _166_/D VPWR VPWR VGND VGND gf180mcu_fd_sc_mcu7t5v0__nor2_1
XFILLER_78_177 VPWR VPWR VGND VGND gf180mcu_fd_sc_mcu7t5v0__fillcap_64
XFILLER_47_542 VPWR VPWR VGND VGND gf180mcu_fd_sc_mcu7t5v0__fillcap_32
XFILLER_15_472 VPWR VPWR VGND VGND gf180mcu_fd_sc_mcu7t5v0__fillcap_64
XFILLER_80_342 VPWR VPWR VGND VGND gf180mcu_fd_sc_mcu7t5v0__fillcap_32
XFILLER_75_136 VPWR VPWR VGND VGND gf180mcu_fd_sc_mcu7t5v0__fillcap_4
XFILLER_44_501 VPWR VPWR VGND VGND gf180mcu_fd_sc_mcu7t5v0__fillcap_4
XFILLER_29_542 VPWR VPWR VGND VGND gf180mcu_fd_sc_mcu7t5v0__fillcap_32
XFILLER_33_72 VPWR VPWR VGND VGND gf180mcu_fd_sc_mcu7t5v0__fillcap_64
XFILLER_8_402 VPWR VPWR VGND VGND gf180mcu_fd_sc_mcu7t5v0__fillcap_32
XFILLER_26_501 VPWR VPWR VGND VGND gf180mcu_fd_sc_mcu7t5v0__fillcap_4
XFILLER_57_136 VPWR VPWR VGND VGND gf180mcu_fd_sc_mcu7t5v0__fillcap_4
XFILLER_72_139 VPWR VPWR VGND VGND gf180mcu_fd_sc_mcu7t5v0__fillcap_4
XFILLER_80_161 VPWR VPWR VGND VGND gf180mcu_fd_sc_mcu7t5v0__fillcap_8
XFILLER_70_37 VPWR VPWR VGND VGND gf180mcu_fd_sc_mcu7t5v0__fillcap_64
XFILLER_76_478 VPWR VPWR VGND VGND gf180mcu_fd_sc_mcu7t5v0__fillcap_4
XFILLER_10_2 VPWR VPWR VGND VGND gf180mcu_fd_sc_mcu7t5v0__fillcap_32
XFILLER_39_136 VPWR VPWR VGND VGND gf180mcu_fd_sc_mcu7t5v0__fillcap_4
XFILLER_54_139 VPWR VPWR VGND VGND gf180mcu_fd_sc_mcu7t5v0__fillcap_4
XFILLER_36_139 VPWR VPWR VGND VGND gf180mcu_fd_sc_mcu7t5v0__fillcap_4
XFILLER_20_507 VPWR VPWR VGND VGND gf180mcu_fd_sc_mcu7t5v0__fillcap_64
XFILLER_58_2 VPWR VPWR VGND VGND gf180mcu_fd_sc_mcu7t5v0__fillcap_32
XFILLER_9_574 VPWR VPWR VGND VGND gf180mcu_fd_sc_mcu7t5v0__fillcap_16
XFILLER_70_418 VPWR VPWR VGND VGND gf180mcu_fd_sc_mcu7t5v0__fillcap_16
XFILLER_46_437 VPWR VPWR VGND VGND gf180mcu_fd_sc_mcu7t5v0__fillcap_64
XFILLER_18_139 VPWR VPWR VGND VGND gf180mcu_fd_sc_mcu7t5v0__fillcap_4
XFILLER_76_36 VPWR VPWR VGND VGND gf180mcu_fd_sc_mcu7t5v0__fillcap_32
X_120__45 _120__45/I _171_/D VPWR VPWR VGND VGND gf180mcu_fd_sc_mcu7t5v0__clkinv_1
XFILLER_41_72 VPWR VPWR VGND VGND gf180mcu_fd_sc_mcu7t5v0__fillcap_64
XFILLER_6_577 VPWR VPWR VGND VGND gf180mcu_fd_sc_mcu7t5v0__fillcap_16
XFILLER_1_282 VPWR VPWR VGND VGND gf180mcu_fd_sc_mcu7t5v0__fillcap_64
XFILLER_60_495 VPWR VPWR VGND VGND gf180mcu_fd_sc_mcu7t5v0__fillcap_8
XFILLER_28_437 VPWR VPWR VGND VGND gf180mcu_fd_sc_mcu7t5v0__fillcap_64
XFILLER_74_543 VPWR VPWR VGND VGND gf180mcu_fd_sc_mcu7t5v0__fillcap_32
XFILLER_65_521 VPWR VPWR VGND VGND gf180mcu_fd_sc_mcu7t5v0__fillcap_4
XFILLER_2_591 VPWR VPWR VGND VGND gf180mcu_fd_sc_mcu7t5v0__fillcap_4
XFILLER_65_598 VPWR VPWR VGND VGND gf180mcu_fd_sc_mcu7t5v0__fillcap_4
XFILLER_20_101 VPWR VPWR VGND VGND gf180mcu_fd_sc_mcu7t5v0__fillcap_4
X_101_ _162_/Q _097_/Z _101_/B _162_/D VPWR VPWR VGND VGND gf180mcu_fd_sc_mcu7t5v0__aoi21_1
XFILLER_78_101 VPWR VPWR VGND VGND gf180mcu_fd_sc_mcu7t5v0__fillcap_4
XFILLER_47_598 VPWR VPWR VGND VGND gf180mcu_fd_sc_mcu7t5v0__fillcap_4
XFILLER_40_2 VPWR VPWR VGND VGND gf180mcu_fd_sc_mcu7t5v0__fillcap_32
XFILLER_61_590 VPWR VPWR VGND VGND gf180mcu_fd_sc_mcu7t5v0__fillcap_8
XFILLER_68_37 VPWR VPWR VGND VGND gf180mcu_fd_sc_mcu7t5v0__fillcap_64
XFILLER_29_598 VPWR VPWR VGND VGND gf180mcu_fd_sc_mcu7t5v0__fillcap_4
Xtt_um_ihsan_sa_pll uio_oe[0] VPWR VPWR VGND VGND gf180mcu_fd_sc_mcu7t5v0__tiel
XFILLER_43_590 VPWR VPWR VGND VGND gf180mcu_fd_sc_mcu7t5v0__fillcap_8
XFILLER_72_107 VPWR VPWR VGND VGND gf180mcu_fd_sc_mcu7t5v0__fillcap_32
XFILLER_76_468 VPWR VPWR VGND VGND gf180mcu_fd_sc_mcu7t5v0__fillcap_8
XFILLER_40_571 VPWR VPWR VGND VGND gf180mcu_fd_sc_mcu7t5v0__fillcap_4
XFILLER_25_590 VPWR VPWR VGND VGND gf180mcu_fd_sc_mcu7t5v0__fillcap_8
XFILLER_40_593 VPWR VPWR VGND VGND gf180mcu_fd_sc_mcu7t5v0__fillcap_8
XFILLER_5_66 VPWR VPWR VGND VGND gf180mcu_fd_sc_mcu7t5v0__fillcap_4
XFILLER_54_107 VPWR VPWR VGND VGND gf180mcu_fd_sc_mcu7t5v0__fillcap_32
XFILLER_58_402 VPWR VPWR VGND VGND gf180mcu_fd_sc_mcu7t5v0__fillcap_32
XFILLER_22_571 VPWR VPWR VGND VGND gf180mcu_fd_sc_mcu7t5v0__fillcap_4
XFILLER_22_593 VPWR VPWR VGND VGND gf180mcu_fd_sc_mcu7t5v0__fillcap_8
XFILLER_39_72 VPWR VPWR VGND VGND gf180mcu_fd_sc_mcu7t5v0__fillcap_64
XFILLER_49_402 VPWR VPWR VGND VGND gf180mcu_fd_sc_mcu7t5v0__fillcap_64
XFILLER_1_486 VPWR VPWR VGND VGND gf180mcu_fd_sc_mcu7t5v0__fillcap_4
XFILLER_36_107 VPWR VPWR VGND VGND gf180mcu_fd_sc_mcu7t5v0__fillcap_32
XFILLER_9_542 VPWR VPWR VGND VGND gf180mcu_fd_sc_mcu7t5v0__fillcap_32
XFILLER_18_107 VPWR VPWR VGND VGND gf180mcu_fd_sc_mcu7t5v0__fillcap_32
XFILLER_6_501 VPWR VPWR VGND VGND gf180mcu_fd_sc_mcu7t5v0__fillcap_4
XFILLER_70_2 VPWR VPWR VGND VGND gf180mcu_fd_sc_mcu7t5v0__fillcap_32
XFILLER_59_574 VPWR VPWR VGND VGND gf180mcu_fd_sc_mcu7t5v0__fillcap_16
XFILLER_78_349 VPWR VPWR VGND VGND gf180mcu_fd_sc_mcu7t5v0__fillcap_8
XFILLER_74_577 VPWR VPWR VGND VGND gf180mcu_fd_sc_mcu7t5v0__fillcap_16
XFILLER_77_360 VPWR VPWR VGND VGND gf180mcu_fd_sc_mcu7t5v0__fillcap_4
XFILLER_77_393 VPWR VPWR VGND VGND gf180mcu_fd_sc_mcu7t5v0__fillcap_16
XFILLER_56_577 VPWR VPWR VGND VGND gf180mcu_fd_sc_mcu7t5v0__fillcap_16
X_100_ _162_/Q _097_/Z _109_/B _101_/B VPWR VPWR VGND VGND gf180mcu_fd_sc_mcu7t5v0__oai21_1
XFILLER_0_2 VPWR VPWR VGND VGND gf180mcu_fd_sc_mcu7t5v0__fillcap_32
XFILLER_47_72 VPWR VPWR VGND VGND gf180mcu_fd_sc_mcu7t5v0__fillcap_64
XFILLER_33_2 VPWR VPWR VGND VGND gf180mcu_fd_sc_mcu7t5v0__fillcap_64
XFILLER_53_536 VPWR VPWR VGND VGND gf180mcu_fd_sc_mcu7t5v0__fillcap_4
XFILLER_38_577 VPWR VPWR VGND VGND gf180mcu_fd_sc_mcu7t5v0__fillcap_16
XFILLER_80_333 VPWR VPWR VGND VGND gf180mcu_fd_sc_mcu7t5v0__fillcap_4
XFILLER_21_466 VPWR VPWR VGND VGND gf180mcu_fd_sc_mcu7t5v0__fillcap_4
XFILLER_8_437 VPWR VPWR VGND VGND gf180mcu_fd_sc_mcu7t5v0__fillcap_64
XFILLER_3_142 VPWR VPWR VGND VGND gf180mcu_fd_sc_mcu7t5v0__fillcap_64
XFILLER_35_536 VPWR VPWR VGND VGND gf180mcu_fd_sc_mcu7t5v0__fillcap_4
XFILLER_17_536 VPWR VPWR VGND VGND gf180mcu_fd_sc_mcu7t5v0__fillcap_4
XFILLER_60_601 VPWR VPWR VGND VGND gf180mcu_fd_sc_mcu7t5v0__fillcap_4
XFILLER_55_72 VPWR VPWR VGND VGND gf180mcu_fd_sc_mcu7t5v0__fillcap_64
XFILLER_9_598 VPWR VPWR VGND VGND gf180mcu_fd_sc_mcu7t5v0__fillcap_4
XFILLER_42_601 VPWR VPWR VGND VGND gf180mcu_fd_sc_mcu7t5v0__fillcap_4
XFILLER_60_453 VPWR VPWR VGND VGND gf180mcu_fd_sc_mcu7t5v0__fillcap_8
XFILLER_45_472 VPWR VPWR VGND VGND gf180mcu_fd_sc_mcu7t5v0__fillcap_64
XFILLER_60_431 VPWR VPWR VGND VGND gf180mcu_fd_sc_mcu7t5v0__fillcap_4
XFILLER_63_2 VPWR VPWR VGND VGND gf180mcu_fd_sc_mcu7t5v0__fillcap_64
XFILLER_68_564 VPWR VPWR VGND VGND gf180mcu_fd_sc_mcu7t5v0__fillcap_8
XFILLER_68_542 VPWR VPWR VGND VGND gf180mcu_fd_sc_mcu7t5v0__fillcap_4
XFILLER_5_590 VPWR VPWR VGND VGND gf180mcu_fd_sc_mcu7t5v0__fillcap_8
XFILLER_24_601 VPWR VPWR VGND VGND gf180mcu_fd_sc_mcu7t5v0__fillcap_4
XFILLER_11_66 VPWR VPWR VGND VGND gf180mcu_fd_sc_mcu7t5v0__fillcap_4
XFILLER_78_317 VPWR VPWR VGND VGND gf180mcu_fd_sc_mcu7t5v0__fillcap_32
XFILLER_59_542 VPWR VPWR VGND VGND gf180mcu_fd_sc_mcu7t5v0__fillcap_32
XFILLER_27_472 VPWR VPWR VGND VGND gf180mcu_fd_sc_mcu7t5v0__fillcap_64
XFILLER_56_501 VPWR VPWR VGND VGND gf180mcu_fd_sc_mcu7t5v0__fillcap_4
XFILLER_11_136 VPWR VPWR VGND VGND gf180mcu_fd_sc_mcu7t5v0__fillcap_4
XFILLER_3_346 VPWR VPWR VGND VGND gf180mcu_fd_sc_mcu7t5v0__fillcap_4
Xclkbuf_regs_1_clk_pre _128_/Z clkbuf_regs_1_clk_pre/Z VPWR VPWR VGND VGND gf180mcu_fd_sc_mcu7t5v0__clkbuf_8
XFILLER_70_570 VPWR VPWR VGND VGND gf180mcu_fd_sc_mcu7t5v0__fillcap_4
XFILLER_63_72 VPWR VPWR VGND VGND gf180mcu_fd_sc_mcu7t5v0__fillcap_64
X_159_ _159_/D wire11/I _161_/CLK _159_/Q VPWR VPWR VGND VGND gf180mcu_fd_sc_mcu7t5v0__dffrnq_1
XFILLER_38_501 VPWR VPWR VGND VGND gf180mcu_fd_sc_mcu7t5v0__fillcap_4
XFILLER_26_2 VPWR VPWR VGND VGND gf180mcu_fd_sc_mcu7t5v0__fillcap_32
XFILLER_69_136 VPWR VPWR VGND VGND gf180mcu_fd_sc_mcu7t5v0__fillcap_4
XFILLER_66_139 VPWR VPWR VGND VGND gf180mcu_fd_sc_mcu7t5v0__fillcap_4
XFILLER_50_507 VPWR VPWR VGND VGND gf180mcu_fd_sc_mcu7t5v0__fillcap_64
XFILLER_48_139 VPWR VPWR VGND VGND gf180mcu_fd_sc_mcu7t5v0__fillcap_4
XFILLER_32_507 VPWR VPWR VGND VGND gf180mcu_fd_sc_mcu7t5v0__fillcap_64
XFILLER_58_437 VPWR VPWR VGND VGND gf180mcu_fd_sc_mcu7t5v0__fillcap_64
XFILLER_14_507 VPWR VPWR VGND VGND gf180mcu_fd_sc_mcu7t5v0__fillcap_64
XFILLER_1_422 VPWR VPWR VGND VGND gf180mcu_fd_sc_mcu7t5v0__fillcap_64
XFILLER_71_72 VPWR VPWR VGND VGND gf180mcu_fd_sc_mcu7t5v0__fillcap_64
XFILLER_50_101 VPWR VPWR VGND VGND gf180mcu_fd_sc_mcu7t5v0__fillcap_4
XFILLER_32_101 VPWR VPWR VGND VGND gf180mcu_fd_sc_mcu7t5v0__fillcap_4
XFILLER_56_2 VPWR VPWR VGND VGND gf180mcu_fd_sc_mcu7t5v0__fillcap_32
Xtt_um_ihsan_sa_pll_40 uo_out[5] VPWR VPWR VGND VGND gf180mcu_fd_sc_mcu7t5v0__tiel
XFILLER_59_598 VPWR VPWR VGND VGND gf180mcu_fd_sc_mcu7t5v0__fillcap_4
XFILLER_14_101 VPWR VPWR VGND VGND gf180mcu_fd_sc_mcu7t5v0__fillcap_4
XFILLER_73_590 VPWR VPWR VGND VGND gf180mcu_fd_sc_mcu7t5v0__fillcap_8
XFILLER_55_590 VPWR VPWR VGND VGND gf180mcu_fd_sc_mcu7t5v0__fillcap_8
XFILLER_70_593 VPWR VPWR VGND VGND gf180mcu_fd_sc_mcu7t5v0__fillcap_8
XFILLER_30_402 VPWR VPWR VGND VGND gf180mcu_fd_sc_mcu7t5v0__fillcap_32
X_158_ _158_/D _158_/RN _161_/CLK _158_/Q VPWR VPWR VGND VGND gf180mcu_fd_sc_mcu7t5v0__dffrnq_1
X_089_ _089_/A1 _093_/B _159_/D VPWR VPWR VGND VGND gf180mcu_fd_sc_mcu7t5v0__nor2_1
XFILLER_19_2 VPWR VPWR VGND VGND gf180mcu_fd_sc_mcu7t5v0__fillcap_64
XFILLER_21_402 VPWR VPWR VGND VGND gf180mcu_fd_sc_mcu7t5v0__fillcap_64
XFILLER_37_590 VPWR VPWR VGND VGND gf180mcu_fd_sc_mcu7t5v0__fillcap_8
XFILLER_17_66 VPWR VPWR VGND VGND gf180mcu_fd_sc_mcu7t5v0__fillcap_4
XFILLER_52_571 VPWR VPWR VGND VGND gf180mcu_fd_sc_mcu7t5v0__fillcap_4
XFILLER_52_593 VPWR VPWR VGND VGND gf180mcu_fd_sc_mcu7t5v0__fillcap_8
XFILLER_12_402 VPWR VPWR VGND VGND gf180mcu_fd_sc_mcu7t5v0__fillcap_32
XFILLER_66_107 VPWR VPWR VGND VGND gf180mcu_fd_sc_mcu7t5v0__fillcap_32
XFILLER_7_472 VPWR VPWR VGND VGND gf180mcu_fd_sc_mcu7t5v0__fillcap_64
XFILLER_19_590 VPWR VPWR VGND VGND gf180mcu_fd_sc_mcu7t5v0__fillcap_8
XFILLER_34_593 VPWR VPWR VGND VGND gf180mcu_fd_sc_mcu7t5v0__fillcap_8
XFILLER_34_571 VPWR VPWR VGND VGND gf180mcu_fd_sc_mcu7t5v0__fillcap_4
XFILLER_80_176 VPWR VPWR VGND VGND gf180mcu_fd_sc_mcu7t5v0__fillcap_4
XFILLER_80_187 VPWR VPWR VGND VGND gf180mcu_fd_sc_mcu7t5v0__fillcap_8
XFILLER_48_107 VPWR VPWR VGND VGND gf180mcu_fd_sc_mcu7t5v0__fillcap_32
XFILLER_69_72 VPWR VPWR VGND VGND gf180mcu_fd_sc_mcu7t5v0__fillcap_64
XFILLER_79_276 VPWR VPWR VGND VGND gf180mcu_fd_sc_mcu7t5v0__fillcap_4
XFILLER_31_574 VPWR VPWR VGND VGND gf180mcu_fd_sc_mcu7t5v0__fillcap_16
XFILLER_16_571 VPWR VPWR VGND VGND gf180mcu_fd_sc_mcu7t5v0__fillcap_4
XFILLER_16_593 VPWR VPWR VGND VGND gf180mcu_fd_sc_mcu7t5v0__fillcap_8
XFILLER_72_463 VPWR VPWR VGND VGND gf180mcu_fd_sc_mcu7t5v0__fillcap_8
XFILLER_13_574 VPWR VPWR VGND VGND gf180mcu_fd_sc_mcu7t5v0__fillcap_16
X_114__46 _170_/CLK _172_/D VPWR VPWR VGND VGND gf180mcu_fd_sc_mcu7t5v0__clkinv_1
XFILLER_25_66 VPWR VPWR VGND VGND gf180mcu_fd_sc_mcu7t5v0__fillcap_4
XFILLER_10_577 VPWR VPWR VGND VGND gf180mcu_fd_sc_mcu7t5v0__fillcap_16
XFILLER_2_37 VPWR VPWR VGND VGND gf180mcu_fd_sc_mcu7t5v0__fillcap_64
Xtt_um_ihsan_sa_pll_30 uio_out[0] VPWR VPWR VGND VGND gf180mcu_fd_sc_mcu7t5v0__tiel
Xtt_um_ihsan_sa_pll_41 uo_out[6] VPWR VPWR VGND VGND gf180mcu_fd_sc_mcu7t5v0__tiel
XFILLER_49_2 VPWR VPWR VGND VGND gf180mcu_fd_sc_mcu7t5v0__fillcap_64
XFILLER_68_577 VPWR VPWR VGND VGND gf180mcu_fd_sc_mcu7t5v0__fillcap_16
XFILLER_51_466 VPWR VPWR VGND VGND gf180mcu_fd_sc_mcu7t5v0__fillcap_4
XFILLER_77_72 VPWR VPWR VGND VGND gf180mcu_fd_sc_mcu7t5v0__fillcap_64
XFILLER_77_352 VPWR VPWR VGND VGND gf180mcu_fd_sc_mcu7t5v0__fillcap_8
XFILLER_33_466 VPWR VPWR VGND VGND gf180mcu_fd_sc_mcu7t5v0__fillcap_4
Xu_analog u_analog/vco_out _125_/Z _126_/Z _145_/Q _144_/Q _146_/Q ua[0] ua[1] VPWR
+ VGND pll_analog
XFILLER_47_536 VPWR VPWR VGND VGND gf180mcu_fd_sc_mcu7t5v0__fillcap_4
XFILLER_15_466 VPWR VPWR VGND VGND gf180mcu_fd_sc_mcu7t5v0__fillcap_4
X_157_ _157_/D _158_/RN _161_/CLK _157_/Q VPWR VPWR VGND VGND gf180mcu_fd_sc_mcu7t5v0__dffrnq_1
X_088_ _109_/B _109_/A2 _093_/B VPWR VPWR VGND VGND gf180mcu_fd_sc_mcu7t5v0__nand2_1
XFILLER_2_381 VPWR VPWR VGND VGND gf180mcu_fd_sc_mcu7t5v0__fillcap_4
XFILLER_29_536 VPWR VPWR VGND VGND gf180mcu_fd_sc_mcu7t5v0__fillcap_4
XFILLER_33_66 VPWR VPWR VGND VGND gf180mcu_fd_sc_mcu7t5v0__fillcap_4
XFILLER_31_2 VPWR VPWR VGND VGND gf180mcu_fd_sc_mcu7t5v0__fillcap_64
XFILLER_0_70 VPWR VPWR VGND VGND gf180mcu_fd_sc_mcu7t5v0__fillcap_32
XFILLER_80_122 VPWR VPWR VGND VGND gf180mcu_fd_sc_mcu7t5v0__fillcap_8
XFILLER_0_104 VPWR VPWR VGND VGND gf180mcu_fd_sc_mcu7t5v0__fillcap_32
XFILLER_72_601 VPWR VPWR VGND VGND gf180mcu_fd_sc_mcu7t5v0__fillcap_4
XFILLER_4_410 VPWR VPWR VGND VGND gf180mcu_fd_sc_mcu7t5v0__fillcap_32
XFILLER_31_542 VPWR VPWR VGND VGND gf180mcu_fd_sc_mcu7t5v0__fillcap_32
XFILLER_79_2 VPWR VPWR VGND VGND gf180mcu_fd_sc_mcu7t5v0__fillcap_64
XFILLER_54_601 VPWR VPWR VGND VGND gf180mcu_fd_sc_mcu7t5v0__fillcap_4
XFILLER_57_472 VPWR VPWR VGND VGND gf180mcu_fd_sc_mcu7t5v0__fillcap_64
XFILLER_13_542 VPWR VPWR VGND VGND gf180mcu_fd_sc_mcu7t5v0__fillcap_32
XFILLER_4_240 VPWR VPWR VGND VGND gf180mcu_fd_sc_mcu7t5v0__fillcap_32
XFILLER_36_601 VPWR VPWR VGND VGND gf180mcu_fd_sc_mcu7t5v0__fillcap_4
X_114__47 _170_/CLK _107_/A1 VPWR VPWR VGND VGND gf180mcu_fd_sc_mcu7t5v0__clkinv_1
XFILLER_39_472 VPWR VPWR VGND VGND gf180mcu_fd_sc_mcu7t5v0__fillcap_64
XFILLER_41_136 VPWR VPWR VGND VGND gf180mcu_fd_sc_mcu7t5v0__fillcap_4
XFILLER_10_501 VPWR VPWR VGND VGND gf180mcu_fd_sc_mcu7t5v0__fillcap_4
XFILLER_9_2 VPWR VPWR VGND VGND gf180mcu_fd_sc_mcu7t5v0__fillcap_64
XFILLER_41_66 VPWR VPWR VGND VGND gf180mcu_fd_sc_mcu7t5v0__fillcap_4
XFILLER_1_276 VPWR VPWR VGND VGND gf180mcu_fd_sc_mcu7t5v0__fillcap_4
XFILLER_18_601 VPWR VPWR VGND VGND gf180mcu_fd_sc_mcu7t5v0__fillcap_4
Xtt_um_ihsan_sa_pll_31 uio_out[1] VPWR VPWR VGND VGND gf180mcu_fd_sc_mcu7t5v0__tiel
Xtt_um_ihsan_sa_pll_42 uo_out[7] VPWR VPWR VGND VGND gf180mcu_fd_sc_mcu7t5v0__tiel
XFILLER_68_523 VPWR VPWR VGND VGND gf180mcu_fd_sc_mcu7t5v0__fillcap_4
XFILLER_68_501 VPWR VPWR VGND VGND gf180mcu_fd_sc_mcu7t5v0__fillcap_4
XFILLER_68_534 VPWR VPWR VGND VGND gf180mcu_fd_sc_mcu7t5v0__fillcap_8
XFILLER_23_136 VPWR VPWR VGND VGND gf180mcu_fd_sc_mcu7t5v0__fillcap_4
XFILLER_20_139 VPWR VPWR VGND VGND gf180mcu_fd_sc_mcu7t5v0__fillcap_4
XFILLER_61_2 VPWR VPWR VGND VGND gf180mcu_fd_sc_mcu7t5v0__fillcap_64
XFILLER_70_562 VPWR VPWR VGND VGND gf180mcu_fd_sc_mcu7t5v0__fillcap_8
XFILLER_30_437 VPWR VPWR VGND VGND gf180mcu_fd_sc_mcu7t5v0__fillcap_64
X_156_ _156_/D _156_/RN _156_/CLK _156_/Q VPWR VPWR VGND VGND gf180mcu_fd_sc_mcu7t5v0__dffrnq_1
X_087_ _157_/Q _158_/Q _159_/Q _078_/Z _109_/A2 VPWR VPWR VGND VGND gf180mcu_fd_sc_mcu7t5v0__nand4_1
XFILLER_8_37 VPWR VPWR VGND VGND gf180mcu_fd_sc_mcu7t5v0__fillcap_64
XFILLER_0_308 VPWR VPWR VGND VGND gf180mcu_fd_sc_mcu7t5v0__fillcap_32
XFILLER_44_507 VPWR VPWR VGND VGND gf180mcu_fd_sc_mcu7t5v0__fillcap_64
XFILLER_12_437 VPWR VPWR VGND VGND gf180mcu_fd_sc_mcu7t5v0__fillcap_64
XFILLER_79_415 VPWR VPWR VGND VGND gf180mcu_fd_sc_mcu7t5v0__fillcap_4
X_139_ _149_/Q _148_/Q _150_/Q _140_/A3 VPWR VPWR VGND VGND gf180mcu_fd_sc_mcu7t5v0__aoi21_1
XFILLER_24_2 VPWR VPWR VGND VGND gf180mcu_fd_sc_mcu7t5v0__fillcap_32
XFILLER_26_507 VPWR VPWR VGND VGND gf180mcu_fd_sc_mcu7t5v0__fillcap_64
XFILLER_0_138 VPWR VPWR VGND VGND gf180mcu_fd_sc_mcu7t5v0__fillcap_32
XFILLER_4_444 VPWR VPWR VGND VGND gf180mcu_fd_sc_mcu7t5v0__fillcap_32
XFILLER_79_212 VPWR VPWR VGND VGND gf180mcu_fd_sc_mcu7t5v0__fillcap_64
Xclkbuf_2_3__f_clk clkbuf_0_clk/Z _156_/CLK VPWR VPWR VGND VGND gf180mcu_fd_sc_mcu7t5v0__clkbuf_8
XFILLER_62_101 VPWR VPWR VGND VGND gf180mcu_fd_sc_mcu7t5v0__fillcap_4
XFILLER_31_598 VPWR VPWR VGND VGND gf180mcu_fd_sc_mcu7t5v0__fillcap_4
XFILLER_39_66 VPWR VPWR VGND VGND gf180mcu_fd_sc_mcu7t5v0__fillcap_4
XFILLER_44_101 VPWR VPWR VGND VGND gf180mcu_fd_sc_mcu7t5v0__fillcap_4
XFILLER_9_536 VPWR VPWR VGND VGND gf180mcu_fd_sc_mcu7t5v0__fillcap_4
XFILLER_13_598 VPWR VPWR VGND VGND gf180mcu_fd_sc_mcu7t5v0__fillcap_4
XFILLER_4_274 VPWR VPWR VGND VGND gf180mcu_fd_sc_mcu7t5v0__fillcap_32
XFILLER_26_101 VPWR VPWR VGND VGND gf180mcu_fd_sc_mcu7t5v0__fillcap_4
XFILLER_77_568 VPWR VPWR VGND VGND gf180mcu_fd_sc_mcu7t5v0__fillcap_32
XFILLER_60_402 VPWR VPWR VGND VGND gf180mcu_fd_sc_mcu7t5v0__fillcap_8
Xtt_um_ihsan_sa_pll_32 uio_out[2] VPWR VPWR VGND VGND gf180mcu_fd_sc_mcu7t5v0__tiel
XFILLER_51_402 VPWR VPWR VGND VGND gf180mcu_fd_sc_mcu7t5v0__fillcap_64
XFILLER_67_590 VPWR VPWR VGND VGND gf180mcu_fd_sc_mcu7t5v0__fillcap_8
XFILLER_42_402 VPWR VPWR VGND VGND gf180mcu_fd_sc_mcu7t5v0__fillcap_32
X_172_ _172_/D wire16/Z _172_/CLK _172_/Q VPWR VPWR VGND VGND gf180mcu_fd_sc_mcu7t5v0__dffrnq_1
XFILLER_2_597 VPWR VPWR VGND VGND gf180mcu_fd_sc_mcu7t5v0__fillcap_8
XFILLER_33_402 VPWR VPWR VGND VGND gf180mcu_fd_sc_mcu7t5v0__fillcap_64
XFILLER_20_107 VPWR VPWR VGND VGND gf180mcu_fd_sc_mcu7t5v0__fillcap_32
XFILLER_54_2 VPWR VPWR VGND VGND gf180mcu_fd_sc_mcu7t5v0__fillcap_32
XFILLER_64_593 VPWR VPWR VGND VGND gf180mcu_fd_sc_mcu7t5v0__fillcap_8
Xwire11 wire11/I wire11/Z VPWR VPWR VGND VGND gf180mcu_fd_sc_mcu7t5v0__clkbuf_2
XFILLER_49_590 VPWR VPWR VGND VGND gf180mcu_fd_sc_mcu7t5v0__fillcap_8
XFILLER_24_402 VPWR VPWR VGND VGND gf180mcu_fd_sc_mcu7t5v0__fillcap_32
XFILLER_78_107 VPWR VPWR VGND VGND gf180mcu_fd_sc_mcu7t5v0__fillcap_64
XFILLER_47_66 VPWR VPWR VGND VGND gf180mcu_fd_sc_mcu7t5v0__fillcap_4
XFILLER_15_402 VPWR VPWR VGND VGND gf180mcu_fd_sc_mcu7t5v0__fillcap_64
X_165__43 _165_/D VPWR VPWR VGND VGND gf180mcu_fd_sc_mcu7t5v0__tieh
X_155_ _155_/D _156_/RN _156_/CLK _155_/Q VPWR VPWR VGND VGND gf180mcu_fd_sc_mcu7t5v0__dffrnq_1
X_086_ _159_/Q _083_/Z _089_/A1 VPWR VPWR VGND VGND gf180mcu_fd_sc_mcu7t5v0__nor2_1
XFILLER_46_571 VPWR VPWR VGND VGND gf180mcu_fd_sc_mcu7t5v0__fillcap_4
XFILLER_46_593 VPWR VPWR VGND VGND gf180mcu_fd_sc_mcu7t5v0__fillcap_8
XFILLER_61_574 VPWR VPWR VGND VGND gf180mcu_fd_sc_mcu7t5v0__fillcap_16
XFILLER_3_136 VPWR VPWR VGND VGND gf180mcu_fd_sc_mcu7t5v0__fillcap_4
XFILLER_28_593 VPWR VPWR VGND VGND gf180mcu_fd_sc_mcu7t5v0__fillcap_8
XFILLER_28_571 VPWR VPWR VGND VGND gf180mcu_fd_sc_mcu7t5v0__fillcap_4
XFILLER_43_574 VPWR VPWR VGND VGND gf180mcu_fd_sc_mcu7t5v0__fillcap_16
X_069_ _145_/Q _116_/ZN _109_/B VPWR VPWR VGND VGND gf180mcu_fd_sc_mcu7t5v0__and2_1
X_138_ _147_/Q _138_/A2 _149_/D VPWR VPWR VGND VGND gf180mcu_fd_sc_mcu7t5v0__nor2_1
XFILLER_17_2 VPWR VPWR VGND VGND gf180mcu_fd_sc_mcu7t5v0__fillcap_64
XFILLER_40_577 VPWR VPWR VGND VGND gf180mcu_fd_sc_mcu7t5v0__fillcap_16
XFILLER_25_574 VPWR VPWR VGND VGND gf180mcu_fd_sc_mcu7t5v0__fillcap_16
XFILLER_4_478 VPWR VPWR VGND VGND gf180mcu_fd_sc_mcu7t5v0__fillcap_32
XFILLER_66_463 VPWR VPWR VGND VGND gf180mcu_fd_sc_mcu7t5v0__fillcap_4
XFILLER_14_37 VPWR VPWR VGND VGND gf180mcu_fd_sc_mcu7t5v0__fillcap_64
XFILLER_22_577 VPWR VPWR VGND VGND gf180mcu_fd_sc_mcu7t5v0__fillcap_16
XFILLER_55_66 VPWR VPWR VGND VGND gf180mcu_fd_sc_mcu7t5v0__fillcap_4
XFILLER_6_507 VPWR VPWR VGND VGND gf180mcu_fd_sc_mcu7t5v0__fillcap_64
XFILLER_1_212 VPWR VPWR VGND VGND gf180mcu_fd_sc_mcu7t5v0__fillcap_64
XFILLER_45_466 VPWR VPWR VGND VGND gf180mcu_fd_sc_mcu7t5v0__fillcap_4
Xtt_um_ihsan_sa_pll_33 uio_out[3] VPWR VPWR VGND VGND gf180mcu_fd_sc_mcu7t5v0__tiel
XFILLER_76_580 VPWR VPWR VGND VGND gf180mcu_fd_sc_mcu7t5v0__fillcap_16
XFILLER_59_536 VPWR VPWR VGND VGND gf180mcu_fd_sc_mcu7t5v0__fillcap_4
XFILLER_27_466 VPWR VPWR VGND VGND gf180mcu_fd_sc_mcu7t5v0__fillcap_4
X_171_ _171_/D wire11/Z _171_/CLK _171_/Q VPWR VPWR VGND VGND gf180mcu_fd_sc_mcu7t5v0__dffrnq_1
XFILLER_2_521 VPWR VPWR VGND VGND gf180mcu_fd_sc_mcu7t5v0__fillcap_4
XFILLER_47_2 VPWR VPWR VGND VGND gf180mcu_fd_sc_mcu7t5v0__fillcap_64
XFILLER_3_72 VPWR VPWR VGND VGND gf180mcu_fd_sc_mcu7t5v0__fillcap_64
XFILLER_22_37 VPWR VPWR VGND VGND gf180mcu_fd_sc_mcu7t5v0__fillcap_64
XFILLER_6_101 VPWR VPWR VGND VGND gf180mcu_fd_sc_mcu7t5v0__fillcap_4
XFILLER_63_66 VPWR VPWR VGND VGND gf180mcu_fd_sc_mcu7t5v0__fillcap_4
X_154_ _154_/D _169_/RN _156_/CLK _154_/Q VPWR VPWR VGND VGND gf180mcu_fd_sc_mcu7t5v0__dffrnq_1
X_085_ _083_/Z _085_/A2 _158_/D VPWR VPWR VGND VGND gf180mcu_fd_sc_mcu7t5v0__nor2_1
XFILLER_61_542 VPWR VPWR VGND VGND gf180mcu_fd_sc_mcu7t5v0__fillcap_32
XFILLER_80_317 VPWR VPWR VGND VGND gf180mcu_fd_sc_mcu7t5v0__fillcap_16
XFILLER_43_542 VPWR VPWR VGND VGND gf180mcu_fd_sc_mcu7t5v0__fillcap_32
X_137_ _149_/Q _148_/Q _138_/A2 VPWR VPWR VGND VGND gf180mcu_fd_sc_mcu7t5v0__xnor2_1
XFILLER_11_472 VPWR VPWR VGND VGND gf180mcu_fd_sc_mcu7t5v0__fillcap_64
X_068_ _152_/D _068_/A2 _163_/D VPWR VPWR VGND VGND gf180mcu_fd_sc_mcu7t5v0__and2_1
XFILLER_66_601 VPWR VPWR VGND VGND gf180mcu_fd_sc_mcu7t5v0__fillcap_4
Xu_ihsan_sa_pll.u_clk_fb_obuf u_ihsan_sa_pll.u_clk_fb_obuf/I _197_/I VPWR VPWR VGND
+ VGND gf180mcu_fd_sc_mcu7t5v0__clkbuf_8
XFILLER_40_501 VPWR VPWR VGND VGND gf180mcu_fd_sc_mcu7t5v0__fillcap_4
XFILLER_25_542 VPWR VPWR VGND VGND gf180mcu_fd_sc_mcu7t5v0__fillcap_32
XFILLER_71_136 VPWR VPWR VGND VGND gf180mcu_fd_sc_mcu7t5v0__fillcap_4
Xclkbuf_0_u_ihsan_sa_pll.clk_pre _172_/Q clkbuf_0_u_ihsan_sa_pll.clk_pre/Z VPWR VPWR
+ VGND VGND gf180mcu_fd_sc_mcu7t5v0__clkbuf_8
XFILLER_48_601 VPWR VPWR VGND VGND gf180mcu_fd_sc_mcu7t5v0__fillcap_4
Xclkbuf_1_0__f_u_ihsan_sa_pll.clk_pre_regs clkbuf_0_u_ihsan_sa_pll.clk_pre_regs/Z
+ _170_/CLK VPWR VPWR VGND VGND gf180mcu_fd_sc_mcu7t5v0__clkbuf_8
XFILLER_53_136 VPWR VPWR VGND VGND gf180mcu_fd_sc_mcu7t5v0__fillcap_4
XFILLER_22_501 VPWR VPWR VGND VGND gf180mcu_fd_sc_mcu7t5v0__fillcap_4
XFILLER_30_37 VPWR VPWR VGND VGND gf180mcu_fd_sc_mcu7t5v0__fillcap_64
XFILLER_1_416 VPWR VPWR VGND VGND gf180mcu_fd_sc_mcu7t5v0__fillcap_4
XFILLER_76_206 VPWR VPWR VGND VGND gf180mcu_fd_sc_mcu7t5v0__fillcap_32
XFILLER_71_66 VPWR VPWR VGND VGND gf180mcu_fd_sc_mcu7t5v0__fillcap_4
XFILLER_35_136 VPWR VPWR VGND VGND gf180mcu_fd_sc_mcu7t5v0__fillcap_4
XFILLER_50_139 VPWR VPWR VGND VGND gf180mcu_fd_sc_mcu7t5v0__fillcap_4
XFILLER_77_2 VPWR VPWR VGND VGND gf180mcu_fd_sc_mcu7t5v0__fillcap_64
XFILLER_8_593 VPWR VPWR VGND VGND gf180mcu_fd_sc_mcu7t5v0__fillcap_8
XFILLER_8_571 VPWR VPWR VGND VGND gf180mcu_fd_sc_mcu7t5v0__fillcap_4
XFILLER_17_136 VPWR VPWR VGND VGND gf180mcu_fd_sc_mcu7t5v0__fillcap_4
XFILLER_60_437 VPWR VPWR VGND VGND gf180mcu_fd_sc_mcu7t5v0__fillcap_16
XFILLER_32_139 VPWR VPWR VGND VGND gf180mcu_fd_sc_mcu7t5v0__fillcap_4
Xtt_um_ihsan_sa_pll_23 uio_oe[1] VPWR VPWR VGND VGND gf180mcu_fd_sc_mcu7t5v0__tiel
Xtt_um_ihsan_sa_pll_34 uio_out[4] VPWR VPWR VGND VGND gf180mcu_fd_sc_mcu7t5v0__tiel
XFILLER_5_574 VPWR VPWR VGND VGND gf180mcu_fd_sc_mcu7t5v0__fillcap_16
X_170_ _170_/D wire16/Z _170_/CLK _170_/Q VPWR VPWR VGND VGND gf180mcu_fd_sc_mcu7t5v0__dffrnq_1
XFILLER_42_437 VPWR VPWR VGND VGND gf180mcu_fd_sc_mcu7t5v0__fillcap_64
XFILLER_14_139 VPWR VPWR VGND VGND gf180mcu_fd_sc_mcu7t5v0__fillcap_4
XFILLER_7_2 VPWR VPWR VGND VGND gf180mcu_fd_sc_mcu7t5v0__fillcap_64
XFILLER_56_507 VPWR VPWR VGND VGND gf180mcu_fd_sc_mcu7t5v0__fillcap_64
XFILLER_24_437 VPWR VPWR VGND VGND gf180mcu_fd_sc_mcu7t5v0__fillcap_64
X_153_ _153_/D _169_/RN _156_/CLK _153_/Q VPWR VPWR VGND VGND gf180mcu_fd_sc_mcu7t5v0__dffrnq_1
X_084_ _158_/Q _081_/Z _109_/B _085_/A2 VPWR VPWR VGND VGND gf180mcu_fd_sc_mcu7t5v0__oai21_1
XFILLER_38_507 VPWR VPWR VGND VGND gf180mcu_fd_sc_mcu7t5v0__fillcap_64
XFILLER_77_142 VPWR VPWR VGND VGND gf180mcu_fd_sc_mcu7t5v0__fillcap_64
XFILLER_61_598 VPWR VPWR VGND VGND gf180mcu_fd_sc_mcu7t5v0__fillcap_4
XFILLER_79_407 VPWR VPWR VGND VGND gf180mcu_fd_sc_mcu7t5v0__fillcap_8
XFILLER_74_101 VPWR VPWR VGND VGND gf180mcu_fd_sc_mcu7t5v0__fillcap_4
XFILLER_43_598 VPWR VPWR VGND VGND gf180mcu_fd_sc_mcu7t5v0__fillcap_4
X_136_ _147_/Q _148_/Q _136_/A3 _148_/D VPWR VPWR VGND VGND gf180mcu_fd_sc_mcu7t5v0__nor3_1
XFILLER_7_466 VPWR VPWR VGND VGND gf180mcu_fd_sc_mcu7t5v0__fillcap_4
XFILLER_2_171 VPWR VPWR VGND VGND gf180mcu_fd_sc_mcu7t5v0__fillcap_4
X_067_ _149_/D _150_/D _151_/D _068_/A2 VPWR VPWR VGND VGND gf180mcu_fd_sc_mcu7t5v0__nor3_1
XFILLER_80_148 VPWR VPWR VGND VGND gf180mcu_fd_sc_mcu7t5v0__fillcap_8
XFILLER_9_72 VPWR VPWR VGND VGND gf180mcu_fd_sc_mcu7t5v0__fillcap_64
XFILLER_28_37 VPWR VPWR VGND VGND gf180mcu_fd_sc_mcu7t5v0__fillcap_64
XFILLER_56_101 VPWR VPWR VGND VGND gf180mcu_fd_sc_mcu7t5v0__fillcap_4
XFILLER_25_598 VPWR VPWR VGND VGND gf180mcu_fd_sc_mcu7t5v0__fillcap_4
Xu_ihsan_sa_pll.u_pre.u_pre_ff0 u_ihsan_sa_pll.u_pre.u_pre_ff0/D _113_/I u_analog/vco_out
+ u_ihsan_sa_pll.u_pre.u_pre_ff0/Q VPWR VPWR VGND VGND gf180mcu_fd_sc_mcu7t5v0__dffrnq_2
XFILLER_69_66 VPWR VPWR VGND VGND gf180mcu_fd_sc_mcu7t5v0__fillcap_4
X_119_ _170_/Q _170_/D VPWR VPWR VGND VGND gf180mcu_fd_sc_mcu7t5v0__clkinv_1
XFILLER_22_2 VPWR VPWR VGND VGND gf180mcu_fd_sc_mcu7t5v0__fillcap_32
XFILLER_38_101 VPWR VPWR VGND VGND gf180mcu_fd_sc_mcu7t5v0__fillcap_4
XFILLER_21_590 VPWR VPWR VGND VGND gf180mcu_fd_sc_mcu7t5v0__fillcap_8
XFILLER_50_107 VPWR VPWR VGND VGND gf180mcu_fd_sc_mcu7t5v0__fillcap_32
XFILLER_54_402 VPWR VPWR VGND VGND gf180mcu_fd_sc_mcu7t5v0__fillcap_32
XFILLER_32_107 VPWR VPWR VGND VGND gf180mcu_fd_sc_mcu7t5v0__fillcap_32
XFILLER_45_402 VPWR VPWR VGND VGND gf180mcu_fd_sc_mcu7t5v0__fillcap_64
Xtt_um_ihsan_sa_pll_24 uio_oe[2] VPWR VPWR VGND VGND gf180mcu_fd_sc_mcu7t5v0__tiel
Xtt_um_ihsan_sa_pll_35 uio_out[5] VPWR VPWR VGND VGND gf180mcu_fd_sc_mcu7t5v0__tiel
XFILLER_5_542 VPWR VPWR VGND VGND gf180mcu_fd_sc_mcu7t5v0__fillcap_32
XFILLER_36_402 VPWR VPWR VGND VGND gf180mcu_fd_sc_mcu7t5v0__fillcap_32
XFILLER_36_37 VPWR VPWR VGND VGND gf180mcu_fd_sc_mcu7t5v0__fillcap_64
XFILLER_14_107 VPWR VPWR VGND VGND gf180mcu_fd_sc_mcu7t5v0__fillcap_32
XFILLER_27_402 VPWR VPWR VGND VGND gf180mcu_fd_sc_mcu7t5v0__fillcap_64
XFILLER_58_571 VPWR VPWR VGND VGND gf180mcu_fd_sc_mcu7t5v0__fillcap_4
XFILLER_58_593 VPWR VPWR VGND VGND gf180mcu_fd_sc_mcu7t5v0__fillcap_8
XFILLER_77_66 VPWR VPWR VGND VGND gf180mcu_fd_sc_mcu7t5v0__fillcap_4
XFILLER_18_402 VPWR VPWR VGND VGND gf180mcu_fd_sc_mcu7t5v0__fillcap_32
XFILLER_77_346 VPWR VPWR VGND VGND gf180mcu_fd_sc_mcu7t5v0__fillcap_4
XFILLER_73_574 VPWR VPWR VGND VGND gf180mcu_fd_sc_mcu7t5v0__fillcap_16
XFILLER_70_577 VPWR VPWR VGND VGND gf180mcu_fd_sc_mcu7t5v0__fillcap_16
XFILLER_55_574 VPWR VPWR VGND VGND gf180mcu_fd_sc_mcu7t5v0__fillcap_16
X_083_ _157_/Q _158_/Q _078_/Z _083_/Z VPWR VPWR VGND VGND gf180mcu_fd_sc_mcu7t5v0__and3_1
X_152_ _152_/D wire15/Z _163_/CLK _152_/Q VPWR VPWR VGND VGND gf180mcu_fd_sc_mcu7t5v0__dffrnq_1
XFILLER_80_308 VPWR VPWR VGND VGND gf180mcu_fd_sc_mcu7t5v0__fillcap_4
XFILLER_52_2 VPWR VPWR VGND VGND gf180mcu_fd_sc_mcu7t5v0__fillcap_32
Xclkbuf_1_1__f_u_ihsan_sa_pll.clk_pre_regs clkbuf_0_u_ihsan_sa_pll.clk_pre_regs/Z
+ _168_/CLK VPWR VPWR VGND VGND gf180mcu_fd_sc_mcu7t5v0__clkbuf_8
XFILLER_52_577 VPWR VPWR VGND VGND gf180mcu_fd_sc_mcu7t5v0__fillcap_16
XFILLER_37_574 VPWR VPWR VGND VGND gf180mcu_fd_sc_mcu7t5v0__fillcap_16
X_135_ _135_/A1 _149_/Q _150_/Q _151_/Q _136_/A3 VPWR VPWR VGND VGND gf180mcu_fd_sc_mcu7t5v0__nor4_1
XFILLER_34_577 VPWR VPWR VGND VGND gf180mcu_fd_sc_mcu7t5v0__fillcap_16
XFILLER_80_138 VPWR VPWR VGND VGND gf180mcu_fd_sc_mcu7t5v0__fillcap_4
XFILLER_19_574 VPWR VPWR VGND VGND gf180mcu_fd_sc_mcu7t5v0__fillcap_16
XFILLER_44_37 VPWR VPWR VGND VGND gf180mcu_fd_sc_mcu7t5v0__fillcap_64
Xclkbuf_1_0__f_u_ihsan_sa_pll.clk_fb_int clkbuf_0_u_ihsan_sa_pll.clk_fb_int/Z u_ihsan_sa_pll.u_clk_fb_obuf/I
+ VPWR VPWR VGND VGND gf180mcu_fd_sc_mcu7t5v0__clkbuf_8
XFILLER_31_536 VPWR VPWR VGND VGND gf180mcu_fd_sc_mcu7t5v0__fillcap_4
XFILLER_16_577 VPWR VPWR VGND VGND gf180mcu_fd_sc_mcu7t5v0__fillcap_16
X_118_ _152_/Q _135_/A1 VPWR VPWR VGND VGND gf180mcu_fd_sc_mcu7t5v0__clkinv_1
XFILLER_15_2 VPWR VPWR VGND VGND gf180mcu_fd_sc_mcu7t5v0__fillcap_64
XFILLER_3_492 VPWR VPWR VGND VGND gf180mcu_fd_sc_mcu7t5v0__fillcap_64
XFILLER_57_466 VPWR VPWR VGND VGND gf180mcu_fd_sc_mcu7t5v0__fillcap_4
XFILLER_13_536 VPWR VPWR VGND VGND gf180mcu_fd_sc_mcu7t5v0__fillcap_4
XFILLER_71_480 VPWR VPWR VGND VGND gf180mcu_fd_sc_mcu7t5v0__fillcap_4
XANTENNA_1 _145_/Q VPWR VPWR VGND VGND gf180mcu_fd_sc_mcu7t5v0__antenna
XFILLER_39_466 VPWR VPWR VGND VGND gf180mcu_fd_sc_mcu7t5v0__fillcap_4
XFILLER_60_417 VPWR VPWR VGND VGND gf180mcu_fd_sc_mcu7t5v0__fillcap_4
XFILLER_15_72 VPWR VPWR VGND VGND gf180mcu_fd_sc_mcu7t5v0__fillcap_64
Xtt_um_ihsan_sa_pll_25 uio_oe[3] VPWR VPWR VGND VGND gf180mcu_fd_sc_mcu7t5v0__tiel
Xtt_um_ihsan_sa_pll_36 uio_out[6] VPWR VPWR VGND VGND gf180mcu_fd_sc_mcu7t5v0__tiel
XFILLER_5_598 VPWR VPWR VGND VGND gf180mcu_fd_sc_mcu7t5v0__fillcap_4
XFILLER_52_37 VPWR VPWR VGND VGND gf180mcu_fd_sc_mcu7t5v0__fillcap_64
XFILLER_73_542 VPWR VPWR VGND VGND gf180mcu_fd_sc_mcu7t5v0__fillcap_32
XFILLER_41_472 VPWR VPWR VGND VGND gf180mcu_fd_sc_mcu7t5v0__fillcap_64
Xwire15 wire16/Z wire15/Z VPWR VPWR VGND VGND gf180mcu_fd_sc_mcu7t5v0__buf_1
XFILLER_20_601 VPWR VPWR VGND VGND gf180mcu_fd_sc_mcu7t5v0__fillcap_4
XFILLER_55_542 VPWR VPWR VGND VGND gf180mcu_fd_sc_mcu7t5v0__fillcap_32
XFILLER_70_523 VPWR VPWR VGND VGND gf180mcu_fd_sc_mcu7t5v0__fillcap_4
XFILLER_23_472 VPWR VPWR VGND VGND gf180mcu_fd_sc_mcu7t5v0__fillcap_64
X_082_ _099_/A1 _082_/A2 _081_/Z _157_/D VPWR VPWR VGND VGND gf180mcu_fd_sc_mcu7t5v0__nor3_1
X_151_ _151_/D _151_/RN _163_/CLK _151_/Q VPWR VPWR VGND VGND gf180mcu_fd_sc_mcu7t5v0__dffrnq_1
XFILLER_2_387 VPWR VPWR VGND VGND gf180mcu_fd_sc_mcu7t5v0__fillcap_64
XFILLER_61_534 VPWR VPWR VGND VGND gf180mcu_fd_sc_mcu7t5v0__fillcap_4
XFILLER_45_2 VPWR VPWR VGND VGND gf180mcu_fd_sc_mcu7t5v0__fillcap_64
XFILLER_37_542 VPWR VPWR VGND VGND gf180mcu_fd_sc_mcu7t5v0__fillcap_32
XFILLER_52_501 VPWR VPWR VGND VGND gf180mcu_fd_sc_mcu7t5v0__fillcap_4
XFILLER_23_72 VPWR VPWR VGND VGND gf180mcu_fd_sc_mcu7t5v0__fillcap_64
XFILLER_7_402 VPWR VPWR VGND VGND gf180mcu_fd_sc_mcu7t5v0__fillcap_64
X_134_ _134_/A1 _134_/A2 _169_/D VPWR VPWR VGND VGND gf180mcu_fd_sc_mcu7t5v0__nand2_1
XFILLER_65_136 VPWR VPWR VGND VGND gf180mcu_fd_sc_mcu7t5v0__fillcap_4
XFILLER_19_542 VPWR VPWR VGND VGND gf180mcu_fd_sc_mcu7t5v0__fillcap_32
XFILLER_34_501 VPWR VPWR VGND VGND gf180mcu_fd_sc_mcu7t5v0__fillcap_4
XFILLER_60_37 VPWR VPWR VGND VGND gf180mcu_fd_sc_mcu7t5v0__fillcap_64
XFILLER_79_206 VPWR VPWR VGND VGND gf180mcu_fd_sc_mcu7t5v0__fillcap_4
XFILLER_47_136 VPWR VPWR VGND VGND gf180mcu_fd_sc_mcu7t5v0__fillcap_4
XFILLER_62_139 VPWR VPWR VGND VGND gf180mcu_fd_sc_mcu7t5v0__fillcap_4
XFILLER_16_501 VPWR VPWR VGND VGND gf180mcu_fd_sc_mcu7t5v0__fillcap_4
X_117_ _160_/Q _117_/ZN VPWR VPWR VGND VGND gf180mcu_fd_sc_mcu7t5v0__clkinv_1
XFILLER_29_136 VPWR VPWR VGND VGND gf180mcu_fd_sc_mcu7t5v0__fillcap_4
XFILLER_44_139 VPWR VPWR VGND VGND gf180mcu_fd_sc_mcu7t5v0__fillcap_4
XFILLER_54_437 VPWR VPWR VGND VGND gf180mcu_fd_sc_mcu7t5v0__fillcap_64
XFILLER_26_139 VPWR VPWR VGND VGND gf180mcu_fd_sc_mcu7t5v0__fillcap_4
XFILLER_10_507 VPWR VPWR VGND VGND gf180mcu_fd_sc_mcu7t5v0__fillcap_64
XFILLER_31_72 VPWR VPWR VGND VGND gf180mcu_fd_sc_mcu7t5v0__fillcap_64
Xtt_um_ihsan_sa_pll_26 uio_oe[4] VPWR VPWR VGND VGND gf180mcu_fd_sc_mcu7t5v0__tiel
Xtt_um_ihsan_sa_pll_37 uio_out[7] VPWR VPWR VGND VGND gf180mcu_fd_sc_mcu7t5v0__tiel
XFILLER_68_507 VPWR VPWR VGND VGND gf180mcu_fd_sc_mcu7t5v0__fillcap_16
XFILLER_36_437 VPWR VPWR VGND VGND gf180mcu_fd_sc_mcu7t5v0__fillcap_64
XFILLER_75_2 VPWR VPWR VGND VGND gf180mcu_fd_sc_mcu7t5v0__fillcap_64
XFILLER_18_437 VPWR VPWR VGND VGND gf180mcu_fd_sc_mcu7t5v0__fillcap_64
XFILLER_73_598 VPWR VPWR VGND VGND gf180mcu_fd_sc_mcu7t5v0__fillcap_4
Xwire16 wire16/I wire16/Z VPWR VPWR VGND VGND gf180mcu_fd_sc_mcu7t5v0__buf_1
XFILLER_55_598 VPWR VPWR VGND VGND gf180mcu_fd_sc_mcu7t5v0__fillcap_4
XFILLER_10_101 VPWR VPWR VGND VGND gf180mcu_fd_sc_mcu7t5v0__fillcap_4
X_150_ _150_/D _151_/RN _163_/CLK _150_/Q VPWR VPWR VGND VGND gf180mcu_fd_sc_mcu7t5v0__dffrnq_1
X_081_ _157_/Q _078_/Z _081_/Z VPWR VPWR VGND VGND gf180mcu_fd_sc_mcu7t5v0__and2_1
XFILLER_2_311 VPWR VPWR VGND VGND gf180mcu_fd_sc_mcu7t5v0__fillcap_4
XFILLER_5_2 VPWR VPWR VGND VGND gf180mcu_fd_sc_mcu7t5v0__fillcap_64
XFILLER_38_2 VPWR VPWR VGND VGND gf180mcu_fd_sc_mcu7t5v0__fillcap_32
XFILLER_68_101 VPWR VPWR VGND VGND gf180mcu_fd_sc_mcu7t5v0__fillcap_4
XFILLER_37_598 VPWR VPWR VGND VGND gf180mcu_fd_sc_mcu7t5v0__fillcap_4
XFILLER_58_37 VPWR VPWR VGND VGND gf180mcu_fd_sc_mcu7t5v0__fillcap_64
X_133_ _166_/Q _133_/A2 _133_/B _168_/Q _134_/A2 VPWR VPWR VGND VGND gf180mcu_fd_sc_mcu7t5v0__aoi211_2
XFILLER_51_590 VPWR VPWR VGND VGND gf180mcu_fd_sc_mcu7t5v0__fillcap_8
Xclkbuf_regs_0_clk_pre delaybuf_0_clk_pre/Z clkbuf_regs_0_clk_pre/Z VPWR VPWR VGND
+ VGND gf180mcu_fd_sc_mcu7t5v0__clkbuf_8
XFILLER_19_598 VPWR VPWR VGND VGND gf180mcu_fd_sc_mcu7t5v0__fillcap_4
XFILLER_69_443 VPWR VPWR VGND VGND gf180mcu_fd_sc_mcu7t5v0__fillcap_16
XFILLER_33_590 VPWR VPWR VGND VGND gf180mcu_fd_sc_mcu7t5v0__fillcap_8
XFILLER_62_107 VPWR VPWR VGND VGND gf180mcu_fd_sc_mcu7t5v0__fillcap_32
X_116_ _198_/I _116_/ZN VPWR VPWR VGND VGND gf180mcu_fd_sc_mcu7t5v0__clkinv_1
XFILLER_30_571 VPWR VPWR VGND VGND gf180mcu_fd_sc_mcu7t5v0__fillcap_4
XFILLER_15_590 VPWR VPWR VGND VGND gf180mcu_fd_sc_mcu7t5v0__fillcap_8
XFILLER_30_593 VPWR VPWR VGND VGND gf180mcu_fd_sc_mcu7t5v0__fillcap_8
XFILLER_57_402 VPWR VPWR VGND VGND gf180mcu_fd_sc_mcu7t5v0__fillcap_64
XFILLER_44_107 VPWR VPWR VGND VGND gf180mcu_fd_sc_mcu7t5v0__fillcap_32
XFILLER_48_402 VPWR VPWR VGND VGND gf180mcu_fd_sc_mcu7t5v0__fillcap_32
XFILLER_29_72 VPWR VPWR VGND VGND gf180mcu_fd_sc_mcu7t5v0__fillcap_64
XFILLER_12_571 VPWR VPWR VGND VGND gf180mcu_fd_sc_mcu7t5v0__fillcap_4
XFILLER_12_593 VPWR VPWR VGND VGND gf180mcu_fd_sc_mcu7t5v0__fillcap_8
XFILLER_20_2 VPWR VPWR VGND VGND gf180mcu_fd_sc_mcu7t5v0__fillcap_32
XFILLER_39_402 VPWR VPWR VGND VGND gf180mcu_fd_sc_mcu7t5v0__fillcap_64
XFILLER_62_460 VPWR VPWR VGND VGND gf180mcu_fd_sc_mcu7t5v0__fillcap_4
XFILLER_26_107 VPWR VPWR VGND VGND gf180mcu_fd_sc_mcu7t5v0__fillcap_32
XFILLER_1_206 VPWR VPWR VGND VGND gf180mcu_fd_sc_mcu7t5v0__fillcap_4
XFILLER_66_37 VPWR VPWR VGND VGND gf180mcu_fd_sc_mcu7t5v0__fillcap_64
Xtt_um_ihsan_sa_pll_27 uio_oe[5] VPWR VPWR VGND VGND gf180mcu_fd_sc_mcu7t5v0__tiel
Xtt_um_ihsan_sa_pll_38 uo_out[3] VPWR VPWR VGND VGND gf180mcu_fd_sc_mcu7t5v0__tiel
XFILLER_76_574 VPWR VPWR VGND VGND gf180mcu_fd_sc_mcu7t5v0__fillcap_4
XFILLER_76_596 VPWR VPWR VGND VGND gf180mcu_fd_sc_mcu7t5v0__fillcap_8
XFILLER_68_2 VPWR VPWR VGND VGND gf180mcu_fd_sc_mcu7t5v0__fillcap_32
XFILLER_67_574 VPWR VPWR VGND VGND gf180mcu_fd_sc_mcu7t5v0__fillcap_16
XFILLER_9_136 VPWR VPWR VGND VGND gf180mcu_fd_sc_mcu7t5v0__fillcap_4
XFILLER_49_574 VPWR VPWR VGND VGND gf180mcu_fd_sc_mcu7t5v0__fillcap_16
XFILLER_3_66 VPWR VPWR VGND VGND gf180mcu_fd_sc_mcu7t5v0__fillcap_4
XFILLER_64_577 VPWR VPWR VGND VGND gf180mcu_fd_sc_mcu7t5v0__fillcap_16
X_080_ _157_/Q _078_/Z _082_/A2 VPWR VPWR VGND VGND gf180mcu_fd_sc_mcu7t5v0__nor2_1
XFILLER_6_139 VPWR VPWR VGND VGND gf180mcu_fd_sc_mcu7t5v0__fillcap_4
XFILLER_46_577 VPWR VPWR VGND VGND gf180mcu_fd_sc_mcu7t5v0__fillcap_16
XFILLER_37_72 VPWR VPWR VGND VGND gf180mcu_fd_sc_mcu7t5v0__fillcap_64
XFILLER_43_536 VPWR VPWR VGND VGND gf180mcu_fd_sc_mcu7t5v0__fillcap_4
XFILLER_28_577 VPWR VPWR VGND VGND gf180mcu_fd_sc_mcu7t5v0__fillcap_16
XFILLER_74_37 VPWR VPWR VGND VGND gf180mcu_fd_sc_mcu7t5v0__fillcap_64
X_132_ _130_/B input4/Z _133_/B VPWR VPWR VGND VGND gf180mcu_fd_sc_mcu7t5v0__nor2_1
XFILLER_11_466 VPWR VPWR VGND VGND gf180mcu_fd_sc_mcu7t5v0__fillcap_4
XFILLER_50_2 VPWR VPWR VGND VGND gf180mcu_fd_sc_mcu7t5v0__fillcap_32
XFILLER_25_536 VPWR VPWR VGND VGND gf180mcu_fd_sc_mcu7t5v0__fillcap_4
X_115_ _167_/Q _131_/A1 VPWR VPWR VGND VGND gf180mcu_fd_sc_mcu7t5v0__clkinv_1
XFILLER_78_241 VPWR VPWR VGND VGND gf180mcu_fd_sc_mcu7t5v0__fillcap_4
Xclkbuf_1_0__f_u_ihsan_sa_pll.u_pre.pre_q1 _171_/Q _120__45/I VPWR VPWR VGND VGND
+ gf180mcu_fd_sc_mcu7t5v0__clkbuf_8
XFILLER_0_410 VPWR VPWR VGND VGND gf180mcu_fd_sc_mcu7t5v0__fillcap_32
XFILLER_71_461 VPWR VPWR VGND VGND gf180mcu_fd_sc_mcu7t5v0__fillcap_8
XFILLER_45_72 VPWR VPWR VGND VGND gf180mcu_fd_sc_mcu7t5v0__fillcap_64
XFILLER_79_594 VPWR VPWR VGND VGND gf180mcu_fd_sc_mcu7t5v0__fillcap_8
XFILLER_13_2 VPWR VPWR VGND VGND gf180mcu_fd_sc_mcu7t5v0__fillcap_64
XFILLER_62_472 VPWR VPWR VGND VGND gf180mcu_fd_sc_mcu7t5v0__fillcap_8
XFILLER_50_601 VPWR VPWR VGND VGND gf180mcu_fd_sc_mcu7t5v0__fillcap_4
XFILLER_53_472 VPWR VPWR VGND VGND gf180mcu_fd_sc_mcu7t5v0__fillcap_64
Xtt_um_ihsan_sa_pll_28 uio_oe[6] VPWR VPWR VGND VGND gf180mcu_fd_sc_mcu7t5v0__tiel
XFILLER_80_291 VPWR VPWR VGND VGND gf180mcu_fd_sc_mcu7t5v0__fillcap_8
Xtt_um_ihsan_sa_pll_39 uo_out[4] VPWR VPWR VGND VGND gf180mcu_fd_sc_mcu7t5v0__tiel
XFILLER_0_240 VPWR VPWR VGND VGND gf180mcu_fd_sc_mcu7t5v0__fillcap_32
XFILLER_32_601 VPWR VPWR VGND VGND gf180mcu_fd_sc_mcu7t5v0__fillcap_4
.ends
